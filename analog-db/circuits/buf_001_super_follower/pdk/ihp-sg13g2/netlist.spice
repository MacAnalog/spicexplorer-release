** GENERATED by `analog-db generate` — DO NOT EDIT. Source: abstract/netlist.spice → ihp-sg13g2
* buf_001_super_follower (emitted by spicexplorer-circuitgraph)
CC na vss x_cc
XM1 na vin vout vss sg13_lv_nmos l=x_dut_xm1_l m=x_dut_xm1_m w=x_dut_xm1_w
XM2 vout na vss vss sg13_lv_nmos l=x_dut_xm2_l m=x_dut_xm2_m w=x_dut_xm2_w
XMNS pd ibias vss vss sg13_lv_nmos l=x_dut_xmns_l m=x_dut_xmns_m w=x_dut_xmns_w
XMPB na pd vdd vdd sg13_lv_pmos l=x_dut_xmpb_l m=x_dut_xmpb_m w=x_dut_xmpb_w
XMPD pd pd vdd vdd sg13_lv_pmos l=x_dut_xmpd_l m=x_dut_xmpd_m w=x_dut_xmpd_w
XMRN ibias ibias vss vss sg13_lv_nmos l=x_dut_xmrn_l m=x_dut_xmrn_m w=x_dut_xmrn_w
.end
