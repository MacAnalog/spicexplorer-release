** GENERATED by `analog-db export-raw` — DO NOT EDIT.
** circuit=amp_030_miller_cmfb_composite  class=amplifier  pdk=tsmc-n65  testbench=cmrr_vcm  corner=tt
** Self-contained deck: testbench + bound params + lowered DUT (.subckt amp_030_miller_cmfb_composite).
** PDK corner libs resolve by BARE NAME on the image's ngspice sourcepath — run in a
** PDK-enabled env (the base image / api container), NOT a bare host:
**   docker run --rm -i spicexplorer-spice-base:local \
**     bash -lc 'd=$(mktemp -d) && cat > $d/c.spice && cd $d && ngspice -b c.spice' < raw/amp_030_miller_cmfb_composite/tsmc-n65/cmrr_vcm.spice
*----------------------------------------------------------*
** params: 21 free + 6 frozen knobs (sizing.yaml) · 17 tied · 0 ratio-derived (abstract/params.yaml) · 3 testbench params
** AUTHORED TEMPLATE — amplifier/cmrr_vcm_diff: common-mode rejection of a fully-differential
** (self-biased, voutp/voutn) DUT, in the same CM-pinned differential unity-feedback network
** stb_diff uses.
**
** CONFIGURATION (see stb_diff.spice for the full why). The differential loop is closed by two
** ideal VCVSs, fbn/fbp = VCM +/- (voutp-voutn)/2, feeding the inputs through 0 V sources; the
** feedback carries the differential output ONLY, so the input CM is pinned at VCM and the DC
** operating point is the matched-inputs-at-VCM point of dc_op_diff/ac_open_loop_diff. No CM
** loop is closed by the bench — the output CM is left to the DUT's own CMFB, and being a
** small-signal bench this works on every FD cell that has a DC OP, regardless of CMFB quality.
**
** STIMULUS + MATH (the exact FD analog of cmrr_vcm.spice). BOTH feedback sources carry the
** SAME +1 V AC, so both inputs ride up together:
**     vinn = fbn + vac,  vinp = fbp + vac
**  => vin_d = vinp - vinn = -(voutp-voutn)   (the unity differential feedback, unchanged)
**     vin_c = VCM + vac                       (the common mode moves by a full volt)
** With vout_d = Add*vin_d + Adc*vin_c (Adc = the cell's CM->differential conversion gain, the
** thing mismatch creates and CMRR measures):
**     vout_d = -Add*vout_d + Adc*vac  =>  vout_d = Adc/(1+Add) * vac ~= vac/CMRR,
** where CMRR = Add/Adc — so cmrr_db = -20*log10|vout_d| (vac = 1), read at FSTART (the DC-band
** floor), exactly mirroring the SE bench's vout ~= vac/CMRR derivation.
**
** SOLVER-RESOLUTION CEILING (why the 1e-15 floor exists). The corpus netlists are written
** perfectly symmetric (matched W/L, no mismatch corners in the tt deck), so the TRUE
** small-signal Adc of the deck is zero and the AC solve's vout_d response to a pure CM
** stimulus cancels to matrix round-off — ~1e-16 relative to the ~1 V node signals in a double-
** precision LU solve. Any |vout_d| below ~1e-13 is solver noise, not physics, and -db() of it
** would report a plausible-looking 260..320 dB "CMRR" (or -db(0) = Inf, which the runner
** cannot parse). The `+ 1e-15` magnitude floor therefore CAPS the reportable figure at 300 dB:
** a cmrr_db at or near 300 means "beyond what the matrix solver can resolve on a symmetric
** netlist" — a statement about the deck, NOT a physical rejection. Consumers should treat
** anything above ~200 dB as unresolved-by-construction; the measured CMRR of real silicon is
** set by mismatch, which this nominal deck does not model.
**
** cmrr_cm_db — the SECONDARY, always-physical figure. Because the differential response of a
** symmetric cell saturates the solver, the bench also reports the OUTPUT-CM response to the
** same 1 V input-CM ride: vocm = (voutp+voutn)/2, cmrr_cm_db = -db|vocm|. That is the closed
** CM-loop's rejection of an input-CM disturbance — finite, CMFB-quality-dependent, and
** therefore the discriminating number between FD cells whose cmrr_db all read "perfect".
** (Naming: the cm figure is NOT a canonical datasheet metric; it rides the scoreboard entry's
** analyses block like stb's loop measures do.)
**
** DIFFERENTIAL-GAIN CORRECTION (downstream, scoreboard.record). cmrr_cm_db here is the RAW CM
** residual -db|vocm| — a CM-to-CM ratio, NOT yet a rejection FIGURE. A CMRR is (differential
** gain)/(CM disturbance gain), so the physical FD CMRR adds the differential open-loop gain
** back: cmrr_cm_corr_db = dc_gain_db + cmrr_cm_db (the SE unity-buffer cmrr_db folds this in via
** its closed loop; the FD CM path does not close a CM loop, so the deck cannot, and the term is
** added when the scoreboard entry is assembled). cmrr_cm_corr_db is the figure the paper prints.
**
** Bindings: DUT PORT_LINE VDD VCM CL FSTART FSTOP PPD PDK_INCLUDE.
.lib tsmc_n65_models.scs tt
.temp 27

.param VDD=1.2
.param VCM=0.6
.param CL=10p

Vdd  vdd 0 dc {VDD}          ; supply quiet — isolate the common-mode path
Vss  vss 0 dc 0
CLoadp voutp 0 {CL}
CLoadn voutn 0 {CL}

* differential unity feedback, CM pinned at VCM (see stb_diff.spice)
Vcm  vcm 0 dc {VCM}
Efbn fbn vcm voutp voutn 0.5
Efbp fbp vcm voutp voutn -0.5

* ... and the SAME +1 V AC lifted onto BOTH inputs: pure common-mode ride, zero differential
Vfbn vinn fbn dc 0 ac 1
Vfbp vinp fbp dc 0 ac 1

XDUT vinp vinn voutp voutn vdd vss amp_030_miller_cmfb_composite

.control
  set filetype=ascii
  ac dec 101 1k 1G
  let vodm = v(voutp) - v(voutn)
  let vocm = (v(voutp) + v(voutn))/2
  * 1e-15 magnitude floor: caps the figure at 300 dB = "beyond solver resolution" (see header);
  * also keeps -db() finite on a bit-symmetric netlist whose true response is exactly 0.
  let cmrr   = -db(mag(vodm) + 1e-15)
  let cmrrcm = -db(mag(vocm) + 1e-15)
  meas ac cmrr_db    FIND cmrr   AT=1k
  meas ac cmrr_cm_db FIND cmrrcm AT=1k
  write
  quit
.endc
.param x_dut_xm1_core_w=5e-06
.param x_dut_xm1_core_l=5e-07
.param x_dut_xm3_core_w=5e-06
.param x_dut_xm3_core_l=2e-06
.param x_dut_xm5_core_w=4e-05
.param x_dut_xm5_core_l=2e-06
.param x_dut_xm6_core_w=3.5e-06
.param x_dut_xm6_core_l=2e-06
.param x_dut_xm7_core_w=1.05e-05
.param x_dut_xm8_core_w=3.5e-06
.param x_dut_r1_core_value=8000.0
.param x_dut_c1_core_value=1p
.param i_bias_core=2e-05
.param x_dut_xm1_core_m=1
.param x_dut_xm3_core_m=1
.param x_dut_xm5_core_m=1
.param x_dut_xm6_core_m=1
.param x_dut_xm7_core_m=1
.param x_dut_xm8_core_m=1
.param gm_val_servo=100u
.param rout_val_servo=10k
.param cout_val_servo=100f
.param rin_val_servo=1e12
.param cin_val_servo=10f
.param x_dut_rmp_servo_value=1Meg
.param vcm_ref=0.6
.param vbl0=0.71
* ---- GENERATED parameter ties (abstract/params.yaml groups/ratios) ----
* Each tied symbol is defined exactly once, by its line below; rewrite that
* .param to untie just that symbol (untying = shadowing, plan D-3).
.param x_dut_xm10_core_l = {x_dut_xm6_core_l}
.param x_dut_xm7_core_l = {x_dut_xm6_core_l}
.param x_dut_xm8_core_l = {x_dut_xm6_core_l}
.param x_dut_xm2_core_w = {x_dut_xm1_core_w}
.param x_dut_xm2_core_l = {x_dut_xm1_core_l}
.param x_dut_xm2_core_m = {x_dut_xm1_core_m}
.param x_dut_xm4_core_w = {x_dut_xm3_core_w}
.param x_dut_xm4_core_l = {x_dut_xm3_core_l}
.param x_dut_xm4_core_m = {x_dut_xm3_core_m}
.param x_dut_xm9_core_w = {x_dut_xm5_core_w}
.param x_dut_xm9_core_l = {x_dut_xm5_core_l}
.param x_dut_xm9_core_m = {x_dut_xm5_core_m}
.param x_dut_xm10_core_w = {x_dut_xm7_core_w}
.param x_dut_xm10_core_m = {x_dut_xm7_core_m}
.param x_dut_r2_core_value = {x_dut_r1_core_value}
.param x_dut_c2_core_value = {x_dut_c1_core_value}
.param x_dut_rmn_servo_value = {x_dut_rmp_servo_value}
.subckt amp_030_miller_cmfb_composite vinp vinn voutp voutn vdd vss
C1_CORE core__mill_p voutp 'x_dut_c1_core_value'
C2_CORE core__mill_n voutn 'x_dut_c2_core_value'
CIN_SERVO_SERVO servo__cm_sense vref_cm 'cin_val_servo'
COUT_SERVO_SERVO vss vcmfb_raw 'cout_val_servo'
GM_SERVO_SERVO vss vcmfb_raw vref_cm servo__cm_sense {gm_val_servo}
IBIAS_CORE vdd core__ref dc {i_bias_core}
R1_CORE core__stg1p core__mill_p 'x_dut_r1_core_value'
R2_CORE core__stg1n core__mill_n 'x_dut_r2_core_value'
RIN_SERVO_SERVO servo__cm_sense vref_cm 'rin_val_servo'
RMN_SERVO voutn servo__cm_sense 'x_dut_rmn_servo_value'
RMP_SERVO servo__cm_sense voutp 'x_dut_rmp_servo_value'
ROUT_SERVO_SERVO vss vcmfb_raw 'rout_val_servo'
VBL0 vbl_ctl vcmfb_raw dc {vbl0}
VREFCM vref_cm vss dc {vcm_ref}
XM10_CORE voutn core__ref vss vss nch_lvt l=x_dut_xm10_core_l m=x_dut_xm10_core_m w=x_dut_xm10_core_w
XM1_CORE core__stg1p vinp core__tail vss nch_lvt l=x_dut_xm1_core_l m=x_dut_xm1_core_m w=x_dut_xm1_core_w
XM2_CORE core__stg1n vinn core__tail vss nch_lvt l=x_dut_xm2_core_l m=x_dut_xm2_core_m w=x_dut_xm2_core_w
XM3_CORE core__stg1p vbl_ctl vdd vdd pch_lvt l=x_dut_xm3_core_l m=x_dut_xm3_core_m w=x_dut_xm3_core_w
XM4_CORE core__stg1n vbl_ctl vdd vdd pch_lvt l=x_dut_xm4_core_l m=x_dut_xm4_core_m w=x_dut_xm4_core_w
XM5_CORE voutp core__stg1p vdd vdd pch_lvt l=x_dut_xm5_core_l m=x_dut_xm5_core_m w=x_dut_xm5_core_w
XM6_CORE core__ref core__ref vss vss nch_lvt l=x_dut_xm6_core_l m=x_dut_xm6_core_m w=x_dut_xm6_core_w
XM7_CORE voutp core__ref vss vss nch_lvt l=x_dut_xm7_core_l m=x_dut_xm7_core_m w=x_dut_xm7_core_w
XM8_CORE core__tail core__ref vss vss nch_lvt l=x_dut_xm8_core_l m=x_dut_xm8_core_m w=x_dut_xm8_core_w
XM9_CORE voutn core__stg1n vdd vdd pch_lvt l=x_dut_xm9_core_l m=x_dut_xm9_core_m w=x_dut_xm9_core_w
.ends
.end
