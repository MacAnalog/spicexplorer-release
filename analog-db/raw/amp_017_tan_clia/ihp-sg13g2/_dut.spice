** GENERATED by `analog-db export-raw` — DO NOT EDIT.
** Standalone lowered DUT subckt for amp_017_tan_clia on ihp-sg13g2 (sizing .param defaults + .subckt).
** Not a runnable deck on its own — include it under your own testbench:
**   .include _dut.spice
**   XDUT vss vdd vinn vinp vout amp_017_tan_clia
** Source: pdk/ihp-sg13g2/netlist.spice (run `analog-db generate` to refresh).
*----------------------------------------------------------*
** params: 28 free + 0 frozen knobs (sizing.yaml) · 36 tied · 15 ratio-derived (abstract/params.yaml)
.param CAPACITOR_0=7.59622027721245e-13
.param CAPACITOR_1=6.7e-12
.param CURRENT_0_BIAS=2.0890206544741707e-06
.param x_dut_xm73_l=1.5254490870560365e-07
.param x_dut_xm73_m=2400
.param x_dut_xm73_w=5.056743856650465e-06
.param x_dut_xm61_l=5.0351585535749765e-06
.param x_dut_xm14_m=1
.param x_dut_xm61_w=9.788613060895045e-06
.param x_dut_xm5_l=6.961344030002521e-07
.param x_dut_xm5_m=117
.param x_dut_xm5_w=4.386594553489162e-06
.param x_dut_xm68_l=4.516238510119449e-06
.param x_dut_xm68_m=6
.param x_dut_xm68_w=8.75252105949699e-06
.param x_dut_xm69_l=7.9722432801625e-06
.param x_dut_xm69_m=3
.param x_dut_xm69_w=9.589343036263532e-07
.param x_dut_xm70_l=9.68649032038032e-06
.param x_dut_xm70_m=2
.param x_dut_xm70_w=9.306375982546267e-06
.param x_dut_xm71_l=4.699337257099538e-07
.param x_dut_xm71_m=1
.param x_dut_xm71_w=5.381959059568765e-06
.param x_dut_xm9_l=9.504924722469453e-07
.param x_dut_xm9_m=100
.param x_dut_xm9_w=6.859827618742331e-06
.param RESISTOR_0=277416.87924876553
* ---- GENERATED parameter ties (abstract/params.yaml groups/ratios) ----
* Each tied symbol is defined exactly once, by its line below; rewrite that
* .param to untie just that symbol (untying = shadowing, plan D-3).
.param x_dut_xm2_w = {x_dut_xm73_w}
.param x_dut_xm4_w = {x_dut_xm73_w}
.param x_dut_xm3_w = {x_dut_xm73_w}
.param x_dut_xm1_w = {x_dut_xm73_w}
.param x_dut_xm0_w = {x_dut_xm73_w}
.param x_dut_xm2_l = {x_dut_xm73_l}
.param x_dut_xm4_l = {x_dut_xm73_l}
.param x_dut_xm3_l = {x_dut_xm73_l}
.param x_dut_xm1_l = {x_dut_xm73_l}
.param x_dut_xm0_l = {x_dut_xm73_l}
.param x_dut_xm6_w = {x_dut_xm5_w}
.param x_dut_xm6_l = {x_dut_xm5_l}
.param x_dut_xm6_m = {x_dut_xm5_m}
.param x_dut_xm8_w = {x_dut_xm9_w}
.param x_dut_xm8_l = {x_dut_xm9_l}
.param x_dut_xm8_m = {x_dut_xm9_m}
.param x_dut_xm72_w = {x_dut_xm71_w}
.param x_dut_xm72_l = {x_dut_xm71_l}
.param x_dut_xm19_w = {x_dut_xm61_w}
.param x_dut_xm15_w = {x_dut_xm61_w}
.param x_dut_xm20_w = {x_dut_xm61_w}
.param x_dut_xm16_w = {x_dut_xm61_w}
.param x_dut_xm18_w = {x_dut_xm61_w}
.param x_dut_xm12_w = {x_dut_xm61_w}
.param x_dut_xm13_w = {x_dut_xm61_w}
.param x_dut_xm17_w = {x_dut_xm61_w}
.param x_dut_xm14_w = {x_dut_xm61_w}
.param x_dut_xm19_l = {x_dut_xm61_l}
.param x_dut_xm15_l = {x_dut_xm61_l}
.param x_dut_xm20_l = {x_dut_xm61_l}
.param x_dut_xm16_l = {x_dut_xm61_l}
.param x_dut_xm18_l = {x_dut_xm61_l}
.param x_dut_xm12_l = {x_dut_xm61_l}
.param x_dut_xm13_l = {x_dut_xm61_l}
.param x_dut_xm17_l = {x_dut_xm61_l}
.param x_dut_xm14_l = {x_dut_xm61_l}
.param x_dut_xm2_m = {x_dut_xm73_m*1/3}
.param x_dut_xm4_m = {x_dut_xm73_m*2/3}
.param x_dut_xm3_m = {x_dut_xm73_m*1/3}
.param x_dut_xm1_m = {x_dut_xm73_m*1/3}
.param x_dut_xm0_m = {x_dut_xm73_m*1/3}
.param x_dut_xm72_m = {x_dut_xm71_m*3}
.param x_dut_xm61_m = {x_dut_xm14_m*6}
.param x_dut_xm19_m = {x_dut_xm14_m*12}
.param x_dut_xm15_m = {x_dut_xm14_m*8}
.param x_dut_xm20_m = {x_dut_xm14_m*12}
.param x_dut_xm16_m = {x_dut_xm14_m*8}
.param x_dut_xm18_m = {x_dut_xm14_m*4}
.param x_dut_xm12_m = {x_dut_xm14_m*4}
.param x_dut_xm13_m = {x_dut_xm14_m*4}
.param x_dut_xm17_m = {x_dut_xm14_m*4}
.subckt amp_017_tan_clia vss vdd vinn vinp vout
C0 net2 vss 'CAPACITOR_0'
C1 net8 VOUT 'CAPACITOR_1'
I0 net1 vss 'CURRENT_0_BIAS'
R0 net5 net2 'RESISTOR_0'
XM0 net1 net1 vdd vdd sg13_lv_pmos l=x_dut_xm0_l m=x_dut_xm0_m w=x_dut_xm0_w
XM1 VB4 net1 vdd vdd sg13_lv_pmos l=x_dut_xm1_l m=x_dut_xm1_m w=x_dut_xm1_w
XM12 VB4 VB3 net6 vss sg13_lv_nmos l=x_dut_xm12_l m=x_dut_xm12_m w=x_dut_xm12_w
XM13 DM_1 VB3 net7 vss sg13_lv_nmos l=x_dut_xm13_l m=x_dut_xm13_m w=x_dut_xm13_w
XM14 VB3 VB3 vss vss sg13_lv_nmos l=x_dut_xm14_l m=x_dut_xm14_m w=x_dut_xm14_w
XM15 VOUTN VB3 DM_2 vss sg13_lv_nmos l=x_dut_xm15_l m=x_dut_xm15_m w=x_dut_xm15_w
XM16 net050 VB3 net8 vss sg13_lv_nmos l=x_dut_xm16_l m=x_dut_xm16_m w=x_dut_xm16_w
XM17 net6 VB4 vss vss sg13_lv_nmos l=x_dut_xm17_l m=x_dut_xm17_m w=x_dut_xm17_w
XM18 net7 VB4 vss vss sg13_lv_nmos l=x_dut_xm18_l m=x_dut_xm18_m w=x_dut_xm18_w
XM19 DM_2 VB4 vss vss sg13_lv_nmos l=x_dut_xm19_l m=x_dut_xm19_m w=x_dut_xm19_w
XM2 DM_1 DM_1 vdd vdd sg13_lv_pmos l=x_dut_xm2_l m=x_dut_xm2_m w=x_dut_xm2_w
XM20 net8 VB4 vss vss sg13_lv_nmos l=x_dut_xm20_l m=x_dut_xm20_m w=x_dut_xm20_w
XM3 VB3 net1 vdd vdd sg13_lv_pmos l=x_dut_xm3_l m=x_dut_xm3_m w=x_dut_xm3_w
XM4 net31 net1 vdd vdd sg13_lv_pmos l=x_dut_xm4_l m=x_dut_xm4_m w=x_dut_xm4_w
XM5 VOUTN VOUTN vdd vdd sg13_lv_pmos l=x_dut_xm5_l m=x_dut_xm5_m w=x_dut_xm5_w
XM6 net050 VOUTN vdd vdd sg13_lv_pmos l=x_dut_xm6_l m=x_dut_xm6_m w=x_dut_xm6_w
XM61 net3 VB4 vss vss sg13_lv_nmos l=x_dut_xm61_l m=x_dut_xm61_m w=x_dut_xm61_w
XM68 VOUT net050 vdd vdd sg13_lv_pmos l=x_dut_xm68_l m=x_dut_xm68_m w=x_dut_xm68_w
XM69 VOUT net5 vss vss sg13_lv_nmos l=x_dut_xm69_l m=x_dut_xm69_m w=x_dut_xm69_w
XM70 net3 net050 vdd vdd sg13_lv_pmos l=x_dut_xm70_l m=x_dut_xm70_m w=x_dut_xm70_w
XM71 net3 net3 vss vss sg13_lv_nmos l=x_dut_xm71_l m=x_dut_xm71_m w=x_dut_xm71_w
XM72 net5 net3 vss vss sg13_lv_nmos l=x_dut_xm72_l m=x_dut_xm72_m w=x_dut_xm72_w
XM73 net5 DM_1 vdd vdd sg13_lv_pmos l=x_dut_xm73_l m=x_dut_xm73_m w=x_dut_xm73_w
XM8 DM_2 VINN net31 net31 sg13_lv_pmos l=x_dut_xm8_l m=x_dut_xm8_m w=x_dut_xm8_w
XM9 net8 VINP net31 net31 sg13_lv_pmos l=x_dut_xm9_l m=x_dut_xm9_m w=x_dut_xm9_w
.ends
