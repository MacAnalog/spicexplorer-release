** GENERATED by `analog-db generate` — DO NOT EDIT. Source: abstract/netlist.spice → ihp-sg13g2
* ia_002_fan_chopper_simple (emitted by spicexplorer-circuitgraph)
CFB1 fbch_p vsum_n 'x_dut_cfb1_value'
CFB2 fbch_n vsum_p 'x_dut_cfb2_value'
CIN1 vsum_n inch_n 'x_dut_cin1_value'
CIN2 vsum_p inch_p 'x_dut_cin2_value'
CM1 g2_p voutp 'x_dut_cm1_value'
CM2 g2_n voutn 'x_dut_cm2_value'
RB1 vsum_n vref 'x_dut_rb1_value'
RB2 vsum_p vref 'x_dut_rb2_value'
VB1 vb1 vss dc {vb1}
VB2 vb2 vss dc {vb2}
VB3 vb3 vss dc {vb3}
VB4 vb4 vss dc {vb4}
XM1 tail vb4 vdd vdd sg13_lv_pmos l=x_dut_xm1_l m=x_dut_xm1_m w=x_dut_xm1_w
XM10 out1_n vb3 casc_src_n vdd sg13_lv_pmos l=x_dut_xm10_l m=x_dut_xm10_m w=x_dut_xm10_w
XM11 out1_p vb3 casc_src_p vdd sg13_lv_pmos l=x_dut_xm11_l m=x_dut_xm11_m w=x_dut_xm11_w
XM12 out1_p vb2 fold_p vss sg13_lv_nmos l=x_dut_xm12_l m=x_dut_xm12_m w=x_dut_xm12_w
XM13 out1_n vb2 fold_n vss sg13_lv_nmos l=x_dut_xm13_l m=x_dut_xm13_m w=x_dut_xm13_w
XM14 voutp g2_p vss vss sg13_lv_nmos l=x_dut_xm14_l m=x_dut_xm14_m w=x_dut_xm14_w
XM15 voutn g2_n vss vss sg13_lv_nmos l=x_dut_xm15_l m=x_dut_xm15_m w=x_dut_xm15_w
XM16 out1_n clk_chout g2_n vss sg13_lv_nmos l=x_dut_xm16_l m=x_dut_xm16_m w=x_dut_xm16_w
XM17 g2_n clk_chout_not out1_n vdd sg13_lv_pmos l=x_dut_xm17_l m=x_dut_xm17_m w=x_dut_xm17_w
XM18 out1_p clk_chout g2_p vss sg13_lv_nmos l=x_dut_xm18_l m=x_dut_xm18_m w=x_dut_xm18_w
XM19 g2_p clk_chout_not out1_p vdd sg13_lv_pmos l=x_dut_xm19_l m=x_dut_xm19_m w=x_dut_xm19_w
XM2 fold_p vsum_p tail vdd sg13_lv_pmos l=x_dut_xm2_l m=x_dut_xm2_m w=x_dut_xm2_w
XM20 fbch_p clk_chfb voutp vss sg13_lv_nmos l=x_dut_xm20_l m=x_dut_xm20_m w=x_dut_xm20_w
XM21 voutp clk_chfb_not fbch_p vdd sg13_lv_pmos l=x_dut_xm21_l m=x_dut_xm21_m w=x_dut_xm21_w
XM22 fbch_n clk_chfb voutn vss sg13_lv_nmos l=x_dut_xm22_l m=x_dut_xm22_m w=x_dut_xm22_w
XM23 voutn clk_chfb_not fbch_n vdd sg13_lv_pmos l=x_dut_xm23_l m=x_dut_xm23_m w=x_dut_xm23_w
XM24 vinn clk_chin inch_n vss sg13_lv_nmos l=x_dut_xm24_l m=x_dut_xm24_m w=x_dut_xm24_w
XM25 inch_n clk_chin_not vinn vdd sg13_lv_pmos l=x_dut_xm25_l m=x_dut_xm25_m w=x_dut_xm25_w
XM26 vinp clk_chin inch_p vss sg13_lv_nmos l=x_dut_xm26_l m=x_dut_xm26_m w=x_dut_xm26_w
XM27 inch_p clk_chin_not vinp vdd sg13_lv_pmos l=x_dut_xm27_l m=x_dut_xm27_m w=x_dut_xm27_w
XM28 out1_n clk_chout_not g2_p vss sg13_lv_nmos l=x_dut_xm28_l m=x_dut_xm28_m w=x_dut_xm28_w
XM29 g2_p clk_chout out1_n vdd sg13_lv_pmos l=x_dut_xm29_l m=x_dut_xm29_m w=x_dut_xm29_w
XM3 fold_n vsum_n tail vdd sg13_lv_pmos l=x_dut_xm3_l m=x_dut_xm3_m w=x_dut_xm3_w
XM30 out1_p clk_chout_not g2_n vss sg13_lv_nmos l=x_dut_xm30_l m=x_dut_xm30_m w=x_dut_xm30_w
XM31 g2_n clk_chout out1_p vdd sg13_lv_pmos l=x_dut_xm31_l m=x_dut_xm31_m w=x_dut_xm31_w
XM32 vinn clk_chin_not inch_p vss sg13_lv_nmos l=x_dut_xm32_l m=x_dut_xm32_m w=x_dut_xm32_w
XM33 inch_p clk_chin vinn vdd sg13_lv_pmos l=x_dut_xm33_l m=x_dut_xm33_m w=x_dut_xm33_w
XM34 vinp clk_chin_not inch_n vss sg13_lv_nmos l=x_dut_xm34_l m=x_dut_xm34_m w=x_dut_xm34_w
XM35 inch_n clk_chin vinp vdd sg13_lv_pmos l=x_dut_xm35_l m=x_dut_xm35_m w=x_dut_xm35_w
XM36 fbch_p clk_chfb_not voutn vss sg13_lv_nmos l=x_dut_xm36_l m=x_dut_xm36_m w=x_dut_xm36_w
XM37 voutn clk_chfb fbch_p vdd sg13_lv_pmos l=x_dut_xm37_l m=x_dut_xm37_m w=x_dut_xm37_w
XM38 fbch_n clk_chfb_not voutp vss sg13_lv_nmos l=x_dut_xm38_l m=x_dut_xm38_m w=x_dut_xm38_w
XM39 voutp clk_chfb fbch_n vdd sg13_lv_pmos l=x_dut_xm39_l m=x_dut_xm39_m w=x_dut_xm39_w
XM4 fold_p vb1 vss vss sg13_lv_nmos l=x_dut_xm4_l m=x_dut_xm4_m w=x_dut_xm4_w
XM5 fold_n vb1 vss vss sg13_lv_nmos l=x_dut_xm5_l m=x_dut_xm5_m w=x_dut_xm5_w
XM6 casc_src_n vb4 vdd vdd sg13_lv_pmos l=x_dut_xm6_l m=x_dut_xm6_m w=x_dut_xm6_w
XM7 casc_src_p vb4 vdd vdd sg13_lv_pmos l=x_dut_xm7_l m=x_dut_xm7_m w=x_dut_xm7_w
XM8 voutp vb4 vdd vdd sg13_lv_pmos l=x_dut_xm8_l m=x_dut_xm8_m w=x_dut_xm8_w
XM9 voutn vb4 vdd vdd sg13_lv_pmos l=x_dut_xm9_l m=x_dut_xm9_m w=x_dut_xm9_w
.end
