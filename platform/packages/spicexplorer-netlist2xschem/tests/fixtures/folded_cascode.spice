* folded cascode inline
** GENERATED by `analog-db export-raw` — DO NOT EDIT.
** Standalone lowered DUT subckt for folded_cascode_ota on ihp-sg13g2 (sizing .param defaults + .subckt).
** Not a runnable deck on its own — include it under your own testbench:
**   .include _dut.spice
**   XDUT vinn vinp vout vdd ibias vss folded_cascode_ota
** Source: pdk/ihp-sg13g2/netlist.spice (run `analog-db generate` to refresh).
*----------------------------------------------------------*
.param x_dut_w_1=72u
.param x_dut_l_1=2u
.param x_dut_w_2=106.5u
.param x_dut_l_2=2u
.param x_dut_w_3=44u
.param x_dut_l_3=2.5u
.param x_dut_w_4=78u
.param x_dut_l_4=2u
.param x_dut_w_5=183u
.param x_dut_l_5=4.5u
.param x_dut_w_6=50u
.param x_dut_l_6=3u
.param x_dut_w_7=50u
.param x_dut_l_7=3u
.param x_dut_vb1=1.225
.param x_dut_vb2=1.275
.param x_dut_ib=34u
.param x_dut_ng_1=8
.param x_dut_ng_2=11
.param x_dut_ng_3=5
.param x_dut_ng_4=8
.param x_dut_ng_5=19
.param x_dut_ng_6=5
.param x_dut_ng_7=5
.subckt folded_cascode_ota vinn vinp vout vdd ibias vss
V1 vb1 vss x_dut_vb1
V2 vb2 vss x_dut_vb2
XM0 tail ibias vdd vdd sg13_lv_pmos l=x_dut_l_6 m=1 ng=x_dut_ng_6 w=x_dut_w_6
XM1 foldp vinp tail vdd sg13_lv_pmos l=x_dut_l_1 m=1 ng=x_dut_ng_1 w=x_dut_w_1
XM10 s10 cascp vdd vdd sg13_lv_pmos l=x_dut_l_5 m=1 ng=x_dut_ng_5 w=x_dut_w_5
XM11 ibias ibias vdd vdd sg13_lv_pmos l=x_dut_l_6 m=1 ng=x_dut_ng_6 w=x_dut_w_6
XM12 nbias ibias vdd vdd sg13_lv_pmos l=x_dut_l_7 m=1 ng=x_dut_ng_7 w=x_dut_w_7
XM13 nbias nbias vss vss sg13_lv_nmos l=x_dut_l_2 m=1 ng=x_dut_ng_2 w=x_dut_w_2
XM2 foldn vinn tail vdd sg13_lv_pmos l=x_dut_l_1 m=1 ng=x_dut_ng_1 w=x_dut_w_1
XM3 foldp nbias vss vss sg13_lv_nmos l=x_dut_l_2 m=1 ng=x_dut_ng_2 w=x_dut_w_2
XM4 foldn nbias vss vss sg13_lv_nmos l=x_dut_l_2 m=1 ng=x_dut_ng_2 w=x_dut_w_2
XM5 cascp vb1 foldp vss sg13_lv_nmos l=x_dut_l_3 m=1 ng=x_dut_ng_3 w=x_dut_w_3
XM6 vout vb1 foldn vss sg13_lv_nmos l=x_dut_l_3 m=1 ng=x_dut_ng_3 w=x_dut_w_3
XM7 cascp vb2 s9 vdd sg13_lv_pmos l=x_dut_l_4 m=1 ng=x_dut_ng_4 w=x_dut_w_4
XM8 vout vb2 s10 vdd sg13_lv_pmos l=x_dut_l_4 m=1 ng=x_dut_ng_4 w=x_dut_w_4
XM9 s9 cascp vdd vdd sg13_lv_pmos l=x_dut_l_5 m=1 ng=x_dut_ng_5 w=x_dut_w_5
.ends
XDUT vinn vinp vout vdd ibias vss folded_cascode_ota
.end
