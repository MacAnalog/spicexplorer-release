** GENERATED by `analog-db export-raw` — DO NOT EDIT.
** circuit=adc_001_inv1b  class=adc  pdk=ihp-sg13g2  testbench=dc_transfer  corner=tt
** Self-contained deck: testbench + bound params + lowered DUT (.subckt adc_001_inv1b).
** PDK corner libs resolve by BARE NAME on the image's ngspice sourcepath — run in a
** PDK-enabled env (the base image / api container), NOT a bare host:
**   docker run --rm -i spicexplorer-spice-base:local \
**     bash -lc 'd=$(mktemp -d) && cat > $d/c.spice && cd $d && ngspice -b c.spice' < raw/adc_001_inv1b/ihp-sg13g2/dc_transfer.spice
*----------------------------------------------------------*
** params: 6 free + 0 frozen knobs (sizing.yaml) · 0 tied · 0 ratio-derived (abstract/params.yaml) · 1 testbench params
** AUTHORED TEMPLATE — adc/dc_transfer: static input→output transfer of a converter.
** For a 1-bit/flash slice: sweeps the analog input and reads the digital output rails
** (v_out_high at VIN_LO, v_out_low at VIN_HI) and the decision level threshold_v (input where the
** output crosses VMID). For a multi-bit converter this same sweep yields offset / gain-error /
** INL/DNL from the code transfer. Port convention: vdd vin vout vss.
** Bindings: DUT PORT_LINE VDD VIN_LO VIN_HI VIN_STEP VMID PDK_INCLUDE.
.lib cornerMOSlv.lib mos_tt
.temp 27

.param VDD=1.2

Vdd vdd 0 dc {VDD}
Vss vss 0 dc 0
Vin vin 0 dc 0

XDUT vdd vin vout vss adc_001_inv1b

.control
  set filetype=ascii
  dc Vin 0 1.2 0.01
  meas dc v_out_high  FIND v(vout) AT=0
  meas dc v_out_low   FIND v(vout) AT=1.2
  meas dc threshold_v WHEN v(vout)=0.6
  print v_out_high v_out_low threshold_v
  write
  quit
.endc
.param x_dut_xmn_w=1.0u
.param x_dut_xmn_l=0.13u
.param x_dut_xmn_m=1
.param x_dut_xmp_w=2.5u
.param x_dut_xmp_l=0.13u
.param x_dut_xmp_m=1
.subckt adc_001_inv1b vdd vin vout vss
XMN vout vin vss vss sg13_lv_nmos l=x_dut_xmn_l m=x_dut_xmn_m w=x_dut_xmn_w
XMP vout vin vdd vdd sg13_lv_pmos l=x_dut_xmp_l m=x_dut_xmp_m w=x_dut_xmp_w
.ends
.end
