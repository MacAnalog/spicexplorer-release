** GENERATED by `analog-db export-raw` — DO NOT EDIT.
** circuit=amp_019_ti_ldo_error  class=amplifier  pdk=ihp-sg13g2  testbench=noise  corner=tt
** Self-contained deck: testbench + bound params + lowered DUT (.subckt amp_019_ti_ldo_error).
** PDK corner libs resolve by BARE NAME on the image's ngspice sourcepath — run in a
** PDK-enabled env (the base image / api container), NOT a bare host:
**   docker run --rm -i spicexplorer-spice-base:local \
**     bash -lc 'd=$(mktemp -d) && cat > $d/c.spice && cd $d && ngspice -b c.spice' < raw/amp_019_ti_ldo_error/ihp-sg13g2/noise.spice
*----------------------------------------------------------*
** params: 19 free + 0 frozen knobs (sizing.yaml) · 10 tied · 0 ratio-derived (abstract/params.yaml) · 4 testbench params
** AUTHORED TEMPLATE — amplifier/noise_biaswrap_ibias: input-referred noise for DUTs on the class
** ibias-port convention (ports vdd vout vinp vinn ibias vss) whose OPEN-LOOP op point does not sit
** at mid-rail — an amp with a large systematic offset (e.g. amp_019's ratioed error-amp sink) rails
** or near-rails the output under a plain (unwrapped) noise bench, so its input-referred noise is
** taken at a non-representative bias. Same 1 TH / 1 TF bias-wrap as ac_open_loop_biaswrap_ibias:
** Lfb DC-shorts vout back to the INVERTING input to set the high-gain operating point, while Cin
** AC-opens that loop and injects the noise input source Vac; input-referred noise is w.r.t. Vac
** (at the noise band Cin is a short + Lfb an open, so the small-signal input path is vinn).
** Bindings: DUT PORT_LINE VDD VCM CL IBIAS FSTART FSTOP PPD PDK_INCLUDE.
.lib cornerMOShv.lib mos_tt
.lib cornerRES.lib res_typ
.temp 27

.param VDD=3.3
.param VCM=1.2
.param CL=10p
.param IBIAS=1m

Vdd  vdd 0 dc {VDD}
Vss  vss 0 dc 0
Ibias vdd ibias dc {IBIAS}
Vcm  vinp 0 dc {VCM}          ; common-mode bias on the non-inverting input
Vac  sigin 0 dc 0 ac 1        ; noise input source (input-referral reference)
Lfb  vout vinn 1T             ; 1 TH: DC short (bias), AC open
Cin  vinn sigin 1T            ; 1 TF: DC open, AC inject into the inverting node
CLoad vout 0 {CL}

XDUT vdd vout vinp vinn ibias vss amp_019_ti_ldo_error

.control
  set filetype=ascii
  noise v(vout) Vac dec 101 1 1MEG
  print inoise_total onoise_total
  write
  quit
.endc
.param x_dut_xmb0_w=0.0001
.param x_dut_xmb0_l=5e-07
.param x_dut_xmbc_m=1
.param x_dut_xmbo_m=1
.param x_dut_xm1_w=0.0001
.param x_dut_xm1_l=4.5e-07
.param x_dut_xm3_w=0.00015
.param x_dut_xm3_l=4.5e-07
.param x_dut_xm4_w=1e-05
.param x_dut_xm4_l=5e-07
.param x_dut_xm7_w=0.0001
.param x_dut_xm7_l=4.5e-07
.param x_dut_xm6_w=1.6e-05
.param x_dut_xm6_l=4.5e-07
.param r_z=680
.param c_comp=4e-11
.param x_dut_xmbe_w=5e-06
.param x_dut_xmbf_w=5e-06
.param r_nd=500000
* ---- GENERATED parameter ties (abstract/params.yaml groups/ratios) ----
* Each tied symbol is defined exactly once, by its line below; rewrite that
* .param to untie just that symbol (untying = shadowing, plan D-3).
.param x_dut_xmbc_l = {x_dut_xmb0_l}
.param x_dut_xmbf_l = {x_dut_xmb0_l}
.param x_dut_xmbe_l = {x_dut_xmb0_l}
.param x_dut_xmbo_l = {x_dut_xmb0_l}
.param x_dut_xmbc_w = {x_dut_xmb0_w}
.param x_dut_xmbo_w = {x_dut_xmb0_w}
.param x_dut_xm2_w = {x_dut_xm1_w}
.param x_dut_xm2_l = {x_dut_xm1_l}
.param x_dut_xm5_w = {x_dut_xm3_w}
.param x_dut_xm5_l = {x_dut_xm3_l}
.subckt amp_019_ti_ldo_error vdd vout vinp vinn ibias vss
CC ncz vout 'c_comp'
RND na nd 'r_nd'
RZ nb ncz 'r_z'
XM1 na vinn tail vss sg13_hv_nmos l=x_dut_xm1_l w=x_dut_xm1_w
XM2 nb vinp tail vss sg13_hv_nmos l=x_dut_xm2_l w=x_dut_xm2_w
XM3 na nd vdd vdd sg13_hv_pmos l=x_dut_xm3_l w=x_dut_xm3_w
XM4 nlev na nd vdd sg13_hv_pmos l=x_dut_xm4_l w=x_dut_xm4_w
XM5 nb nd vdd vdd sg13_hv_pmos l=x_dut_xm5_l w=x_dut_xm5_w
XM6 vout ne vdd vdd sg13_hv_pmos l=x_dut_xm6_l w=x_dut_xm6_w
XM7 ne ne nb vdd sg13_hv_pmos l=x_dut_xm7_l w=x_dut_xm7_w
XMB0 ibias ibias vss vss sg13_hv_nmos l=x_dut_xmb0_l w=x_dut_xmb0_w
XMBC tail ibias vss vss sg13_hv_nmos l=x_dut_xmbc_l m=x_dut_xmbc_m w=x_dut_xmbc_w
XMBE ne ibias vss vss sg13_hv_nmos l=x_dut_xmbe_l w=x_dut_xmbe_w
XMBF nlev ibias vss vss sg13_hv_nmos l=x_dut_xmbf_l w=x_dut_xmbf_w
XMBO vout ibias vss vss sg13_hv_nmos l=x_dut_xmbo_l m=x_dut_xmbo_m w=x_dut_xmbo_w
.ends
.end
