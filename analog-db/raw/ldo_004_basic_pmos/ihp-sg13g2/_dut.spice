** GENERATED by `analog-db export-raw` — DO NOT EDIT.
** Standalone lowered DUT subckt for ldo_004_basic_pmos on ihp-sg13g2 (sizing .param defaults + .subckt).
** Not a runnable deck on its own — include it under your own testbench:
**   .include _dut.spice
**   XDUT vdd vout vss ldo_004_basic_pmos
** Source: pdk/ihp-sg13g2/netlist.spice (run `analog-db generate` to refresh).
*----------------------------------------------------------*
** params: 11 free + 0 frozen knobs (sizing.yaml) · 4 tied · 0 ratio-derived (abstract/params.yaml)
.param x_dut_xmp_w=10u
.param x_dut_xmp_m=200
.param x_dut_xmp_l=0.3u
.param r_top=100k
.param r_bot=100k
.param vref_val=0.635
.param i_tail=200u
.param x_dut_xm1_w=50u
.param x_dut_xm1_l=1u
.param x_dut_xm3_w=45u
.param x_dut_xm3_l=1u
* ---- GENERATED parameter ties (abstract/params.yaml groups/ratios) ----
* Each tied symbol is defined exactly once, by its line below; rewrite that
* .param to untie just that symbol (untying = shadowing, plan D-3).
.param x_dut_xm2_w = {x_dut_xm1_w}
.param x_dut_xm2_l = {x_dut_xm1_l}
.param x_dut_xm4_w = {x_dut_xm3_w}
.param x_dut_xm4_l = {x_dut_xm3_l}
.subckt ldo_004_basic_pmos vdd vout vss
ITAIL etail vss dc {i_tail}
R1 vout fb 'r_top'
R2 fb vss 'r_bot'
VREF vref vss dc {vref_val}
XM1 noutm fb etail vss sg13_lv_nmos l=x_dut_xm1_l w=x_dut_xm1_w
XM2 egate vref etail vss sg13_lv_nmos l=x_dut_xm2_l w=x_dut_xm2_w
XM3 noutm noutm vdd vdd sg13_lv_pmos l=x_dut_xm3_l w=x_dut_xm3_w
XM4 egate noutm vdd vdd sg13_lv_pmos l=x_dut_xm4_l w=x_dut_xm4_w
XMP vout egate vdd vdd sg13_lv_pmos l=x_dut_xmp_l m=x_dut_xmp_m w=x_dut_xmp_w
.ends
