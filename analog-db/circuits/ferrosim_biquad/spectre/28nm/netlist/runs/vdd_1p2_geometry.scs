simulator lang=spectre
parameters VDD=1.2
include "runs/common_setup_geometry.scs"
