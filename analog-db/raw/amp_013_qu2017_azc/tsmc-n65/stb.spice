** GENERATED by `analog-db export-raw` — DO NOT EDIT.
** circuit=amp_013_qu2017_azc  class=amplifier  pdk=tsmc-n65  testbench=stb  corner=tt
** Self-contained deck: testbench + bound params + lowered DUT (.subckt amp_013_qu2017_azc).
** PDK corner libs resolve by BARE NAME on the image's ngspice sourcepath — run in a
** PDK-enabled env (the base image / api container), NOT a bare host:
**   docker run --rm -i spicexplorer-spice-base:local \
**     bash -lc 'd=$(mktemp -d) && cat > $d/c.spice && cd $d && ngspice -b c.spice' < raw/amp_013_qu2017_azc/tsmc-n65/stb.spice
*----------------------------------------------------------*
** params: 38 free + 0 frozen knobs (sizing.yaml) · 34 tied · 11 ratio-derived (abstract/params.yaml) · 3 testbench params
** AUTHORED TEMPLATE — amplifier/stb_selfbias (2026-08-01): TRUE loop gain, phase margin and
** gain margin of the unity-gain buffer by Middlebrook voltage injection at the VIPRB marker,
** for SELF-BIASED DUTs (no ibias port — the TI-LDO error amps amp_032/033). Identical to
** `stb` except there is no external bias source — derived exactly as psrr_vdd_selfbias
** derives from psrr_vdd (drop `.param IBIAS` and the `Ibias` line), so a 5-port
** [vdd vout vinp vinn vss] DUT does not leave a current source driving a dangling `ibias`
** node (which makes the DC solve singular). Injecting at the DC-short keeps the operating
** point the CLOSED-loop buffer one — the same op point ac_closed_loop_selfbias already proves
** out for these DUTs, so biasing is safe (amp_032's designed-in systematic offset rails an
** UNWRAPPED open-loop bias, which is exactly why its ac_open_loop needs biaswrap; this bench
** never leaves the closed loop, so it needs no wrap).
** EVERYTHING measurement-side is grafted from stb.spice UNCHANGED — that header carries the
** full audited story (math, phase-reference snap + guard, crossing convention, seed
** discipline) and is the reference for any future edit here; the load-bearing invariants:
**   * VIPRB stays a plain 0 V source in the NETLIST — the marker the Spectre emitter maps to
**     `iprobe` for `stb stb probe=VIPRB`; only this .control turns it into the generator via
**     `alter`. Same netlist bytes, same probe, both lanes.
**   * MATH is exact: the marker forces V(vinn) - V(vout) = 1 V AC, so T = v(vout)/v(vinn) = G
**     identically; the only assumption is Middlebrook's impedance condition (low-Z DUT output
**     driving a purely capacitive gate), satisfied by orders of magnitude here.
**   * PHASE REFERENCE snapped to the nearest multiple of 180 at FSTART; |phref_dev| <= 30 or
**     the guard blanks every phase-derived measure to the 999 sentinel (past 90 the branch
**     flips and every margin would be 180 deg out — measured, not hypothetical). Bind the
**     class FSTART = 0.01 Hz (the value at which every single-ended amp of this corpus clears
**     the guard — amp_032/033 @ gf180mcu were part of that measured sweep).
**   * pm_loop at the LAST 0 dB crossing (first-crossing pm certifies unstable loops — the
**     PM-rescue finding); pm_loop_first emitted beside it, gm_loop at the FIRST -180 deg
**     crossing.
**   * SEEDS are the bare -999 sentinel, never a plausible reduction: the only way
**     pm_loop / pm_loop_first / gm_loop carry a number is an actually-interpolated crossing.
**     -999, never +999 — ppa._spec_verdict fails value<min / value>max only, so +999 PASSES
**     every min-bound margin spec silently; -999 fails it (the honest verdict). ugf_loop
**     keeps its reduction seed because its degenerate values (FSTOP / 0) are real information.
**   * No `>` inside a `let` — the .control preprocessor strips it as an output redirection
**     and silently truncates the RHS; masks use `<=` and 1 - mask.
**   * Measure names match the ibias sibling EXACTLY (loopgain_db, ugf_loop, pm_loop, gm_loop,
**     pm_loop_first, phref_dev, phref_ok) so datasheet wiring stays uniform across variants.
** Bindings: DUT PORT_LINE VDD VCM CL FSTART FSTOP PPD PDK_INCLUDE.
.lib tsmc_n65_models.scs tt
.temp 27

.param VDD=1.8
.param VCM=300m
.param CL=10p

Vdd  vdd 0 dc {VDD}
Vss  vss 0 dc 0
CLoad vout 0 {CL}

Vinp vinp 0 dc {VCM} ac 1
VIPRB vinn vout dc 0

XDUT vss vdd vinn vinp vout amp_013_qu2017_azc

.control
  set filetype=ascii
  * break the loop: VIPRB becomes the 1 V AC generator, the forward input goes AC-silent.
  * (Vinp's `ac 1` is left on the netlist line for the Spectre lane; if it stayed live here it
  * would sum into the loop and v(vout)/v(vinn) would not be the loop gain.)
  alter @Vinp[acmag] = 0
  alter @VIPRB[acmag] = 1
  ac dec 101 1e-4 1G

  let tloop = v(vout)/v(vinn)
  let tdb   = db(tloop)
  let ntdb  = 0 - tdb
  let f     = real(frequency)
  let tphc  = cph(tloop)*180/3.14159265
  * snap the DC phase reference to the exact 0/+-180 the loop must have at DC (see header)
  let ph0   = 180*floor(tphc[0]/180 + 0.5)
  let phref_dev = tphc[0] - ph0

  * PHASE-REFERENCE GUARD (see header). |phref_dev| <= 90 by construction, and the snap changes
  * branch at 90, so |phref_dev| IS the distance to the ambiguity. Below 30 deg the branch is
  * unique with 60 deg to spare; at or above it the deck refuses to pick one and blanks the
  * phase vector to the 999 sentinel, which propagates into every phase-derived measure below.
  let phref_ok  = (abs(phref_dev) <= 30)
  let phref_bad = 1 - phref_ok
  let tph = (180 + tphc - ph0)*phref_ok + (-999)*phref_bad

  * mask (no `>` — see the parser gotcha in the header)
  let mb = (tdb <= 0)
  let ma = 1 - mb

  * seeds. ugf_loop's reduction is itself information (FSTOP = |T| > 1 everywhere, 0 = never
  * reaches unity). The margins get the bare sentinel: a seed must never look like a reading.
  let loopgain_db   = tdb[0]
  let ugf_loop      = maximum(f*ma)
  let pm_loop       = -999
  let gm_loop       = -999
  let pm_loop_first = -999

  * interpolated refinements; each silently leaves its seed in place if it finds no crossing
  meas ac loopgain_db FIND tdb  AT=1e-4
  meas ac ugf_loop    WHEN tdb=0 FALL=LAST
  meas ac pm_loop     FIND tph  WHEN tdb=0 FALL=LAST
  meas ac gm_loop     FIND ntdb WHEN tph=0 FALL=1
  meas ac pm_loop_first FIND tph WHEN tdb=0 FALL=1

  print loopgain_db ugf_loop pm_loop gm_loop pm_loop_first phref_dev phref_ok
  write
  quit
.endc
.param CAPACITOR_0=810f
.param CAPACITOR_1=404f
.param CAPACITOR_2=310f
.param CURRENT_0_BIAS=1u
.param x_dut_xm3_l=1u
.param x_dut_xm5_m=4
.param x_dut_xm3_w=1u
.param x_dut_xm11_l=1u
.param x_dut_xm11_m=4
.param x_dut_xm11_w=1u
.param x_dut_xm12_l=1u
.param x_dut_xm12_m=4
.param x_dut_xm12_w=1u
.param x_dut_xm13_l=1u
.param x_dut_xm13_m=4
.param x_dut_xm13_w=1u
.param x_dut_xm16_l=1u
.param x_dut_xm16_m=4
.param x_dut_xm16_w=1u
.param x_dut_xm18_l=1u
.param x_dut_xm18_m=4
.param x_dut_xm18_w=1u
.param x_dut_xm19_l=1u
.param x_dut_xm19_m=4
.param x_dut_xm20_w=7u
.param x_dut_xm24_l=1u
.param x_dut_xm24_m=4
.param x_dut_xm24_w=1u
.param x_dut_xm6_l=1u
.param x_dut_xm6_m=4
.param x_dut_xm6_w=1u
.param x_dut_xm10_l=1u
.param x_dut_xm10_m=4
.param x_dut_xm10_w=1u
.param RESISTOR_0=35K
.param RESISTOR_1=35k
.param RESISTOR_2=350k
.param RESISTOR_3=40k
* ---- GENERATED parameter ties (abstract/params.yaml groups/ratios) ----
* Each tied symbol is defined exactly once, by its line below; rewrite that
* .param to untie just that symbol (untying = shadowing, plan D-3).
.param x_dut_xm7_w = {x_dut_xm6_w}
.param x_dut_xm7_l = {x_dut_xm6_l}
.param x_dut_xm8_w = {x_dut_xm3_w}
.param x_dut_xm5_w = {x_dut_xm3_w}
.param x_dut_xm4_w = {x_dut_xm3_w}
.param x_dut_xm2_w = {x_dut_xm3_w}
.param x_dut_xm1_w = {x_dut_xm3_w}
.param x_dut_xm0_w = {x_dut_xm3_w}
.param x_dut_xm8_l = {x_dut_xm3_l}
.param x_dut_xm5_l = {x_dut_xm3_l}
.param x_dut_xm4_l = {x_dut_xm3_l}
.param x_dut_xm2_l = {x_dut_xm3_l}
.param x_dut_xm1_l = {x_dut_xm3_l}
.param x_dut_xm0_l = {x_dut_xm3_l}
.param x_dut_xm9_w = {x_dut_xm10_w}
.param x_dut_xm9_l = {x_dut_xm10_l}
.param x_dut_xm9_m = {x_dut_xm10_m}
.param x_dut_xm22_w = {x_dut_xm24_w}
.param x_dut_xm23_w = {x_dut_xm24_w}
.param x_dut_xm22_l = {x_dut_xm24_l}
.param x_dut_xm23_l = {x_dut_xm24_l}
.param x_dut_xm17_w = {x_dut_xm16_w}
.param x_dut_xm14_w = {x_dut_xm16_w}
.param x_dut_xm15_w = {x_dut_xm16_w}
.param x_dut_xm17_l = {x_dut_xm16_l}
.param x_dut_xm14_l = {x_dut_xm16_l}
.param x_dut_xm15_l = {x_dut_xm16_l}
.param x_dut_xm17_m = {x_dut_xm16_m}
.param x_dut_xm14_m = {x_dut_xm16_m}
.param x_dut_xm15_m = {x_dut_xm16_m}
.param x_dut_xm20_l = {x_dut_xm19_l}
.param x_dut_xm21_l = {x_dut_xm19_l}
.param x_dut_xm20_m = {x_dut_xm19_m}
.param x_dut_xm21_m = {x_dut_xm19_m}
.param x_dut_xm7_m = {x_dut_xm6_m*2}
.param x_dut_xm3_m = {x_dut_xm5_m*6}
.param x_dut_xm8_m = {x_dut_xm5_m*2}
.param x_dut_xm4_m = {x_dut_xm5_m*1}
.param x_dut_xm2_m = {x_dut_xm5_m*2}
.param x_dut_xm1_m = {x_dut_xm5_m*1}
.param x_dut_xm0_m = {x_dut_xm5_m*1}
.param x_dut_xm22_m = {x_dut_xm24_m*4}
.param x_dut_xm23_m = {x_dut_xm24_m*3}
.param x_dut_xm21_w = {x_dut_xm20_w*1}
.param x_dut_xm19_w = {x_dut_xm20_w*2/7}
.subckt amp_013_qu2017_azc vss vdd vinn vinp vout
C0 net063 VOUT 'CAPACITOR_0'
C1 net051 vss 'CAPACITOR_1'
C2 net043 vss 'CAPACITOR_2'
I0 VB1 vss 'CURRENT_0_BIAS'
R0 net078 net077 'RESISTOR_0'
R1 net078 net082 'RESISTOR_1'
R2 net057 net051 'RESISTOR_2'
R3 net057 net043 'RESISTOR_3'
XM0 VB1 VB1 vdd vdd pch_lvt l=x_dut_xm0_l m=x_dut_xm0_m w=x_dut_xm0_w
XM1 VB4 VB1 vdd vdd pch_lvt l=x_dut_xm1_l m=x_dut_xm1_m w=x_dut_xm1_w
XM10 net063 VINP net019 net019 pch_lvt l=x_dut_xm10_l m=x_dut_xm10_m w=x_dut_xm10_w
XM11 net094 net050 vdd vdd pch_lvt l=x_dut_xm11_l m=x_dut_xm11_m w=x_dut_xm11_w
XM12 net055 net094 vss vss nch_lvt l=x_dut_xm12_l m=x_dut_xm12_m w=x_dut_xm12_w
XM13 VOUT net050 vdd vdd pch_lvt l=x_dut_xm13_l m=x_dut_xm13_m w=x_dut_xm13_w
XM14 VOUTN net077 DM_2 vss nch_lvt l=x_dut_xm14_l m=x_dut_xm14_m w=x_dut_xm14_w
XM15 net050 net082 net063 vss nch_lvt l=x_dut_xm15_l m=x_dut_xm15_m w=x_dut_xm15_w
XM16 net077 DM_2 vss vss nch_lvt l=x_dut_xm16_l m=x_dut_xm16_m w=x_dut_xm16_w
XM17 net082 net063 vss vss nch_lvt l=x_dut_xm17_l m=x_dut_xm17_m w=x_dut_xm17_w
XM18 VOUT net049 vss vss nch_lvt l=x_dut_xm18_l m=x_dut_xm18_m w=x_dut_xm18_w
XM19 VB4 VB4 vss vss nch_lvt l=x_dut_xm19_l m=x_dut_xm19_m w=x_dut_xm19_w
XM2 net019 VB1 vdd vdd pch_lvt l=x_dut_xm2_l m=x_dut_xm2_m w=x_dut_xm2_w
XM20 DM_2 VB4 vss vss nch_lvt l=x_dut_xm20_l m=x_dut_xm20_m w=x_dut_xm20_w
XM21 net063 VB4 vss vss nch_lvt l=x_dut_xm21_l m=x_dut_xm21_m w=x_dut_xm21_w
XM22 net094 net051 vss vss nch_lvt l=x_dut_xm22_l m=x_dut_xm22_m w=x_dut_xm22_w
XM23 net057 net043 vss vss nch_lvt l=x_dut_xm23_l m=x_dut_xm23_m w=x_dut_xm23_w
XM24 net049 net057 vss vss nch_lvt l=x_dut_xm24_l m=x_dut_xm24_m w=x_dut_xm24_w
XM3 net078 VB1 vdd vdd pch_lvt l=x_dut_xm3_l m=x_dut_xm3_m w=x_dut_xm3_w
XM4 VOUTN VOUTN vdd vdd pch_lvt l=x_dut_xm4_l m=x_dut_xm4_m w=x_dut_xm4_w
XM5 net050 VOUTN vdd vdd pch_lvt l=x_dut_xm5_l m=x_dut_xm5_m w=x_dut_xm5_w
XM6 net055 net055 vdd vdd pch_lvt l=x_dut_xm6_l m=x_dut_xm6_m w=x_dut_xm6_w
XM7 net057 net055 vdd vdd pch_lvt l=x_dut_xm7_l m=x_dut_xm7_m w=x_dut_xm7_w
XM8 net049 VB1 vdd vdd pch_lvt l=x_dut_xm8_l m=x_dut_xm8_m w=x_dut_xm8_w
XM9 DM_2 VINN net019 net019 pch_lvt l=x_dut_xm9_l m=x_dut_xm9_m w=x_dut_xm9_w
.ends
.end
