** GENERATED by `analog-db export-raw` — DO NOT EDIT.
** Standalone lowered DUT subckt for smp_001_nmos_th on ihp-sg13g2 (sizing .param defaults + .subckt).
** Not a runnable deck on its own — include it under your own testbench:
**   .include _dut.spice
**   XDUT vdd vin clk vout vss smp_001_nmos_th
** Source: pdk/ihp-sg13g2/netlist.spice (run `analog-db generate` to refresh).
*----------------------------------------------------------*
.param x_dut_xm0_w=2.0u
.param x_dut_xm0_l=0.13u
.param x_dut_xm0_m=1
.param x_dut_c0_value=500f
.subckt smp_001_nmos_th vdd vin clk vout vss
C0 vout vss x_dut_c0_value
XM0 vin clk vout vss sg13_lv_nmos l=x_dut_xm0_l m=x_dut_xm0_m w=x_dut_xm0_w
.ends
