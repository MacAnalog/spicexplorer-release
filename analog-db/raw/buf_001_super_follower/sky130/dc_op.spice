** GENERATED by `analog-db export-raw` — DO NOT EDIT.
** circuit=buf_001_super_follower  class=buffer  pdk=sky130  testbench=dc_op  corner=tt
** Self-contained deck: testbench + bound params + lowered DUT (.subckt buf_001_super_follower).
** PDK corner libs resolve by BARE NAME on the image's ngspice sourcepath — run in a
** PDK-enabled env (the base image / api container), NOT a bare host:
**   docker run --rm -i spicexplorer-spice-base:local \
**     bash -lc 'd=$(mktemp -d) && cat > $d/c.spice && cd $d && ngspice -b c.spice' < raw/buf_001_super_follower/sky130/dc_op.spice
*----------------------------------------------------------*
** params: 8 free + 6 frozen knobs (sizing.yaml) · 5 tied · 0 ratio-derived (abstract/params.yaml) · 3 testbench params
** AUTHORED TEMPLATE — buffer/dc_op: DC operating point + supply current.
** Class port convention: vdd vout vin ibias vss; `ibias` is SOURCE-referenced (the DUT holds an
** NMOS diode at ibias, the bench pushes IBIAS into it from vdd). The input sits at VCM.
** Bindings: DUT PORT_LINE VDD VCM IBIAS PDK_INCLUDE.
.lib sky130.lib.spice tt
.temp 27

.param VDD=1.5
.param VCM=1.05
.param IBIAS=10u

Vdd  vdd 0 dc {VDD}
Vss  vss 0 dc 0
Ibias vdd ibias dc {IBIAS}
Vin  vin 0 dc {VCM}

XDUT vdd vout vin ibias vss buf_001_super_follower

.control
  set filetype=ascii
  op
  let i_supply = abs(i(Vdd))
  let v_out = v(vout)
  let v_offset = v(vout) - v(vin)
  print i_supply v_out v_offset
  write
  quit
.endc
.param x_dut_xm1_w=8
.param x_dut_xm2_w=8
.param x_dut_xmrn_w=4
.param x_dut_xmpd_w=8
.param x_dut_xmpb_w=8
.param x_dut_xm1_l=0.3
.param x_dut_xmpd_l=0.3
.param x_cc=250e-15
.param x_dut_xm1_m=4
.param x_dut_xm2_m=4
.param x_dut_xmrn_m=1
.param x_dut_xmns_m=1
.param x_dut_xmpd_m=1
.param x_dut_xmpb_m=6
* ---- GENERATED parameter ties (abstract/params.yaml groups/ratios) ----
* Each tied symbol is defined exactly once, by its line below; rewrite that
* .param to untie just that symbol (untying = shadowing, plan D-3).
.param x_dut_xm2_l = {x_dut_xm1_l}
.param x_dut_xmrn_l = {x_dut_xm1_l}
.param x_dut_xmns_l = {x_dut_xm1_l}
.param x_dut_xmns_w = {x_dut_xmrn_w}
.param x_dut_xmpb_l = {x_dut_xmpd_l}
.subckt buf_001_super_follower vdd vout vin ibias vss
CC na vss x_cc
XM1 na vin vout vss sky130_fd_pr__nfet_01v8 l=x_dut_xm1_l m=x_dut_xm1_m w=x_dut_xm1_w
XM2 vout na vss vss sky130_fd_pr__nfet_01v8 l=x_dut_xm2_l m=x_dut_xm2_m w=x_dut_xm2_w
XMNS pd ibias vss vss sky130_fd_pr__nfet_01v8 l=x_dut_xmns_l m=x_dut_xmns_m w=x_dut_xmns_w
XMPB na pd vdd vdd sky130_fd_pr__pfet_01v8 l=x_dut_xmpb_l m=x_dut_xmpb_m w=x_dut_xmpb_w
XMPD pd pd vdd vdd sky130_fd_pr__pfet_01v8 l=x_dut_xmpd_l m=x_dut_xmpd_m w=x_dut_xmpd_w
XMRN ibias ibias vss vss sky130_fd_pr__nfet_01v8 l=x_dut_xmrn_l m=x_dut_xmrn_m w=x_dut_xmrn_w
.ends
.end
