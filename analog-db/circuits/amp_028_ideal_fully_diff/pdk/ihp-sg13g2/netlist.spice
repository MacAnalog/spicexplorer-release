** GENERATED by `analog-db generate` — DO NOT EDIT. Source: abstract/netlist.spice → ihp-sg13g2
* amp_028_ideal_fully_diff (emitted by spicexplorer-circuitgraph)
CIN vinp vinn 'cin_val'
COUT voutn voutp 'cout_val'
GM voutn voutp vinp vinn {gm_val}
RIN vinp vinn 'rin_val'
ROUT voutn voutp 'rout_val'
.end
