* TB[pam4] .op/.ac S22 sweep (ngspice-45)
Vcc vcc 0 DC 4
Vcasc vcasc 0 DC 3.25
Vcmb vcmb 0 DC 1.9
Vblsb blsb 0 DC 16
Vbmsb bmsb 0 DC 16
XDUT lsbp lsbn msbp msbn outp outn vcc vcasc vcmb blsb bmsb pam4drv_pam4
Vslsbp slsbp 0 DC 1.9
Vslsbn slsbn 0 DC 1.9
Rslsbp slsbp lsbp 50
Rslsbn slsbn lsbn 50
Vsmsbp smsbp 0 DC 1.9
Vsmsbn smsbn 0 DC 1.9
Rsmsbp smsbp msbp 50
Rsmsbn smsbn msbn 50
Vsop sop 0 DC 4 AC 0.5
Vson son 0 DC 4 AC -0.5
Rsop sop outp 50
Rson son outn 50
.include ../dut/dut_pam4.spice
.lib "cornerHBT.lib" hbt_typ
.options gmin=1e-12 reltol=1e-3
.control
op
ac dec 20 1e+08 1e+11
let vodiff = v(outp)-v(outn)
let zout = vodiff*100/(1-vodiff)
let s22db = db((zout-100)/(zout+100))
wrdata acs22.csv s22db
.endc
.GLOBAL GND
.end
