** GENERATED by `analog-db export-raw` — DO NOT EDIT.
** circuit=ia_006_fan_chopper_cmfb  class=ia  pdk=ihp-sg13g2  testbench=psrr_vdd_chop  corner=tt
** Self-contained deck: testbench + bound params + lowered DUT (.subckt ia_006_fan_chopper_cmfb).
** PDK corner libs resolve by BARE NAME on the image's ngspice sourcepath — run in a
** PDK-enabled env (the base image / api container), NOT a bare host:
**   docker run --rm -i spicexplorer-spice-base:local \
**     bash -lc 'd=$(mktemp -d) && cat > $d/c.spice && cd $d && ngspice -b c.spice' < raw/ia_006_fan_chopper_cmfb/ihp-sg13g2/psrr_vdd_chop.spice
*----------------------------------------------------------*
** params: 47 free + 19 frozen knobs (sizing.yaml) · 88 tied · 0 ratio-derived (abstract/params.yaml) · 7 testbench params
** AUTHORED TEMPLATE — ia/psrr_vdd_chopper_diff: positive-supply rejection of a chopper IA
** measured IN OPERATION (all chopper clocks RUNNING at FCHOP) via Spectre PSS+PAC. The twin
** of pac_gain_chopper_diff, with the small-signal excitation moved from the inputs to the
** SUPPLY: the periodic steady state pins the clocked operating point, and the periodic AC
** computes the baseband supply feed-through the signal band actually sees. This is the figure
** a static .ac on the frozen chopper CANNOT see — the chopper up-modulates the low-frequency
** supply-induced disturbance to FCHOP, so the BASEBAND (harmonic-0) response is what remains
** in-band.
**
** READ (registry, Spectre lane): the DIFFERENTIAL supply feed-through cancels on a symmetric
** netlist (matrix round-off), so the always-physical figure is the OUTPUT-CM response:
**   {meas: rejection_db, analysis: pac, out: vocm}  -> -dB20|vocm baseband transfer| = raw CM
**   supply rejection; the corrected PSRR adds the differential gain (dc_gain / gain_cl), the
**   same fold-in the FD static benches get. vocm is synthesized here by a 1 Gohm averager
**   (Ravp/Ravn) so it is a readable node without loading the outputs.
** ngspice lane: no PSS — the .control runs a frozen-clock .ac EYEBALL only (clocks at t=0).
**
** CM ANCHOR (RCM): identical rationale to pac_gain_chopper_diff — the no-CMFB core has no CM
** periodic steady state on its own, so RCM to vref pins the per-phase output CM and lets the
** chopped orbit close. It is a bench reference (a real CCIA gets it from its CMFB + next-stage
** load), NOT part of the DUT.
** Bindings: DUT PORT_LINE VDD VCM CL FCHOP TEDGE RCM FSTART FSTOP PPD PDK_INCLUDE.
.lib cornerMOSlv.lib mos_tt
.temp 27

.param VDD=1.2
.param VCM=0.6
.param CL=50f
.param FCHOP=5k
.param TCHOP={1/FCHOP}
.param TEDGE=50n
.param RCM=30k

* SUPPLY-ripple stimulus: the `ac 1` marker feeds BOTH lanes (ngspice .ac eyeball via mag=,
* Spectre pac via pacmag=), so the same deck drives either analysis.
Vdd  vdd 0 dc {VDD} ac 1
Vss  vss 0 dc 0
CLoadp voutp 0 {CL}
CLoadn voutn 0 {CL}
Vref vref 0 dc {VCM}
* bench-side output-CM anchor/load (see header): pins the per-phase output CM so the chopped
* orbit has a periodic steady state on the CMFB-less core.
Rcmp voutp vref {RCM}
Rcmn voutn vref {RCM}
Vcm  vcm 0 dc {VCM}
* signal inputs held QUIET at VCM — isolate the supply path
Vinp vinp vcm dc 0
Vinn vinn vcm dc 0
* differential + common-mode output sense nodes (high-Z, non-loading):
*   vout  = voutp - voutn        (differential; saturates on a symmetric deck)
*   vocm  = (voutp + voutn)/2    (the always-physical CM response)
Evd vout 0 voutp voutn 1
Ravp voutp vocm 1G
Ravn voutn vocm 1G

* chopper clocks: complementary pairs, all phases aligned at FCHOP (RUNNING — the pss
* fundamental; on the ngspice eyeball .ac they freeze at their t=0 values)
Vck_in_a  clk_chin      0 pulse(0 {VDD} 0 {TEDGE} {TEDGE} {TCHOP/2-TEDGE} {TCHOP})
Vck_in_b  clk_chin_not  0 pulse({VDD} 0 0 {TEDGE} {TEDGE} {TCHOP/2-TEDGE} {TCHOP})
Vck_fb_a  clk_chfb      0 pulse(0 {VDD} 0 {TEDGE} {TEDGE} {TCHOP/2-TEDGE} {TCHOP})
Vck_fb_b  clk_chfb_not  0 pulse({VDD} 0 0 {TEDGE} {TEDGE} {TCHOP/2-TEDGE} {TCHOP})
Vck_out_a clk_chout     0 pulse(0 {VDD} 0 {TEDGE} {TEDGE} {TCHOP/2-TEDGE} {TCHOP})
Vck_out_b clk_chout_not 0 pulse({VDD} 0 0 {TEDGE} {TEDGE} {TCHOP/2-TEDGE} {TCHOP})

XDUT vinp vinn voutp voutn vref clk_chin clk_chin_not clk_chfb clk_chfb_not clk_chout clk_chout_not vdd vss ia_006_fan_chopper_cmfb

.control
  set filetype=ascii
  * EYEBALL ONLY (frozen clocks — one chop phase); the golden number is Spectre PSS+PAC
  ac dec 8 1 2k
  write
  quit
.endc
.param x_dut_xm4_cmfb_w=1.42u
.param x_dut_xm4_cmfb_l=0.27u
.param x_dut_xm2_cmfb_w=2.32u
.param x_dut_xm2_cmfb_l=1.31u
.param x_dut_xm1_cmfb_w=0.329u
.param x_dut_xm7_cmfb_w=0.293u
.param x_dut_xm7_cmfb_l=0.22u
.param x_dut_xm3_cmfb_w=0.881u
.param x_dut_xm3_cmfb_l=0.259u
.param x_dut_rmp_cmfb_value=1Meg
.param x_dut_xm1_cmfb_m=1
.param x_dut_xm2_cmfb_m=1
.param x_dut_xm3_cmfb_m=1
.param x_dut_xm4_cmfb_m=1
.param x_dut_xm7_cmfb_m=1
.param x_dut_xm1_core_w=20u
.param x_dut_xm1_core_l=1u
.param x_dut_xm2_core_w=20u
.param x_dut_xm2_core_l=0.5u
.param x_dut_xm4_core_w=4.7u
.param x_dut_xm4_core_l=1u
.param x_dut_xm6_core_w=10u
.param x_dut_xm10_core_w=10u
.param x_dut_xm10_core_l=0.3u
.param x_dut_xm12_core_w=5u
.param x_dut_xm12_core_l=0.3u
.param x_dut_xm14_core_w=6u
.param x_dut_xm14_core_l=0.5u
.param x_dut_xm16_core_w=2u
.param x_dut_xm16_core_l=0.13u
.param x_dut_xm17_core_w=2u
.param x_dut_xm17_core_l=0.13u
.param x_dut_xm20_core_w=2u
.param x_dut_xm20_core_l=0.13u
.param x_dut_xm21_core_w=2u
.param x_dut_xm21_core_l=0.13u
.param x_dut_xm24_core_w=2u
.param x_dut_xm24_core_l=0.13u
.param x_dut_xm25_core_w=2u
.param x_dut_xm25_core_l=0.13u
.param x_dut_cin1_core_value=16p
.param x_dut_cfb1_core_value=0.8p
.param x_dut_cm1_core_value=1p
.param x_dut_rb1_core_value=10Meg
.param vb1_core=0.5
.param vb2_core=0.75
.param vb3_core=0.45
.param vb4_core=0.55
.param x_dut_xm1_core_m=1
.param x_dut_xm2_core_m=1
.param x_dut_xm4_core_m=1
.param x_dut_xm6_core_m=1
.param x_dut_xm10_core_m=1
.param x_dut_xm12_core_m=1
.param x_dut_xm14_core_m=1
.param x_dut_xm16_core_m=1
.param x_dut_xm17_core_m=1
.param x_dut_xm20_core_m=1
.param x_dut_xm21_core_m=1
.param x_dut_xm24_core_m=1
.param x_dut_xm25_core_m=1
.param vcm_ref=0.5
.param x_dut_xm8o_w=20u
.param x_dut_xm8o_l=1u
.param x_dut_xm8o_m=1
.param c_cm=1f
* ---- GENERATED parameter ties (abstract/params.yaml groups/ratios) ----
* Each tied symbol is defined exactly once, by its line below; rewrite that
* .param to untie just that symbol (untying = shadowing, plan D-3).
.param x_dut_xm9o_w = {x_dut_xm8o_w}
.param x_dut_xm9o_l = {x_dut_xm8o_l}
.param x_dut_xm9o_m = {x_dut_xm8o_m}
.param x_dut_xm5_cmfb_w = {x_dut_xm4_cmfb_w}
.param x_dut_xm5_cmfb_l = {x_dut_xm4_cmfb_l}
.param x_dut_xm5_cmfb_m = {x_dut_xm4_cmfb_m}
.param x_dut_xm6_cmfb_w = {x_dut_xm2_cmfb_w}
.param x_dut_xm6_cmfb_l = {x_dut_xm2_cmfb_l}
.param x_dut_xm6_cmfb_m = {x_dut_xm2_cmfb_m}
.param x_dut_rmn_cmfb_value = {x_dut_rmp_cmfb_value}
.param x_dut_xm3_core_w = {x_dut_xm2_core_w}
.param x_dut_xm3_core_l = {x_dut_xm2_core_l}
.param x_dut_xm3_core_m = {x_dut_xm2_core_m}
.param x_dut_xm5_core_w = {x_dut_xm4_core_w}
.param x_dut_xm5_core_l = {x_dut_xm4_core_l}
.param x_dut_xm5_core_m = {x_dut_xm4_core_m}
.param x_dut_xm13_core_w = {x_dut_xm12_core_w}
.param x_dut_xm13_core_l = {x_dut_xm12_core_l}
.param x_dut_xm13_core_m = {x_dut_xm12_core_m}
.param x_dut_xm11_core_w = {x_dut_xm10_core_w}
.param x_dut_xm11_core_l = {x_dut_xm10_core_l}
.param x_dut_xm11_core_m = {x_dut_xm10_core_m}
.param x_dut_xm7_core_w = {x_dut_xm6_core_w}
.param x_dut_xm7_core_m = {x_dut_xm6_core_m}
.param x_dut_xm6_core_l = {x_dut_xm1_core_l}
.param x_dut_xm7_core_l = {x_dut_xm1_core_l}
.param x_dut_xm15_core_w = {x_dut_xm14_core_w}
.param x_dut_xm15_core_l = {x_dut_xm14_core_l}
.param x_dut_xm15_core_m = {x_dut_xm14_core_m}
.param x_dut_xm18_core_w = {x_dut_xm16_core_w}
.param x_dut_xm28_core_w = {x_dut_xm16_core_w}
.param x_dut_xm30_core_w = {x_dut_xm16_core_w}
.param x_dut_xm18_core_l = {x_dut_xm16_core_l}
.param x_dut_xm28_core_l = {x_dut_xm16_core_l}
.param x_dut_xm30_core_l = {x_dut_xm16_core_l}
.param x_dut_xm18_core_m = {x_dut_xm16_core_m}
.param x_dut_xm28_core_m = {x_dut_xm16_core_m}
.param x_dut_xm30_core_m = {x_dut_xm16_core_m}
.param x_dut_xm19_core_w = {x_dut_xm17_core_w}
.param x_dut_xm29_core_w = {x_dut_xm17_core_w}
.param x_dut_xm31_core_w = {x_dut_xm17_core_w}
.param x_dut_xm19_core_l = {x_dut_xm17_core_l}
.param x_dut_xm29_core_l = {x_dut_xm17_core_l}
.param x_dut_xm31_core_l = {x_dut_xm17_core_l}
.param x_dut_xm19_core_m = {x_dut_xm17_core_m}
.param x_dut_xm29_core_m = {x_dut_xm17_core_m}
.param x_dut_xm31_core_m = {x_dut_xm17_core_m}
.param x_dut_xm26_core_w = {x_dut_xm24_core_w}
.param x_dut_xm32_core_w = {x_dut_xm24_core_w}
.param x_dut_xm34_core_w = {x_dut_xm24_core_w}
.param x_dut_xm26_core_l = {x_dut_xm24_core_l}
.param x_dut_xm32_core_l = {x_dut_xm24_core_l}
.param x_dut_xm34_core_l = {x_dut_xm24_core_l}
.param x_dut_xm26_core_m = {x_dut_xm24_core_m}
.param x_dut_xm32_core_m = {x_dut_xm24_core_m}
.param x_dut_xm34_core_m = {x_dut_xm24_core_m}
.param x_dut_xm27_core_w = {x_dut_xm25_core_w}
.param x_dut_xm33_core_w = {x_dut_xm25_core_w}
.param x_dut_xm35_core_w = {x_dut_xm25_core_w}
.param x_dut_xm27_core_l = {x_dut_xm25_core_l}
.param x_dut_xm33_core_l = {x_dut_xm25_core_l}
.param x_dut_xm35_core_l = {x_dut_xm25_core_l}
.param x_dut_xm27_core_m = {x_dut_xm25_core_m}
.param x_dut_xm33_core_m = {x_dut_xm25_core_m}
.param x_dut_xm35_core_m = {x_dut_xm25_core_m}
.param x_dut_xm22_core_w = {x_dut_xm20_core_w}
.param x_dut_xm36_core_w = {x_dut_xm20_core_w}
.param x_dut_xm38_core_w = {x_dut_xm20_core_w}
.param x_dut_xm22_core_l = {x_dut_xm20_core_l}
.param x_dut_xm36_core_l = {x_dut_xm20_core_l}
.param x_dut_xm38_core_l = {x_dut_xm20_core_l}
.param x_dut_xm22_core_m = {x_dut_xm20_core_m}
.param x_dut_xm36_core_m = {x_dut_xm20_core_m}
.param x_dut_xm38_core_m = {x_dut_xm20_core_m}
.param x_dut_xm23_core_w = {x_dut_xm21_core_w}
.param x_dut_xm37_core_w = {x_dut_xm21_core_w}
.param x_dut_xm39_core_w = {x_dut_xm21_core_w}
.param x_dut_xm23_core_l = {x_dut_xm21_core_l}
.param x_dut_xm37_core_l = {x_dut_xm21_core_l}
.param x_dut_xm39_core_l = {x_dut_xm21_core_l}
.param x_dut_xm23_core_m = {x_dut_xm21_core_m}
.param x_dut_xm37_core_m = {x_dut_xm21_core_m}
.param x_dut_xm39_core_m = {x_dut_xm21_core_m}
.param x_dut_cin2_core_value = {x_dut_cin1_core_value}
.param x_dut_cfb2_core_value = {x_dut_cfb1_core_value}
.param x_dut_cm2_core_value = {x_dut_cm1_core_value}
.param x_dut_rb2_core_value = {x_dut_rb1_core_value}
.param x_dut_xm1_cmfb_l = {x_dut_xm3_cmfb_l}
.param x_dut_xm30_core_w = {x_dut_xm16_core_w}
.param x_dut_xm30_core_l = {x_dut_xm16_core_l}
.param x_dut_xm30_core_m = {x_dut_xm16_core_m}
.param x_dut_xm29_core_w = {x_dut_xm17_core_w}
.param x_dut_xm29_core_l = {x_dut_xm17_core_l}
.param x_dut_xm29_core_m = {x_dut_xm17_core_m}
.param x_dut_xm28_core_w = {x_dut_xm18_core_w}
.param x_dut_xm28_core_l = {x_dut_xm18_core_l}
.param x_dut_xm28_core_m = {x_dut_xm18_core_m}
.param x_dut_xm31_core_w = {x_dut_xm19_core_w}
.param x_dut_xm31_core_l = {x_dut_xm19_core_l}
.param x_dut_xm31_core_m = {x_dut_xm19_core_m}
.param x_dut_xm38_core_w = {x_dut_xm20_core_w}
.param x_dut_xm38_core_l = {x_dut_xm20_core_l}
.param x_dut_xm38_core_m = {x_dut_xm20_core_m}
.param x_dut_xm37_core_w = {x_dut_xm21_core_w}
.param x_dut_xm37_core_l = {x_dut_xm21_core_l}
.param x_dut_xm37_core_m = {x_dut_xm21_core_m}
.param x_dut_xm36_core_w = {x_dut_xm22_core_w}
.param x_dut_xm36_core_l = {x_dut_xm22_core_l}
.param x_dut_xm36_core_m = {x_dut_xm22_core_m}
.param x_dut_xm39_core_w = {x_dut_xm23_core_w}
.param x_dut_xm39_core_l = {x_dut_xm23_core_l}
.param x_dut_xm39_core_m = {x_dut_xm23_core_m}
.param x_dut_xm34_core_w = {x_dut_xm24_core_w}
.param x_dut_xm34_core_l = {x_dut_xm24_core_l}
.param x_dut_xm34_core_m = {x_dut_xm24_core_m}
.param x_dut_xm33_core_w = {x_dut_xm25_core_w}
.param x_dut_xm33_core_l = {x_dut_xm25_core_l}
.param x_dut_xm33_core_m = {x_dut_xm25_core_m}
.param x_dut_xm32_core_w = {x_dut_xm26_core_w}
.param x_dut_xm32_core_l = {x_dut_xm26_core_l}
.param x_dut_xm32_core_m = {x_dut_xm26_core_m}
.param x_dut_xm35_core_w = {x_dut_xm27_core_w}
.param x_dut_xm35_core_l = {x_dut_xm27_core_l}
.param x_dut_xm35_core_m = {x_dut_xm27_core_m}
.subckt ia_006_fan_chopper_cmfb vinp vinn voutp voutn vref clk_chin clk_chin_not clk_chfb clk_chfb_not clk_chout clk_chout_not vdd vss
CCM vb4o vss 'c_cm'
CFB1_CORE core__fbch_p core__vsum_n 'x_dut_cfb1_core_value'
CFB2_CORE core__fbch_n core__vsum_p 'x_dut_cfb2_core_value'
CIN1_CORE core__vsum_n core__inch_n 'x_dut_cin1_core_value'
CIN2_CORE core__vsum_p core__inch_p 'x_dut_cin2_core_value'
CM1_CORE core__g2_p voutp 'x_dut_cm1_core_value'
CM2_CORE core__g2_n voutn 'x_dut_cm2_core_value'
RB1_CORE core__vsum_n vref 'x_dut_rb1_core_value'
RB2_CORE core__vsum_p vref 'x_dut_rb2_core_value'
RMN_CMFB voutn cmfb__cm_sense 'x_dut_rmn_cmfb_value'
RMP_CMFB cmfb__cm_sense voutp 'x_dut_rmp_cmfb_value'
VB1_CORE core__vb1 vss dc {vb1_core}
VB2_CORE core__vb2 vss dc {vb2_core}
VB3_CORE core__vb3 vss dc {vb3_core}
VB4_CORE core__vb4 vss dc {vb4_core}
VREFCM vref_cm vss dc {vcm_ref}
XM10_CORE core__out1_n core__vb3 core__casc_src_n vdd sg13_lv_pmos l=x_dut_xm10_core_l m=x_dut_xm10_core_m w=x_dut_xm10_core_w
XM11_CORE core__out1_p core__vb3 core__casc_src_p vdd sg13_lv_pmos l=x_dut_xm11_core_l m=x_dut_xm11_core_m w=x_dut_xm11_core_w
XM12_CORE core__out1_p core__vb2 core__fold_p vss sg13_lv_nmos l=x_dut_xm12_core_l m=x_dut_xm12_core_m w=x_dut_xm12_core_w
XM13_CORE core__out1_n core__vb2 core__fold_n vss sg13_lv_nmos l=x_dut_xm13_core_l m=x_dut_xm13_core_m w=x_dut_xm13_core_w
XM14_CORE voutp core__g2_p vss vss sg13_lv_nmos l=x_dut_xm14_core_l m=x_dut_xm14_core_m w=x_dut_xm14_core_w
XM15_CORE voutn core__g2_n vss vss sg13_lv_nmos l=x_dut_xm15_core_l m=x_dut_xm15_core_m w=x_dut_xm15_core_w
XM16_CORE core__out1_n clk_chout core__g2_n vss sg13_lv_nmos l=x_dut_xm16_core_l m=x_dut_xm16_core_m w=x_dut_xm16_core_w
XM17_CORE core__g2_n clk_chout_not core__out1_n vdd sg13_lv_pmos l=x_dut_xm17_core_l m=x_dut_xm17_core_m w=x_dut_xm17_core_w
XM18_CORE core__out1_p clk_chout core__g2_p vss sg13_lv_nmos l=x_dut_xm18_core_l m=x_dut_xm18_core_m w=x_dut_xm18_core_w
XM19_CORE core__g2_p clk_chout_not core__out1_p vdd sg13_lv_pmos l=x_dut_xm19_core_l m=x_dut_xm19_core_m w=x_dut_xm19_core_w
XM1_CMFB cmfb__ptail cmfb__bias vdd vdd sg13_lv_pmos l=x_dut_xm1_cmfb_l m=x_dut_xm1_cmfb_m w=x_dut_xm1_cmfb_w
XM1_CORE core__tail core__vb4 vdd vdd sg13_lv_pmos l=x_dut_xm1_core_l m=x_dut_xm1_core_m w=x_dut_xm1_core_w
XM20_CORE core__fbch_p clk_chfb voutp vss sg13_lv_nmos l=x_dut_xm20_core_l m=x_dut_xm20_core_m w=x_dut_xm20_core_w
XM21_CORE voutp clk_chfb_not core__fbch_p vdd sg13_lv_pmos l=x_dut_xm21_core_l m=x_dut_xm21_core_m w=x_dut_xm21_core_w
XM22_CORE core__fbch_n clk_chfb voutn vss sg13_lv_nmos l=x_dut_xm22_core_l m=x_dut_xm22_core_m w=x_dut_xm22_core_w
XM23_CORE voutn clk_chfb_not core__fbch_n vdd sg13_lv_pmos l=x_dut_xm23_core_l m=x_dut_xm23_core_m w=x_dut_xm23_core_w
XM24_CORE vinn clk_chin core__inch_n vss sg13_lv_nmos l=x_dut_xm24_core_l m=x_dut_xm24_core_m w=x_dut_xm24_core_w
XM25_CORE core__inch_n clk_chin_not vinn vdd sg13_lv_pmos l=x_dut_xm25_core_l m=x_dut_xm25_core_m w=x_dut_xm25_core_w
XM26_CORE vinp clk_chin core__inch_p vss sg13_lv_nmos l=x_dut_xm26_core_l m=x_dut_xm26_core_m w=x_dut_xm26_core_w
XM27_CORE core__inch_p clk_chin_not vinp vdd sg13_lv_pmos l=x_dut_xm27_core_l m=x_dut_xm27_core_m w=x_dut_xm27_core_w
XM28_CORE core__out1_n clk_chout_not core__g2_p vss sg13_lv_nmos l=x_dut_xm28_core_l m=x_dut_xm28_core_m w=x_dut_xm28_core_w
XM29_CORE core__g2_p clk_chout core__out1_n vdd sg13_lv_pmos l=x_dut_xm29_core_l m=x_dut_xm29_core_m w=x_dut_xm29_core_w
XM2_CMFB vb4o cmfb__mirr vss vss sg13_lv_nmos l=x_dut_xm2_cmfb_l m=x_dut_xm2_cmfb_m w=x_dut_xm2_cmfb_w
XM2_CORE core__fold_p core__vsum_p core__tail vdd sg13_lv_pmos l=x_dut_xm2_core_l m=x_dut_xm2_core_m w=x_dut_xm2_core_w
XM30_CORE core__out1_p clk_chout_not core__g2_n vss sg13_lv_nmos l=x_dut_xm30_core_l m=x_dut_xm30_core_m w=x_dut_xm30_core_w
XM31_CORE core__g2_n clk_chout core__out1_p vdd sg13_lv_pmos l=x_dut_xm31_core_l m=x_dut_xm31_core_m w=x_dut_xm31_core_w
XM32_CORE vinn clk_chin_not core__inch_p vss sg13_lv_nmos l=x_dut_xm32_core_l m=x_dut_xm32_core_m w=x_dut_xm32_core_w
XM33_CORE core__inch_p clk_chin vinn vdd sg13_lv_pmos l=x_dut_xm33_core_l m=x_dut_xm33_core_m w=x_dut_xm33_core_w
XM34_CORE vinp clk_chin_not core__inch_n vss sg13_lv_nmos l=x_dut_xm34_core_l m=x_dut_xm34_core_m w=x_dut_xm34_core_w
XM35_CORE core__inch_n clk_chin vinp vdd sg13_lv_pmos l=x_dut_xm35_core_l m=x_dut_xm35_core_m w=x_dut_xm35_core_w
XM36_CORE core__fbch_p clk_chfb_not voutn vss sg13_lv_nmos l=x_dut_xm36_core_l m=x_dut_xm36_core_m w=x_dut_xm36_core_w
XM37_CORE voutn clk_chfb core__fbch_p vdd sg13_lv_pmos l=x_dut_xm37_core_l m=x_dut_xm37_core_m w=x_dut_xm37_core_w
XM38_CORE core__fbch_n clk_chfb_not voutp vss sg13_lv_nmos l=x_dut_xm38_core_l m=x_dut_xm38_core_m w=x_dut_xm38_core_w
XM39_CORE voutp clk_chfb core__fbch_n vdd sg13_lv_pmos l=x_dut_xm39_core_l m=x_dut_xm39_core_m w=x_dut_xm39_core_w
XM3_CMFB cmfb__bias cmfb__bias vdd vdd sg13_lv_pmos l=x_dut_xm3_cmfb_l m=x_dut_xm3_cmfb_m w=x_dut_xm3_cmfb_w
XM3_CORE core__fold_n core__vsum_n core__tail vdd sg13_lv_pmos l=x_dut_xm3_core_l m=x_dut_xm3_core_m w=x_dut_xm3_core_w
XM4_CMFB cmfb__mirr cmfb__cm_sense cmfb__ptail vdd sg13_lv_pmos l=x_dut_xm4_cmfb_l m=x_dut_xm4_cmfb_m w=x_dut_xm4_cmfb_w
XM4_CORE core__fold_p core__vb1 vss vss sg13_lv_nmos l=x_dut_xm4_core_l m=x_dut_xm4_core_m w=x_dut_xm4_core_w
XM5_CMFB vb4o vref_cm cmfb__ptail vdd sg13_lv_pmos l=x_dut_xm5_cmfb_l m=x_dut_xm5_cmfb_m w=x_dut_xm5_cmfb_w
XM5_CORE core__fold_n core__vb1 vss vss sg13_lv_nmos l=x_dut_xm5_core_l m=x_dut_xm5_core_m w=x_dut_xm5_core_w
XM6_CMFB cmfb__mirr cmfb__mirr vss vss sg13_lv_nmos l=x_dut_xm6_cmfb_l m=x_dut_xm6_cmfb_m w=x_dut_xm6_cmfb_w
XM6_CORE core__casc_src_n core__vb4 vdd vdd sg13_lv_pmos l=x_dut_xm6_core_l m=x_dut_xm6_core_m w=x_dut_xm6_core_w
XM7_CMFB cmfb__bias cmfb__bias vss vss sg13_lv_nmos l=x_dut_xm7_cmfb_l m=x_dut_xm7_cmfb_m w=x_dut_xm7_cmfb_w
XM7_CORE core__casc_src_p core__vb4 vdd vdd sg13_lv_pmos l=x_dut_xm7_core_l m=x_dut_xm7_core_m w=x_dut_xm7_core_w
XM8O voutp vb4o vdd vdd sg13_lv_pmos l=x_dut_xm8o_l m=x_dut_xm8o_m w=x_dut_xm8o_w
XM9O voutn vb4o vdd vdd sg13_lv_pmos l=x_dut_xm9o_l m=x_dut_xm9o_m w=x_dut_xm9o_w
.ends
.end
