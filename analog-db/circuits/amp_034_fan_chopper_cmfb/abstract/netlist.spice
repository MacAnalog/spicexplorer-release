** GENERATED by `analog-db generate` — DO NOT EDIT. Source: composition.yaml (composer, plan P4)
** Composite: amp_034_fan_chopper_cmfb = cmfb(cmfb_002_5t_pmos_input @ cf3a412052ba) + core(amp_026_fan_chopper_ota @ 43c5f13906fb)
** CM closure of amp_026_fan_chopper_ota with a REAL 5T CMFB (cmfb_002_5t_pmos_input), not the behavioral servo amp_030 uses.
** ACTUATOR CHOICE — measured, not assumed. Run open-loop on the sized ihp-sg13g2 core (the amplifier/dc_cmfb_plant_sign math: sweep the candidate actuation node, read vocm), the two candidates give OPPOSITE plant parity:
**   * whole {vb4} tree (tail XM1 + fold sources XM6/XM7 + output sources XM8/XM9):
**     cm_plant_delta = +1.19 V -> NON-inverting plant. Raising vb4 starves the fold
**     load, so out1 collapses and the INVERTING stage 2 drives vocm UP; that stage-1
**     path outguns the direct gm8*rout2 term. A non-inverting plant needs the -inv
**     servo, which is not accessioned (it exists only as a drawings/shared wiring
**     variant). It also modulates the tail, i.e. the input-pair gm, with the CM
**     correction.
**   * output sources XM8/XM9 ALONE, on a split gate node vb4o:
**     cm_plant_delta = -1.06 V -> INVERTING plant, monotonic, balance gate
**     vcmfb_bal ~ 0.55-0.57 V over vocm in [0.45, 0.65] and an achievable output-CM
**     window [0.00, 1.12] V. That is exactly the plant the CANONICAL cmfb_00x blocks
**     (vcmfb = A*(cm_sense - vref)) drive.
** So the composite OMITs XM8/XM9 from the core instance and re-instantiates them itself on vb4o (plan D3 "instantiator owns bias", one level deeper: the class-A output current sources ARE the CM actuator). The core keeps its own {vb4} for XM1/XM6/XM7, so the CM loop never touches the differential gm.
** FLAVOR CHOICE — cmfb_002 (PMOS-input) over cmfb_003 (NMOS-input). Both are canonical polarity, so parity does not decide it; the committed dc_cmfb_transfer baselines at the blocks' validated vref = 0.5 V do:
**   slope 17.7 vs 11.1 V/V | gain_servo 25.2 vs 21.2 dB | vcmfb_max 1.200 vs 0.896 V |
**   vcmfb_nat 0.279 vs 0.251 V | r_sense_in 4.2e11 vs 9.4e10 Ohm.
** The actuator is a PMOS current-source gate that must be able to ride UP toward vdd to starve the output branch on a CM excursion: cmfb_002 reaches the rail, cmfb_003 tops out at 0.896 V. It also has the higher slope (hence the smaller static CM error (vcmfb_bal - vcmfb_nat)/slope ~ 16 mV vs ~28 mV), the higher loop gain, and the lighter load on the sensed outputs. The SRMC consumer (amp_031) picked the same flavor for a different plant; the two choices are not in tension — the rule is plant-specific.
** OPERATING POINT — vcm_ref defaults to 0.5 V, NOT the 0.6 V the core's other benches use for the INPUT common mode. Re-running both blocks' dc_cmfb_transfer at vref = 0.6 collapses them at their committed (SRMC-campaign) sizing: cmfb_002's PMOS pair runs out of tail headroom (slope 17.7 -> 0.20, gain 25.2 -> -13.9 dB) and cmfb_003's output can no longer reach past 0.197 V. 0.5 V is the sizing these blocks were validated at, and the core's plant reaches it comfortably (vb4o_bal 0.5635 V, mid-rail). Commanding 0.6 V needs a CMFB re-size, which is a sizing campaign, not a composition.
** LOOP SIGN: vocm UP -> cm_sense UP -> vcmfb = A*(cm_sense - vref) UP -> vb4o UP -> XM8/XM9 |Vsg| DOWN -> output pull-up current DOWN -> vocm DOWN. NEGATIVE feedback. No range-referencing level shift is needed (amp_030 needed one only because its behavioral servo was unclamped and saturated to +600 V); a real 5T error amp is rail-clamped by construction, so vb4o is driven directly. ACCEPTANCE: dc_cm_bias_sweep over the composite-owned {vcm_ref} must measure cm_interior_pts = 5 (the output CM tracks the command), and cmrr_cm_corr_db / psrr_cm_corr_db must clear amp_026's +10.4 / -2.4 dB by the CM loop gain.
** COMPENSATION ({c_cm} on vb4o) — a REQUIREMENT that emerged from measurement, not a trim. The 2026-08-05 role-based gm/ID re-size of cmfb_002's FOUNDRY-n65 binding raised the CM loop gain ~8.7x (static CM error 33.6 -> 3.9 mV, servo current 54 -> 9 uA) and that gain made the loop OSCILLATE: 70 mV p-p on vocm, undecayed across every octant of the 20 us tran window — including 0-2 us, BEFORE the disturbance is applied. dc_op (vocm 0.60389) and ac_open_loop (57.8 dB / 6.49 MHz / 36.7 deg) both reported a clean operating point the circuit cannot hold, which is exactly the trap amp_035 documented: *AC rejection figures are meaningless until a transient proves the point is dynamically stable*. 1p is the stability knee (p2p decays to 0.02 mV by 17 us); the committed 5p is ~5x past it and settles FASTER than the uncompensated carry-over did (t_cm_settle 0.41 vs 0.91 us). ihp-sg13g2 keeps c_cm = 1f (OFF): its CMFB sizing is low-gain enough (slope 17.7, static error 14.5 mV) to be damped on its own — verified unchanged.
**.subckt amp_034_fan_chopper_cmfb vinp vinn voutp voutn vdd vss
* --- instance cmfb: cmfb_002_5t_pmos_input @ cf3a412052ba ---
RMP_CMFB cmfb__cm_sense voutp 'x_dut_rmp_cmfb_value'
RMN_CMFB voutn cmfb__cm_sense 'x_dut_rmn_cmfb_value'
XM1_CMFB cmfb__ptail cmfb__bias vdd vdd pmos l=x_dut_xm1_cmfb_l m=x_dut_xm1_cmfb_m w=x_dut_xm1_cmfb_w
XM2_CMFB vb4o cmfb__mirr vss vss nmos l=x_dut_xm2_cmfb_l m=x_dut_xm2_cmfb_m w=x_dut_xm2_cmfb_w
XM3_CMFB cmfb__bias cmfb__bias vdd vdd pmos l=x_dut_xm3_cmfb_l m=x_dut_xm3_cmfb_m w=x_dut_xm3_cmfb_w
XM4_CMFB cmfb__mirr cmfb__cm_sense cmfb__ptail vdd pmos l=x_dut_xm4_cmfb_l m=x_dut_xm4_cmfb_m w=x_dut_xm4_cmfb_w
XM5_CMFB vb4o vref_cm cmfb__ptail vdd pmos l=x_dut_xm5_cmfb_l m=x_dut_xm5_cmfb_m w=x_dut_xm5_cmfb_w
XM6_CMFB cmfb__mirr cmfb__mirr vss vss nmos l=x_dut_xm6_cmfb_l m=x_dut_xm6_cmfb_m w=x_dut_xm6_cmfb_w
XM7_CMFB cmfb__bias cmfb__bias vss vss nmos l=x_dut_xm7_cmfb_l m=x_dut_xm7_cmfb_m w=x_dut_xm7_cmfb_w
* --- instance core: amp_026_fan_chopper_ota @ 43c5f13906fb (omit: XM8, XM9) ---
XM1_CORE core__tail core__vb4 vdd vdd pmos w=x_dut_xm1_core_w l=x_dut_xm1_core_l m=x_dut_xm1_core_m
XM2_CORE core__fold_p vinp core__tail vdd pmos w=x_dut_xm2_core_w l=x_dut_xm2_core_l m=x_dut_xm2_core_m
XM3_CORE core__fold_n vinn core__tail vdd pmos w=x_dut_xm3_core_w l=x_dut_xm3_core_l m=x_dut_xm3_core_m
XM4_CORE core__fold_p core__vb1 vss vss nmos w=x_dut_xm4_core_w l=x_dut_xm4_core_l m=x_dut_xm4_core_m
XM5_CORE core__fold_n core__vb1 vss vss nmos w=x_dut_xm5_core_w l=x_dut_xm5_core_l m=x_dut_xm5_core_m
XM12_CORE core__out1_p core__vb2 core__fold_p vss nmos w=x_dut_xm12_core_w l=x_dut_xm12_core_l m=x_dut_xm12_core_m
XM13_CORE core__out1_n core__vb2 core__fold_n vss nmos w=x_dut_xm13_core_w l=x_dut_xm13_core_l m=x_dut_xm13_core_m
XM6_CORE core__casc_src_n core__vb4 vdd vdd pmos w=x_dut_xm6_core_w l=x_dut_xm6_core_l m=x_dut_xm6_core_m
XM7_CORE core__casc_src_p core__vb4 vdd vdd pmos w=x_dut_xm7_core_w l=x_dut_xm7_core_l m=x_dut_xm7_core_m
XM10_CORE core__out1_n core__vb3 core__casc_src_n vdd pmos w=x_dut_xm10_core_w l=x_dut_xm10_core_l m=x_dut_xm10_core_m
XM11_CORE core__out1_p core__vb3 core__casc_src_p vdd pmos w=x_dut_xm11_core_w l=x_dut_xm11_core_l m=x_dut_xm11_core_m
XM16_CORE core__out1_n vdd core__g2_n vss nmos w=x_dut_xm16_core_w l=x_dut_xm16_core_l m=x_dut_xm16_core_m
XM17_CORE core__g2_n vss core__out1_n vdd pmos w=x_dut_xm17_core_w l=x_dut_xm17_core_l m=x_dut_xm17_core_m
XM18_CORE core__out1_p vdd core__g2_p vss nmos w=x_dut_xm18_core_w l=x_dut_xm18_core_l m=x_dut_xm18_core_m
XM19_CORE core__g2_p vss core__out1_p vdd pmos w=x_dut_xm19_core_w l=x_dut_xm19_core_l m=x_dut_xm19_core_m
XM20_CORE core__out1_p vss core__g2_n vss nmos w=x_dut_xm20_core_w l=x_dut_xm20_core_l m=x_dut_xm20_core_m
XM21_CORE core__g2_n vdd core__out1_p vdd pmos w=x_dut_xm21_core_w l=x_dut_xm21_core_l m=x_dut_xm21_core_m
XM22_CORE core__out1_n vss core__g2_p vss nmos w=x_dut_xm22_core_w l=x_dut_xm22_core_l m=x_dut_xm22_core_m
XM23_CORE core__g2_p vdd core__out1_n vdd pmos w=x_dut_xm23_core_w l=x_dut_xm23_core_l m=x_dut_xm23_core_m
XM14_CORE voutp core__g2_p vss vss nmos w=x_dut_xm14_core_w l=x_dut_xm14_core_l m=x_dut_xm14_core_m
XM15_CORE voutn core__g2_n vss vss nmos w=x_dut_xm15_core_w l=x_dut_xm15_core_l m=x_dut_xm15_core_m
Cm1_CORE core__g2_p voutp 'x_dut_cm1_core_value'
Cm2_CORE core__g2_n voutn 'x_dut_cm2_core_value'
Vb1_CORE core__vb1 vss dc {vb1_core}
Vb2_CORE core__vb2 vss dc {vb2_core}
Vb3_CORE core__vb3 vss dc {vb3_core}
Vb4_CORE core__vb4 vss dc {vb4_core}
* --- composite-owned nets ---
Vrefcm vref_cm vss dc {vcm_ref}
XM8O voutp vb4o vdd vdd pmos w=x_dut_xm8o_w l=x_dut_xm8o_l m=x_dut_xm8o_m
XM9O voutn vb4o vdd vdd pmos w=x_dut_xm9o_w l=x_dut_xm9o_l m=x_dut_xm9o_m
Ccm vb4o vss 'c_cm'
**.ends
.end
