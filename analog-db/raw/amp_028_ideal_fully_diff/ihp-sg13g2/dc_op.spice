** GENERATED by `analog-db export-raw` — DO NOT EDIT.
** circuit=amp_028_ideal_fully_diff  class=amplifier  pdk=ihp-sg13g2  testbench=dc_op  corner=tt
** Self-contained deck: testbench + bound params + lowered DUT (.subckt amp_028_ideal_fully_diff).
** PDK corner libs resolve by BARE NAME on the image's ngspice sourcepath — run in a
** PDK-enabled env (the base image / api container), NOT a bare host:
**   docker run --rm -i spicexplorer-spice-base:local \
**     bash -lc 'd=$(mktemp -d) && cat > $d/c.spice && cd $d && ngspice -b c.spice' < raw/amp_028_ideal_fully_diff/ihp-sg13g2/dc_op.spice
*----------------------------------------------------------*
** params: 5 free + 0 frozen knobs (sizing.yaml) · 0 tied · 0 ratio-derived (abstract/params.yaml) · 2 testbench params
** AUTHORED TEMPLATE — amplifier/dc_op_diff (self-biased, differential-output DC op point).
** DC operating point for a DUT with no external ibias port and a true differential output
** (voutp/voutn): supply current + the achieved output offset/common-mode. Matched inputs
** (vinp=vinn=VCM) into a symmetric FD topology give a well-defined offset regardless of
** open-loop gain (see ac_open_loop_diff.spice) — no bias-wrap/loop-closing needed. The
** output COMMON MODE (vocm) is a sizing concern (stage-2 pull-up vs. pull-down balance),
** which is exactly what this analysis exists to surface.
**
** Assumes a self-biased, differential-output DUT port order:
**   .subckt <id> vinp vinn voutp voutn vdd vss
** Required bindings: DUT PORT_LINE VDD VCM PDK_INCLUDE.
.lib cornerMOSlv.lib mos_tt
.temp 27

.param VDD=1.2
.param VCM=0.6

Vdd  vdd 0 dc {VDD}
Vss  vss 0 dc 0
Vcm  vcm 0 dc {VCM}
Vinp vinp vcm dc 0
Vinn vinn vcm dc 0

XDUT vinp vinn voutp voutn vdd vss amp_028_ideal_fully_diff

.control
  set filetype=ascii
  op
  let i_supply = abs(i(Vdd))
  * vos = output offset (voutp - voutn at matched inputs, ideally ~0)
  let vos = v(voutp) - v(voutn)
  * vocm = achieved output common mode (diagnostic — not a formal datasheet metric)
  let vocm = (v(voutp) + v(voutn))/2
  print i_supply vos vocm
  write
  quit
.endc
.param gm_val=100u
.param rout_val=10Meg
.param rin_val=1e12
.param cout_val=1p
.param cin_val=10f
.subckt amp_028_ideal_fully_diff vinp vinn voutp voutn vdd vss
CIN vinp vinn 'cin_val'
COUT voutn voutp 'cout_val'
GM voutn voutp vinp vinn {gm_val}
RIN vinp vinn 'rin_val'
ROUT voutn voutp 'rout_val'
.ends
.end
