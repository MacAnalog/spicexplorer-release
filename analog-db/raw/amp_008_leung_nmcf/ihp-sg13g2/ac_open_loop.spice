** GENERATED by `analog-db export-raw` — DO NOT EDIT.
** circuit=amp_008_leung_nmcf  class=amplifier  pdk=ihp-sg13g2  testbench=ac_open_loop  corner=tt
** Self-contained deck: testbench + bound params + lowered DUT (.subckt amp_008_leung_nmcf).
** PDK corner libs resolve by BARE NAME on the image's ngspice sourcepath — run in a
** PDK-enabled env (the base image / api container), NOT a bare host:
**   docker run --rm -i spicexplorer-spice-base:local \
**     bash -lc 'd=$(mktemp -d) && cat > $d/c.spice && cd $d && ngspice -b c.spice' < raw/amp_008_leung_nmcf/ihp-sg13g2/ac_open_loop.spice
*----------------------------------------------------------*
** params: 24 free + 0 frozen knobs (sizing.yaml) · 36 tied · 15 ratio-derived (abstract/params.yaml) · 3 testbench params
** AUTHORED TEMPLATE — amplifier/ac_open_loop_biaswrap (plan D-4; the AnalogGym bias-wrap).
** Open-loop gain measured in closed-loop bias (analoggym-amplifiers skill §5): a 1 TH inductor
** DC-shorts the output back to the inverting input — setting the high-gain operating point —
** while a 1 TF cap AC-opens that feedback and injects the AC input. This is the only way a
** high-gain 3-stage amp biases stably while still exposing its open-loop AC response.
**
** Assumes the AnalogGym canonical DUT port order (self-biased; NO ibias port):
**   .subckt <id> vss vdd vinn vinp vout
** Bindings: DUT VDD VCM CL FSTART FSTOP PPD PDK_INCLUDE.
.lib cornerMOSlv.lib mos_tt
.temp 27

.param VDD=1.8
.param VCM=300m
.param CL=10p

Vdd  vdd 0 dc {VDD}
Vcm  opin 0 dc {VCM}          ; common-mode bias on the non-inverting input
Vac  sigin 0 dc 0 ac 1        ; AC stimulus
Lfb  opout opout_dc 1T        ; 1 TH: DC short (bias), AC open
Cin  opout_dc sigin 1T        ; 1 TF: DC open, AC inject into the inverting node
CLoad opout 0 {CL}

* DUT: ports vss vdd vinn vinp vout — vinn=opout_dc (feedback), vinp=opin (CM), vout=opout
X1 0 vdd opout_dc opin opout amp_008_leung_nmcf

.control
  set filetype=ascii
  ac dec 50 0.1 1G
  meas ac dcgain FIND vdb(opout) AT=0.1
  meas ac ugf    WHEN vdb(opout)=0 FALL=1
  let phc = cph(opout)*180/3.14159265
  let ph  = 180 + phc - phc[0]
  meas ac pm     FIND ph WHEN vdb(opout)=0 FALL=1
  write
  quit
.endc
.param CAPACITOR_0=5p
.param CAPACITOR_1=3p
.param CURRENT_0_BIAS=20u
.param x_dut_xm7_l=1u
.param x_dut_xm7_m=4
.param x_dut_xm7_w=1u
.param x_dut_xm10_l=1u
.param x_dut_xm10_m=4
.param x_dut_xm10_w=1u
.param x_dut_xm11_l=1u
.param x_dut_xm11_m=4
.param x_dut_xm11_w=1u
.param x_dut_xm14_l=1u
.param x_dut_xm14_m=4
.param x_dut_xm14_w=1u
.param x_dut_xm21_l=1u
.param x_dut_xm21_m=4
.param x_dut_xm21_w=1u
.param x_dut_xm23_l=1u
.param x_dut_xm23_m=4
.param x_dut_xm23_w=1u
.param x_dut_xm9_l=1u
.param x_dut_xm9_m=4
.param x_dut_xm9_w=1u
* ---- GENERATED parameter ties (abstract/params.yaml groups/ratios) ----
* Each tied symbol is defined exactly once, by its line below; rewrite that
* .param to untie just that symbol (untying = shadowing, plan D-3).
.param x_dut_xm6_w = {x_dut_xm7_w}
.param x_dut_xm5_w = {x_dut_xm7_w}
.param x_dut_xm4_w = {x_dut_xm7_w}
.param x_dut_xm3_w = {x_dut_xm7_w}
.param x_dut_xm2_w = {x_dut_xm7_w}
.param x_dut_xm1_w = {x_dut_xm7_w}
.param x_dut_xm0_w = {x_dut_xm7_w}
.param x_dut_xm6_l = {x_dut_xm7_l}
.param x_dut_xm5_l = {x_dut_xm7_l}
.param x_dut_xm4_l = {x_dut_xm7_l}
.param x_dut_xm3_l = {x_dut_xm7_l}
.param x_dut_xm2_l = {x_dut_xm7_l}
.param x_dut_xm1_l = {x_dut_xm7_l}
.param x_dut_xm0_l = {x_dut_xm7_l}
.param x_dut_xm8_w = {x_dut_xm9_w}
.param x_dut_xm8_l = {x_dut_xm9_l}
.param x_dut_xm8_m = {x_dut_xm9_m}
.param x_dut_xm19_w = {x_dut_xm14_w}
.param x_dut_xm15_w = {x_dut_xm14_w}
.param x_dut_xm20_w = {x_dut_xm14_w}
.param x_dut_xm16_w = {x_dut_xm14_w}
.param x_dut_xm17_w = {x_dut_xm14_w}
.param x_dut_xm12_w = {x_dut_xm14_w}
.param x_dut_xm18_w = {x_dut_xm14_w}
.param x_dut_xm13_w = {x_dut_xm14_w}
.param x_dut_xm19_l = {x_dut_xm14_l}
.param x_dut_xm15_l = {x_dut_xm14_l}
.param x_dut_xm20_l = {x_dut_xm14_l}
.param x_dut_xm16_l = {x_dut_xm14_l}
.param x_dut_xm17_l = {x_dut_xm14_l}
.param x_dut_xm12_l = {x_dut_xm14_l}
.param x_dut_xm18_l = {x_dut_xm14_l}
.param x_dut_xm13_l = {x_dut_xm14_l}
.param x_dut_xm22_w = {x_dut_xm21_w}
.param x_dut_xm22_l = {x_dut_xm21_l}
.param x_dut_xm22_m = {x_dut_xm21_m}
.param x_dut_xm6_m = {x_dut_xm7_m*1}
.param x_dut_xm5_m = {x_dut_xm7_m*1}
.param x_dut_xm4_m = {x_dut_xm7_m*4}
.param x_dut_xm3_m = {x_dut_xm7_m*1}
.param x_dut_xm2_m = {x_dut_xm7_m*1}
.param x_dut_xm1_m = {x_dut_xm7_m*1}
.param x_dut_xm0_m = {x_dut_xm7_m*1}
.param x_dut_xm19_m = {x_dut_xm14_m*8}
.param x_dut_xm15_m = {x_dut_xm14_m*4}
.param x_dut_xm20_m = {x_dut_xm14_m*8}
.param x_dut_xm16_m = {x_dut_xm14_m*4}
.param x_dut_xm17_m = {x_dut_xm14_m*4}
.param x_dut_xm12_m = {x_dut_xm14_m*4}
.param x_dut_xm18_m = {x_dut_xm14_m*4}
.param x_dut_xm13_m = {x_dut_xm14_m*4}
.subckt amp_008_leung_nmcf vss vdd vinn vinp vout
C0 net050 VOUT 'CAPACITOR_0'
C1 net049 VOUT 'CAPACITOR_1'
I0 net013 vss 'CURRENT_0_BIAS'
XM0 net013 net013 vdd vdd sg13_lv_pmos l=x_dut_xm0_l m=x_dut_xm0_m w=x_dut_xm0_w
XM1 VB4 net013 vdd vdd sg13_lv_pmos l=x_dut_xm1_l m=x_dut_xm1_m w=x_dut_xm1_w
XM10 net043 net050 vdd vdd sg13_lv_pmos l=x_dut_xm10_l m=x_dut_xm10_m w=x_dut_xm10_w
XM11 VOUT net050 vdd vdd sg13_lv_pmos l=x_dut_xm11_l m=x_dut_xm11_m w=x_dut_xm11_w
XM12 VB4 VB3 net54 vss sg13_lv_nmos l=x_dut_xm12_l m=x_dut_xm12_m w=x_dut_xm12_w
XM13 DM_1 VB3 net56 vss sg13_lv_nmos l=x_dut_xm13_l m=x_dut_xm13_m w=x_dut_xm13_w
XM14 VB3 VB3 vss vss sg13_lv_nmos l=x_dut_xm14_l m=x_dut_xm14_m w=x_dut_xm14_w
XM15 VOUTN VB3 DM_2 vss sg13_lv_nmos l=x_dut_xm15_l m=x_dut_xm15_m w=x_dut_xm15_w
XM16 net050 VB3 net063 vss sg13_lv_nmos l=x_dut_xm16_l m=x_dut_xm16_m w=x_dut_xm16_w
XM17 net54 VB4 vss vss sg13_lv_nmos l=x_dut_xm17_l m=x_dut_xm17_m w=x_dut_xm17_w
XM18 net56 VB4 vss vss sg13_lv_nmos l=x_dut_xm18_l m=x_dut_xm18_m w=x_dut_xm18_w
XM19 DM_2 VB4 vss vss sg13_lv_nmos l=x_dut_xm19_l m=x_dut_xm19_m w=x_dut_xm19_w
XM2 DM_1 net013 vdd vdd sg13_lv_pmos l=x_dut_xm2_l m=x_dut_xm2_m w=x_dut_xm2_w
XM20 net063 VB4 vss vss sg13_lv_nmos l=x_dut_xm20_l m=x_dut_xm20_m w=x_dut_xm20_w
XM21 net043 net043 vss vss sg13_lv_nmos l=x_dut_xm21_l m=x_dut_xm21_m w=x_dut_xm21_w
XM22 net049 net043 vss vss sg13_lv_nmos l=x_dut_xm22_l m=x_dut_xm22_m w=x_dut_xm22_w
XM23 VOUT net049 vss vss sg13_lv_nmos l=x_dut_xm23_l m=x_dut_xm23_m w=x_dut_xm23_w
XM3 VB3 net013 vdd vdd sg13_lv_pmos l=x_dut_xm3_l m=x_dut_xm3_m w=x_dut_xm3_w
XM4 net31 net013 vdd vdd sg13_lv_pmos l=x_dut_xm4_l m=x_dut_xm4_m w=x_dut_xm4_w
XM5 VOUTN VOUTN vdd vdd sg13_lv_pmos l=x_dut_xm5_l m=x_dut_xm5_m w=x_dut_xm5_w
XM6 net050 VOUTN vdd vdd sg13_lv_pmos l=x_dut_xm6_l m=x_dut_xm6_m w=x_dut_xm6_w
XM7 net049 net013 vdd vdd sg13_lv_pmos l=x_dut_xm7_l m=x_dut_xm7_m w=x_dut_xm7_w
XM8 DM_2 VINN net31 net31 sg13_lv_pmos l=x_dut_xm8_l m=x_dut_xm8_m w=x_dut_xm8_w
XM9 net063 VINP net31 net31 sg13_lv_pmos l=x_dut_xm9_l m=x_dut_xm9_m w=x_dut_xm9_w
.ends
.end
