** GENERATED by `analog-db generate` — DO NOT EDIT. Source: abstract/netlist.spice → gf180mcu
* cmp_002_strongarm (emitted by spicexplorer-circuitgraph)
XMINN sp vinn tail vss nfet_03v3 l=x_dut_xminn_l m=x_dut_xminn_m w=x_dut_xminn_w
XMINP sn vinp tail vss nfet_03v3 l=x_dut_xminp_l m=x_dut_xminp_m w=x_dut_xminp_w
XMLEM lm lp sn vss nfet_03v3 l=x_dut_xmlem_l m=x_dut_xmlem_m w=x_dut_xmlem_w
XMLEP lp lm sp vss nfet_03v3 l=x_dut_xmlep_l m=x_dut_xmlep_m w=x_dut_xmlep_w
XMLUM lm lp vdd vdd pfet_03v3 l=x_dut_xmlum_l m=x_dut_xmlum_m w=x_dut_xmlum_w
XMLUP lp lm vdd vdd pfet_03v3 l=x_dut_xmlup_l m=x_dut_xmlup_m w=x_dut_xmlup_w
XMOBN1 voutp lm vss vss nfet_03v3 l=x_dut_xmobn1_l m=x_dut_xmobn1_m w=x_dut_xmobn1_w
XMOBN2 voutn lp vss vss nfet_03v3 l=x_dut_xmobn2_l m=x_dut_xmobn2_m w=x_dut_xmobn2_w
XMOBP1 voutp lm vdd vdd pfet_03v3 l=x_dut_xmobp1_l m=x_dut_xmobp1_m w=x_dut_xmobp1_w
XMOBP2 voutn lp vdd vdd pfet_03v3 l=x_dut_xmobp2_l m=x_dut_xmobp2_m w=x_dut_xmobp2_w
XMPC1 sp clk vdd vdd pfet_03v3 l=x_dut_xmpc1_l m=x_dut_xmpc1_m w=x_dut_xmpc1_w
XMPC2 sn clk vdd vdd pfet_03v3 l=x_dut_xmpc2_l m=x_dut_xmpc2_m w=x_dut_xmpc2_w
XMPC3 lp clk vdd vdd pfet_03v3 l=x_dut_xmpc3_l m=x_dut_xmpc3_m w=x_dut_xmpc3_w
XMPC4 lm clk vdd vdd pfet_03v3 l=x_dut_xmpc4_l m=x_dut_xmpc4_m w=x_dut_xmpc4_w
XMTAIL tail clk vss vss nfet_03v3 l=x_dut_xmtail_l m=x_dut_xmtail_m w=x_dut_xmtail_w
.end
