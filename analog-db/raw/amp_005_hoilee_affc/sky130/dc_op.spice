** GENERATED by `analog-db export-raw` — DO NOT EDIT.
** circuit=amp_005_hoilee_affc  class=amplifier  pdk=sky130  testbench=dc_op  corner=tt
** Self-contained deck: testbench + bound params + lowered DUT (.subckt amp_005_hoilee_affc).
** PDK corner libs resolve by BARE NAME on the image's ngspice sourcepath — run in a
** PDK-enabled env (the base image / api container), NOT a bare host:
**   docker run --rm -i spicexplorer-spice-base:local \
**     bash -lc 'd=$(mktemp -d) && cat > $d/c.spice && cd $d && ngspice -b c.spice' < raw/amp_005_hoilee_affc/sky130/dc_op.spice
*----------------------------------------------------------*
** params: 33 free + 0 frozen knobs (sizing.yaml) · 44 tied · 16 ratio-derived (abstract/params.yaml) · 2 testbench params
** AUTHORED TEMPLATE — amplifier/dc_op_biaswrap: DC operating point + supply current for DUTs on
** the AnalogGym self-bias convention (ports vss vdd vinn vinp vout; NO ibias port). Self-bias
** companion of the universal dc_op (M4 follow-up): a high-gain multistage OTA has no stable
** open-loop DC op point (it rails), so i_supply read open-loop is non-representative. Close the DC
** feedback exactly as ac_open_loop_biaswrap does — Lfb DC-shorts vout back to the inverting input
** (unity DC feedback), pinning the real quiescent operating point (vout ≈ VCM) — then read the
** supply current there. No Cin/Vac: this is a pure DC .op (an inductor is a DC short, so the loop
** is closed at DC).
**
** Assumes the AnalogGym canonical DUT port order (self-biased; NO ibias port):
**   .subckt <id> vss vdd vinn vinp vout
** Bindings: DUT VDD VCM PDK_INCLUDE.
** FIXED 2026-07-20: this template used to hardcode `X1 0 vdd opout_dc opin opout amp_005_hoilee_affc`,
** which silently assumed the AnalogGym port order [vss vdd vinn vinp vout] and MIS-WIRED any
** DUT declaring a different order (e.g. the amplifier-class [vdd vout vinp vinn vss] swaps
** vdd<->vss). It now uses XDUT vss vdd vinn vinp vout with canonical node names, exactly like the
** *_biaswrap_ibias sibling. For the AnalogGym DUTs this is a no-op: their vss port binds to
** node `vss`, which `Vss vss 0 dc 0` ties to ground just as the old direct-to-0 wiring did.
.lib sky130.lib.spice tt
.temp 27

.param VDD=1.8
.param VCM=300m

Vdd  vdd 0 dc {VDD}
Vss  vss 0 dc 0
Vcm  vinp 0 dc {VCM}          ; common-mode bias on the non-inverting input
Lfb  vout vinn 1T        ; 1 TH: DC short → unity feedback sets the quiescent op point

XDUT vss vdd vinn vinp vout amp_005_hoilee_affc
.control
  set filetype=ascii
  op
  let i_supply = abs(i(Vdd))
  * Input-referred systematic offset: the Lfb DC short makes this a unity-gain follower, so the
  * settled (vout - vinp) IS the input offset. Additive metric (2026-07-20) — existing measures
  * are untouched; a topology with a deliberately ratioed sink (e.g. the TI LDO error amp's
  * mirror_e) shows a large vos here, which also caps its ICMR tracking band.
  let vos = v(vout) - v(vinp)
  print i_supply vos
  write
  quit
.endc
.param CAPACITOR_0=4.75361e-11
.param CAPACITOR_1=6.23665e-12
.param CURRENT_0_BIAS=8.30497e-06
.param x_dut_xm7_l=2.38974
.param x_dut_xm7_m=4
.param x_dut_xm7_w=0.847059
.param x_dut_xm11_l=1.087
.param x_dut_xm11_m=4
.param x_dut_xm11_w=2.93234
.param x_dut_xm12_l=0.488603
.param x_dut_xm12_m=4
.param x_dut_xm12_w=2.11504
.param x_dut_xm16_l=0.340046
.param x_dut_xm16_m=16
.param x_dut_xm16_w=0.815767
.param x_dut_xm64_l=1.27588
.param x_dut_xm15_m=4
.param x_dut_xm64_w=0.911042
.param x_dut_xm22_l=0.508278
.param x_dut_xm22_m=4
.param x_dut_xm22_w=0.765563
.param x_dut_xm25_l=1.2578
.param x_dut_xm25_m=4
.param x_dut_xm25_w=0.76744
.param x_dut_xm59_l=0.974568
.param x_dut_xm59_m=4
.param x_dut_xm59_w=0.966023
.param x_dut_xm63_l=0.870432
.param x_dut_xm63_m=4
.param x_dut_xm63_w=0.981823
.param x_dut_xm10_l=0.626819
.param x_dut_xm10_m=4
.param x_dut_xm10_w=0.827909
* ---- GENERATED parameter ties (abstract/params.yaml groups/ratios) ----
* Each tied symbol is defined exactly once, by its line below; rewrite that
* .param to untie just that symbol (untying = shadowing, plan D-3).
.param x_dut_xm62_w = {x_dut_xm59_w}
.param x_dut_xm62_l = {x_dut_xm59_l}
.param x_dut_xm62_m = {x_dut_xm59_m}
.param x_dut_xm6_w = {x_dut_xm7_w}
.param x_dut_xm5_w = {x_dut_xm7_w}
.param x_dut_xm4_w = {x_dut_xm7_w}
.param x_dut_xm3_w = {x_dut_xm7_w}
.param x_dut_xm2_w = {x_dut_xm7_w}
.param x_dut_xm1_w = {x_dut_xm7_w}
.param x_dut_xm0_w = {x_dut_xm7_w}
.param x_dut_xm6_l = {x_dut_xm7_l}
.param x_dut_xm5_l = {x_dut_xm7_l}
.param x_dut_xm4_l = {x_dut_xm7_l}
.param x_dut_xm3_l = {x_dut_xm7_l}
.param x_dut_xm2_l = {x_dut_xm7_l}
.param x_dut_xm1_l = {x_dut_xm7_l}
.param x_dut_xm0_l = {x_dut_xm7_l}
.param x_dut_xm9_w = {x_dut_xm10_w}
.param x_dut_xm9_l = {x_dut_xm10_l}
.param x_dut_xm9_m = {x_dut_xm10_m}
.param x_dut_xm61_w = {x_dut_xm64_w}
.param x_dut_xm20_w = {x_dut_xm64_w}
.param x_dut_xm21_w = {x_dut_xm64_w}
.param x_dut_xm18_w = {x_dut_xm64_w}
.param x_dut_xm15_w = {x_dut_xm64_w}
.param x_dut_xm13_w = {x_dut_xm64_w}
.param x_dut_xm19_w = {x_dut_xm64_w}
.param x_dut_xm14_w = {x_dut_xm64_w}
.param x_dut_xm61_l = {x_dut_xm64_l}
.param x_dut_xm20_l = {x_dut_xm64_l}
.param x_dut_xm21_l = {x_dut_xm64_l}
.param x_dut_xm18_l = {x_dut_xm64_l}
.param x_dut_xm15_l = {x_dut_xm64_l}
.param x_dut_xm13_l = {x_dut_xm64_l}
.param x_dut_xm19_l = {x_dut_xm64_l}
.param x_dut_xm14_l = {x_dut_xm64_l}
.param x_dut_xm60_w = {x_dut_xm63_w}
.param x_dut_xm60_l = {x_dut_xm63_l}
.param x_dut_xm60_m = {x_dut_xm63_m}
.param x_dut_xm23_w = {x_dut_xm22_w}
.param x_dut_xm23_l = {x_dut_xm22_l}
.param x_dut_xm23_m = {x_dut_xm22_m}
.param x_dut_xm17_w = {x_dut_xm16_w}
.param x_dut_xm17_l = {x_dut_xm16_l}
.param x_dut_xm6_m = {x_dut_xm7_m*1}
.param x_dut_xm5_m = {x_dut_xm7_m*1}
.param x_dut_xm4_m = {x_dut_xm7_m*2}
.param x_dut_xm3_m = {x_dut_xm7_m*1}
.param x_dut_xm2_m = {x_dut_xm7_m*1}
.param x_dut_xm1_m = {x_dut_xm7_m*1}
.param x_dut_xm0_m = {x_dut_xm7_m*1}
.param x_dut_xm17_m = {x_dut_xm16_m*1}
.param x_dut_xm64_m = {x_dut_xm15_m*4}
.param x_dut_xm61_m = {x_dut_xm15_m*4}
.param x_dut_xm20_m = {x_dut_xm15_m*8}
.param x_dut_xm21_m = {x_dut_xm15_m*8}
.param x_dut_xm18_m = {x_dut_xm15_m*4}
.param x_dut_xm13_m = {x_dut_xm15_m*4}
.param x_dut_xm19_m = {x_dut_xm15_m*4}
.param x_dut_xm14_m = {x_dut_xm15_m*4}
.subckt amp_005_hoilee_affc vss vdd vinn vinp vout
C0 net049 VOUT 'CAPACITOR_0'
C1 VOUT net1 'CAPACITOR_1'
I0 net013 vss 'CURRENT_0_BIAS'
XM0 net013 net013 vdd vdd sky130_fd_pr__pfet_01v8 l=x_dut_xm0_l m=x_dut_xm0_m w=x_dut_xm0_w
XM1 VB4 net013 vdd vdd sky130_fd_pr__pfet_01v8 l=x_dut_xm1_l m=x_dut_xm1_m w=x_dut_xm1_w
XM10 net063 VINP net31 net31 sky130_fd_pr__pfet_01v8 l=x_dut_xm10_l m=x_dut_xm10_m w=x_dut_xm10_w
XM11 net043 net050 vdd vdd sky130_fd_pr__pfet_01v8 l=x_dut_xm11_l m=x_dut_xm11_m w=x_dut_xm11_w
XM12 VOUT net050 vdd vdd sky130_fd_pr__pfet_01v8 l=x_dut_xm12_l m=x_dut_xm12_m w=x_dut_xm12_w
XM13 VB4 VB3 net54 vss sky130_fd_pr__nfet_01v8 l=x_dut_xm13_l m=x_dut_xm13_m w=x_dut_xm13_w
XM14 DM_1 VB3 net56 vss sky130_fd_pr__nfet_01v8 l=x_dut_xm14_l m=x_dut_xm14_m w=x_dut_xm14_w
XM15 VB3 VB3 vss vss sky130_fd_pr__nfet_01v8 l=x_dut_xm15_l m=x_dut_xm15_m w=x_dut_xm15_w
XM16 VOUTN VB3 DM_2 vss sky130_fd_pr__nfet_01v8 l=x_dut_xm16_l m=x_dut_xm16_m w=x_dut_xm16_w
XM17 net050 VB3 net063 vss sky130_fd_pr__nfet_01v8 l=x_dut_xm17_l m=x_dut_xm17_m w=x_dut_xm17_w
XM18 net54 VB4 vss vss sky130_fd_pr__nfet_01v8 l=x_dut_xm18_l m=x_dut_xm18_m w=x_dut_xm18_w
XM19 net56 VB4 vss vss sky130_fd_pr__nfet_01v8 l=x_dut_xm19_l m=x_dut_xm19_m w=x_dut_xm19_w
XM2 DM_1 net013 vdd vdd sky130_fd_pr__pfet_01v8 l=x_dut_xm2_l m=x_dut_xm2_m w=x_dut_xm2_w
XM20 DM_2 VB4 vss vss sky130_fd_pr__nfet_01v8 l=x_dut_xm20_l m=x_dut_xm20_m w=x_dut_xm20_w
XM21 net063 VB4 vss vss sky130_fd_pr__nfet_01v8 l=x_dut_xm21_l m=x_dut_xm21_m w=x_dut_xm21_w
XM22 net043 net043 vss vss sky130_fd_pr__nfet_01v8 l=x_dut_xm22_l m=x_dut_xm22_m w=x_dut_xm22_w
XM23 net049 net043 vss vss sky130_fd_pr__nfet_01v8 l=x_dut_xm23_l m=x_dut_xm23_m w=x_dut_xm23_w
XM25 VOUT net049 vss vss sky130_fd_pr__nfet_01v8 l=x_dut_xm25_l m=x_dut_xm25_m w=x_dut_xm25_w
XM3 VB3 net013 vdd vdd sky130_fd_pr__pfet_01v8 l=x_dut_xm3_l m=x_dut_xm3_m w=x_dut_xm3_w
XM4 net31 net013 vdd vdd sky130_fd_pr__pfet_01v8 l=x_dut_xm4_l m=x_dut_xm4_m w=x_dut_xm4_w
XM5 VOUTN VOUTN vdd vdd sky130_fd_pr__pfet_01v8 l=x_dut_xm5_l m=x_dut_xm5_m w=x_dut_xm5_w
XM59 net2 net2 vdd vdd sky130_fd_pr__pfet_01v8 l=x_dut_xm59_l m=x_dut_xm59_m w=x_dut_xm59_w
XM6 net050 VOUTN vdd vdd sky130_fd_pr__pfet_01v8 l=x_dut_xm6_l m=x_dut_xm6_m w=x_dut_xm6_w
XM60 net2 VB3 net3 vss sky130_fd_pr__nfet_01v8 l=x_dut_xm60_l m=x_dut_xm60_m w=x_dut_xm60_w
XM61 net3 VB4 vss vss sky130_fd_pr__nfet_01v8 l=x_dut_xm61_l m=x_dut_xm61_m w=x_dut_xm61_w
XM62 net050 net2 vdd vdd sky130_fd_pr__pfet_01v8 l=x_dut_xm62_l m=x_dut_xm62_m w=x_dut_xm62_w
XM63 net050 VB3 net1 vss sky130_fd_pr__nfet_01v8 l=x_dut_xm63_l m=x_dut_xm63_m w=x_dut_xm63_w
XM64 net1 VB4 vss vss sky130_fd_pr__nfet_01v8 l=x_dut_xm64_l m=x_dut_xm64_m w=x_dut_xm64_w
XM7 net049 net013 vdd vdd sky130_fd_pr__pfet_01v8 l=x_dut_xm7_l m=x_dut_xm7_m w=x_dut_xm7_w
XM9 DM_2 VINN net31 net31 sky130_fd_pr__pfet_01v8 l=x_dut_xm9_l m=x_dut_xm9_m w=x_dut_xm9_w
.ends
.end
