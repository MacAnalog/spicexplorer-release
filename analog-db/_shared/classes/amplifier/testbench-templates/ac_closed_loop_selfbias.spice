** AUTHORED TEMPLATE — amplifier/ac_closed_loop_selfbias (2026-07-20): unity-gain buffer AC
** response for SELF-BIASED DUTs (no ibias port). Identical to `ac_closed_loop` except there is no
** external bias source — derived exactly as psrr_vdd_selfbias derives from psrr_vdd (drop
** `.param IBIAS` and the `Ibias` line), so a 5-port [vdd vout vinp vinn vss] DUT does not leave a
** current source driving a dangling `ibias` node (which makes the DC solve singular).
** Unity-gain buffer: vinn shorted to vout (0 V source). This is the analog-circuit-design CACE
** "voltage buffer" measurement (gain ~1, -3 dB bandwidth).
** Bindings: DUT PORT_LINE VDD VCM CL FSTART FSTOP PPD PDK_INCLUDE.
${PDK_INCLUDE}

.param VDD=${VDD}
.param VCM=${VCM}
.param CL=${CL}

Vdd  vdd 0 dc {VDD}
Vss  vss 0 dc 0
CLoad vout 0 {CL}

Vinp vinp 0 dc {VCM} ac 1
Vfb  vinn vout dc 0

${PORT_LINE} ${DUT}

.control
  set filetype=ascii
  ac dec ${PPD} ${FSTART} ${FSTOP}
  meas ac gain_cl FIND vmag(vout) AT=${FSTART}
  let g3db = gain_cl/sqrt(2)
  meas ac bw_cl WHEN vmag(vout)=g3db FALL=1
  write
  quit
.endc
.end
