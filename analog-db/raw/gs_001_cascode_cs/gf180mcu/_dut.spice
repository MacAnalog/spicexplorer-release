** GENERATED by `analog-db export-raw` — DO NOT EDIT.
** Standalone lowered DUT subckt for gs_001_cascode_cs on gf180mcu (sizing .param defaults + .subckt).
** Not a runnable deck on its own — include it under your own testbench:
**   .include _dut.spice
**   XDUT vdd vout vin ibias vss gs_001_cascode_cs
** Source: pdk/gf180mcu/netlist.spice (run `analog-db generate` to refresh).
*----------------------------------------------------------*
** params: 10 free + 9 frozen knobs (sizing.yaml) · 8 tied · 0 ratio-derived (abstract/params.yaml)
.param x_dut_xmpb1_w=16u
.param x_dut_xmpb1_l=0.5u
.param x_dut_xmpnr_w=0.5u
.param x_dut_xmnb2_w=6u
.param x_dut_xmnb2_l=0.3u
.param x_dut_xmpld_w=10u
.param x_dut_xmpld_l=0.5u
.param x_dut_xmnca_w=4u
.param x_dut_xmnin_w=4u
.param x_dut_xmnca_l=0.3u
.param x_dut_xmpb1_m=1
.param x_dut_xmpb2_m=1
.param x_dut_xmpnr_m=1
.param x_dut_xmnb2_m=1
.param x_dut_xmnb1_m=1
.param x_dut_xmpld_m=1
.param x_dut_xmpca_m=1
.param x_dut_xmnca_m=1
.param x_dut_xmnin_m=1
* ---- GENERATED parameter ties (abstract/params.yaml groups/ratios) ----
* Each tied symbol is defined exactly once, by its line below; rewrite that
* .param to untie just that symbol (untying = shadowing, plan D-3).
.param x_dut_xmpb2_l = {x_dut_xmpb1_l}
.param x_dut_xmpnr_l = {x_dut_xmpb1_l}
.param x_dut_xmpb2_w = {x_dut_xmpb1_w}
.param x_dut_xmnb1_w = {x_dut_xmnb2_w}
.param x_dut_xmnb1_l = {x_dut_xmnb2_l}
.param x_dut_xmpca_w = {x_dut_xmpld_w}
.param x_dut_xmpca_l = {x_dut_xmpld_l}
.param x_dut_xmnin_l = {x_dut_xmnca_l}
.subckt gs_001_cascode_cs vdd vout vin ibias vss
XMNB1 nbias1 nbias1 vss vss nfet_03v3 l=x_dut_xmnb1_l m=x_dut_xmnb1_m w=x_dut_xmnb1_w
XMNB2 nbias2 nbias2 nbias1 vss nfet_03v3 l=x_dut_xmnb2_l m=x_dut_xmnb2_m w=x_dut_xmnb2_w
XMNCA vout nbias2 nint vss nfet_03v3 l=x_dut_xmnca_l m=x_dut_xmnca_m w=x_dut_xmnca_w
XMNIN nint vin vss vss nfet_03v3 l=x_dut_xmnin_l m=x_dut_xmnin_m w=x_dut_xmnin_w
XMPB1 pbias1 pbias1 vdd vdd pfet_03v3 l=x_dut_xmpb1_l m=x_dut_xmpb1_m w=x_dut_xmpb1_w
XMPB2 ibias ibias pbias1 vdd pfet_03v3 l=x_dut_xmpb2_l m=x_dut_xmpb2_m w=x_dut_xmpb2_w
XMPCA vout ibias pint vdd pfet_03v3 l=x_dut_xmpca_l m=x_dut_xmpca_m w=x_dut_xmpca_w
XMPLD pint pbias1 vdd vdd pfet_03v3 l=x_dut_xmpld_l m=x_dut_xmpld_m w=x_dut_xmpld_w
XMPNR nbias2 ibias vdd vdd pfet_03v3 l=x_dut_xmpnr_l m=x_dut_xmpnr_m w=x_dut_xmpnr_w
.ends
