* LVS reference for pam4drv_pam4_lay (generated by gen_layout.py — matches the GDS exactly)
.subckt pam4drv_pam4_lay lsbp lsbn msbp msbn outp outn vcc vcasc vcmb tmsb0 tlsb0 tmsb1 sub
QQ1M0 c1M0 msbp e1M0 sub npn13G2 AE=0.063p PE=1.94u M=3
QQ2M0 c2M0 msbn e2M0 sub npn13G2 AE=0.063p PE=1.94u M=3
QQ3M0 outp vcasc c1M0 sub npn13G2 AE=0.063p PE=1.94u M=3
QQ4M0 outn vcasc c2M0 sub npn13G2 AE=0.063p PE=1.94u M=3
QQ1L0 c1L0 lsbp e1L0 sub npn13G2 AE=0.063p PE=1.94u M=3
QQ2L0 c2L0 lsbn e2L0 sub npn13G2 AE=0.063p PE=1.94u M=3
QQ3L0 outp vcasc c1L0 sub npn13G2 AE=0.063p PE=1.94u M=3
QQ4L0 outn vcasc c2L0 sub npn13G2 AE=0.063p PE=1.94u M=3
QQ1M1 c1M1 msbp e1M1 sub npn13G2 AE=0.063p PE=1.94u M=3
QQ2M1 c2M1 msbn e2M1 sub npn13G2 AE=0.063p PE=1.94u M=3
QQ3M1 outp vcasc c1M1 sub npn13G2 AE=0.063p PE=1.94u M=3
QQ4M1 outn vcasc c2M1 sub npn13G2 AE=0.063p PE=1.94u M=3
RRE1M0 e1M0 tmsb0 rsil w=4.5u l=0.77u m=1
RRE2M0 e2M0 tmsb0 rsil w=4.5u l=0.77u m=1
RRE1L0 e1L0 tlsb0 rsil w=4.5u l=0.77u m=1
RRE2L0 e2L0 tlsb0 rsil w=4.5u l=0.77u m=1
RRE1M1 e1M1 tmsb1 rsil w=4.5u l=0.77u m=1
RRE2M1 e2M1 tmsb1 rsil w=4.5u l=0.77u m=1
RRblsbp lsbp vcmb rsil w=0.5u l=2.14u m=1
RRblsbn lsbn vcmb rsil w=0.5u l=2.14u m=1
RRbmsbp msbp vcmb rsil w=0.5u l=2.14u m=1
RRbmsbn msbn vcmb rsil w=0.5u l=2.14u m=1
RRcp outp vcc rsil w=1.4u l=8.71u m=1
RRcn outn vcc rsil w=1.4u l=8.71u m=1
CCdegM0 e2M0 e1M0 cap_cmim W=3.21u L=3.21u M=1
CCdegL0 e2L0 e1L0 cap_cmim W=3.21u L=3.21u M=1
CCdegM1 e2M1 e1M1 cap_cmim W=3.21u L=3.21u M=1
.ends
