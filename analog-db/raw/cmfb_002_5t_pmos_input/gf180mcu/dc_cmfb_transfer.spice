** GENERATED by `analog-db export-raw` — DO NOT EDIT.
** circuit=cmfb_002_5t_pmos_input  class=cmfb  pdk=gf180mcu  testbench=dc_cmfb_transfer  corner=tt
** Self-contained deck: testbench + bound params + lowered DUT (.subckt cmfb_002_5t_pmos_input).
** PDK corner libs resolve by BARE NAME on the image's ngspice sourcepath — run in a
** PDK-enabled env (the base image / api container), NOT a bare host:
**   docker run --rm -i spicexplorer-spice-base:local \
**     bash -lc 'd=$(mktemp -d) && cat > $d/c.spice && cd $d && ngspice -b c.spice' < raw/cmfb_002_5t_pmos_input/gf180mcu/dc_cmfb_transfer.spice
*----------------------------------------------------------*
** params: 11 free + 5 frozen knobs (sizing.yaml) · 7 tied · 0 ratio-derived (abstract/params.yaml) · 2 testbench params
** AUTHORED TEMPLATE — cmfb/dc_cmfb_transfer (block-level polarity + transfer + ranges).
** THE polarity bench: both sense inputs tied to one swept source Vs (a pure sensed-CM
** drive), vref held at VCM; the vcmfb(vs) curve gives
**   cmfb_slope     SIGNED two-point slope at VCM +/- VDELTA (V/V): canonical
**                  vcmfb = A*(sensed - vref) -> positive; inverted -> negative.
**                  Cross-check the plant side with amplifier/dc_cmfb_plant_sign.
**   gain_servo_db  20*log10(|cmfb_slope|)
**   vcmfb_nat      output at Vs = VCM (zero CM error) — the actuator-matching level:
**                  closed-loop static CM error ~ (needed gate - vcmfb_nat)/|slope|
**   vcmfb_min/max  control-output range over the VSLO..VSHI sweep (rail-clamp span)
**   sense_lo/hi    active sensed-CM range: |d vcmfb/d vs| >= 10% of its sweep peak.
**                  NOTE: a LINEAR behavioral servo never crosses the threshold — these
**                  two meas fail harmlessly there; list them in `produces:` only for
**                  members with a real (compressive) input stage.
**   r_sense_in     DC resistance looking into the tied sense pins (plant loading),
**                  from the drive-source current at VCM +/- VDELTA
**   i_supply       op supply current (behavioral members with no-connect vdd: ~0)
** Assumes the CMFB port order (bind a reduced/reordered PORT_LINE otherwise):
**   .subckt <id> vinp vinn vcmfb vref vdd vss
** Required bindings: DUT PORT_LINE VDD VCM VDELTA VSLO VSHI VSSTEP PDK_INCLUDE.
.include design.ngspice
.lib sm141064.ngspice noise_corner
.lib sm141064.ngspice nfet_03v3_t
.lib sm141064.ngspice pfet_03v3_t
.lib sm141064.ngspice fets_mm
.lib sm141064.ngspice res_typical
.lib sm141064.ngspice mimcap_typical
.lib sm141064.ngspice cap_mim
.temp 27

.param VDD=1.2
.param VCM=0.5

Vdd  vdd 0 dc {VDD}
Vss  vss 0 dc 0
Vref vref 0 dc {VCM}
* tied sensed-CM drive (both sense pins follow vs exactly)
Vs   vs 0 dc {VCM}
Vinp vinp vs dc 0
Vinn vinn vs dc 0

XDUT vinp vinn vcmfb vref vdd vss cmfb_002_5t_pmos_input

.control
  set filetype=ascii
  op
  let i_supply = -i(vdd)
  print i_supply
  dc Vs 0 1.2 2m
  meas dc vcmfb_nat FIND v(vcmfb) AT=0.5
  meas dc g_lo FIND v(vcmfb) AT={0.5-10m}
  meas dc g_hi FIND v(vcmfb) AT={0.5+10m}
  let cmfb_slope = (g_hi - g_lo)/(2*10m)
  let gain_servo_db = db(abs(cmfb_slope))
  print cmfb_slope gain_servo_db
  meas dc vcmfb_min MIN v(vcmfb)
  meas dc vcmfb_max MAX v(vcmfb)
  * active sensed-CM range: |local slope| crosses 10% of its peak (real input stages)
  let dm = abs(deriv(v(vcmfb)))
  meas dc dpk MAX dm
  let thr = 0.1*dpk
  meas dc sense_lo WHEN dm=$&thr RISE=1
  meas dc sense_hi WHEN dm=$&thr FALL=LAST
  * sense-port loading from the drive-source current
  meas dc is_lo FIND i(Vs) AT={0.5-10m}
  meas dc is_hi FIND i(Vs) AT={0.5+10m}
  let r_sense_in = abs((2*10m)/(is_hi - is_lo))
  print r_sense_in
  write
  quit
.endc
.param x_dut_xm4_w=1.42u
.param x_dut_xm4_l=0.28u
.param x_dut_xm2_w=2.32u
.param x_dut_xm2_l=1.31u
.param x_dut_xm1_w=0.329u
.param x_dut_xm1_l=0.28u
.param x_dut_xm7_w=0.293u
.param x_dut_xm7_l=0.28u
.param x_dut_xm3_w=0.881u
.param x_dut_xm3_l=0.28u
.param x_dut_rmp_value=1Meg
.param x_dut_xm1_m=1
.param x_dut_xm2_m=1
.param x_dut_xm3_m=1
.param x_dut_xm4_m=1
.param x_dut_xm7_m=1
* ---- GENERATED parameter ties (abstract/params.yaml groups/ratios) ----
* Each tied symbol is defined exactly once, by its line below; rewrite that
* .param to untie just that symbol (untying = shadowing, plan D-3).
.param x_dut_xm5_w = {x_dut_xm4_w}
.param x_dut_xm5_l = {x_dut_xm4_l}
.param x_dut_xm5_m = {x_dut_xm4_m}
.param x_dut_xm6_w = {x_dut_xm2_w}
.param x_dut_xm6_l = {x_dut_xm2_l}
.param x_dut_xm6_m = {x_dut_xm2_m}
.param x_dut_rmn_value = {x_dut_rmp_value}
.subckt cmfb_002_5t_pmos_input vinp vinn vcmfb vref vdd vss
RMN vinn cm_sense 'x_dut_rmn_value'
RMP cm_sense vinp 'x_dut_rmp_value'
XM1 ptail bias vdd vdd pfet_03v3 l=x_dut_xm1_l m=x_dut_xm1_m w=x_dut_xm1_w
XM2 vcmfb mirr vss vss nfet_03v3 l=x_dut_xm2_l m=x_dut_xm2_m w=x_dut_xm2_w
XM3 bias bias vdd vdd pfet_03v3 l=x_dut_xm3_l m=x_dut_xm3_m w=x_dut_xm3_w
XM4 mirr cm_sense ptail vdd pfet_03v3 l=x_dut_xm4_l m=x_dut_xm4_m w=x_dut_xm4_w
XM5 vcmfb vref ptail vdd pfet_03v3 l=x_dut_xm5_l m=x_dut_xm5_m w=x_dut_xm5_w
XM6 mirr mirr vss vss nfet_03v3 l=x_dut_xm6_l m=x_dut_xm6_m w=x_dut_xm6_w
XM7 bias bias vss vss nfet_03v3 l=x_dut_xm7_l m=x_dut_xm7_m w=x_dut_xm7_w
.ends
.end
