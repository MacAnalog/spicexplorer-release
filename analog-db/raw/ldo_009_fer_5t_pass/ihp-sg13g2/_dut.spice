** GENERATED by `analog-db export-raw` — DO NOT EDIT.
** Standalone lowered DUT subckt for ldo_009_fer_5t_pass on ihp-sg13g2 (sizing .param defaults + .subckt).
** Not a runnable deck on its own — include it under your own testbench:
**   .include _dut.spice
**   XDUT vdd vout vss ldo_009_fer_5t_pass
** Source: pdk/ihp-sg13g2/netlist.spice (run `analog-db generate` to refresh).
*----------------------------------------------------------*
** params: 12 free + 9 frozen knobs (sizing.yaml) · 6 tied · 0 ratio-derived (abstract/params.yaml)
.param x_dut_xmnb_w=4u
.param x_dut_xmnb_l=0.4u
.param x_dut_xmip_w=8u
.param x_dut_xmip_l=0.4u
.param x_dut_xmld_w=4u
.param x_dut_xmld_l=0.4u
.param x_dut_xmp_w=8u
.param x_dut_xmp_l=0.2u
.param x_cmil=2e-12
.param x_cout=50e-12
.param x_rbleed=1e5
.param x_rref=10000
.param x_vref_val=0.9
.param x_ibias_val=20e-6
.param x_dut_xmnb_m=1
.param x_dut_xmnt_m=2
.param x_dut_xmip_m=2
.param x_dut_xmin_m=2
.param x_dut_xmld_m=1
.param x_dut_xmlm_m=1
.param x_dut_xmp_m=20
* ---- GENERATED parameter ties (abstract/params.yaml groups/ratios) ----
* Each tied symbol is defined exactly once, by its line below; rewrite that
* .param to untie just that symbol (untying = shadowing, plan D-3).
.param x_dut_xmnt_w = {x_dut_xmnb_w}
.param x_dut_xmnt_l = {x_dut_xmnb_l}
.param x_dut_xmin_w = {x_dut_xmip_w}
.param x_dut_xmin_l = {x_dut_xmip_l}
.param x_dut_xmlm_w = {x_dut_xmld_w}
.param x_dut_xmlm_l = {x_dut_xmld_l}
.subckt ldo_009_fer_5t_pass vdd vout vss
CMIL vout otao x_cmil
COUT vout vss x_cout
IBI vdd nbias dc {x_ibias_val}
RBLD vout vss x_rbleed
RREF ref0 vref x_rref
VLP lp_brk vout dc 0
VREF ref0 vss dc {x_vref_val}
XMIN otao vref tail vss sg13_lv_nmos l=x_dut_xmin_l m=x_dut_xmin_m w=x_dut_xmin_w
XMIP otax lp_brk tail vss sg13_lv_nmos l=x_dut_xmip_l m=x_dut_xmip_m w=x_dut_xmip_w
XMLD otax otax vdd vdd sg13_lv_pmos l=x_dut_xmld_l m=x_dut_xmld_m w=x_dut_xmld_w
XMLM otao otax vdd vdd sg13_lv_pmos l=x_dut_xmlm_l m=x_dut_xmlm_m w=x_dut_xmlm_w
XMNB nbias nbias vss vss sg13_lv_nmos l=x_dut_xmnb_l m=x_dut_xmnb_m w=x_dut_xmnb_w
XMNT tail nbias vss vss sg13_lv_nmos l=x_dut_xmnt_l m=x_dut_xmnt_m w=x_dut_xmnt_w
XMP vout otao vdd vdd sg13_lv_pmos l=x_dut_xmp_l m=x_dut_xmp_m w=x_dut_xmp_w
.ends
