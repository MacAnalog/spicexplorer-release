simulator lang=spectre
parameters VDD=1.0
include "runs/common_setup.scs"
