** GENERATED by `analog-db export-raw` — DO NOT EDIT.
** circuit=amp_031_srmc_core_cmfb  class=amplifier  pdk=gf180mcu  testbench=cmrr_vcm  corner=tt
** Self-contained deck: testbench + bound params + lowered DUT (.subckt amp_031_srmc_core_cmfb).
** PDK corner libs resolve by BARE NAME on the image's ngspice sourcepath — run in a
** PDK-enabled env (the base image / api container), NOT a bare host:
**   docker run --rm -i spicexplorer-spice-base:local \
**     bash -lc 'd=$(mktemp -d) && cat > $d/c.spice && cd $d && ngspice -b c.spice' < raw/amp_031_srmc_core_cmfb/gf180mcu/cmrr_vcm.spice
*----------------------------------------------------------*
** params: 22 free + 6 frozen knobs (sizing.yaml) · 17 tied · 0 ratio-derived (abstract/params.yaml) · 3 testbench params
** AUTHORED TEMPLATE — amplifier/cmrr_vcm_diff: common-mode rejection of a fully-differential
** (self-biased, voutp/voutn) DUT, in the same CM-pinned differential unity-feedback network
** stb_diff uses.
**
** CONFIGURATION (see stb_diff.spice for the full why). The differential loop is closed by two
** ideal VCVSs, fbn/fbp = VCM +/- (voutp-voutn)/2, feeding the inputs through 0 V sources; the
** feedback carries the differential output ONLY, so the input CM is pinned at VCM and the DC
** operating point is the matched-inputs-at-VCM point of dc_op_diff/ac_open_loop_diff. No CM
** loop is closed by the bench — the output CM is left to the DUT's own CMFB, and being a
** small-signal bench this works on every FD cell that has a DC OP, regardless of CMFB quality.
**
** STIMULUS + MATH (the exact FD analog of cmrr_vcm.spice). BOTH feedback sources carry the
** SAME +1 V AC, so both inputs ride up together:
**     vinn = fbn + vac,  vinp = fbp + vac
**  => vin_d = vinp - vinn = -(voutp-voutn)   (the unity differential feedback, unchanged)
**     vin_c = VCM + vac                       (the common mode moves by a full volt)
** With vout_d = Add*vin_d + Adc*vin_c (Adc = the cell's CM->differential conversion gain, the
** thing mismatch creates and CMRR measures):
**     vout_d = -Add*vout_d + Adc*vac  =>  vout_d = Adc/(1+Add) * vac ~= vac/CMRR,
** where CMRR = Add/Adc — so cmrr_db = -20*log10|vout_d| (vac = 1), read at FSTART (the DC-band
** floor), exactly mirroring the SE bench's vout ~= vac/CMRR derivation.
**
** SOLVER-RESOLUTION CEILING (why the 1e-15 floor exists). The corpus netlists are written
** perfectly symmetric (matched W/L, no mismatch corners in the tt deck), so the TRUE
** small-signal Adc of the deck is zero and the AC solve's vout_d response to a pure CM
** stimulus cancels to matrix round-off — ~1e-16 relative to the ~1 V node signals in a double-
** precision LU solve. Any |vout_d| below ~1e-13 is solver noise, not physics, and -db() of it
** would report a plausible-looking 260..320 dB "CMRR" (or -db(0) = Inf, which the runner
** cannot parse). The `+ 1e-15` magnitude floor therefore CAPS the reportable figure at 300 dB:
** a cmrr_db at or near 300 means "beyond what the matrix solver can resolve on a symmetric
** netlist" — a statement about the deck, NOT a physical rejection. Consumers should treat
** anything above ~200 dB as unresolved-by-construction; the measured CMRR of real silicon is
** set by mismatch, which this nominal deck does not model.
**
** cmrr_cm_db — the SECONDARY, always-physical figure. Because the differential response of a
** symmetric cell saturates the solver, the bench also reports the OUTPUT-CM response to the
** same 1 V input-CM ride: vocm = (voutp+voutn)/2, cmrr_cm_db = -db|vocm|. That is the closed
** CM-loop's rejection of an input-CM disturbance — finite, CMFB-quality-dependent, and
** therefore the discriminating number between FD cells whose cmrr_db all read "perfect".
** (Naming: the cm figure is NOT a canonical datasheet metric; it rides the scoreboard entry's
** analyses block like stb's loop measures do.)
**
** DIFFERENTIAL-GAIN CORRECTION (downstream, scoreboard.record). cmrr_cm_db here is the RAW CM
** residual -db|vocm| — a CM-to-CM ratio, NOT yet a rejection FIGURE. A CMRR is (differential
** gain)/(CM disturbance gain), so the physical FD CMRR adds the differential open-loop gain
** back: cmrr_cm_corr_db = dc_gain_db + cmrr_cm_db (the SE unity-buffer cmrr_db folds this in via
** its closed loop; the FD CM path does not close a CM loop, so the deck cannot, and the term is
** added when the scoreboard entry is assembled). cmrr_cm_corr_db is the figure the paper prints.
**
** Bindings: DUT PORT_LINE VDD VCM CL FSTART FSTOP PPD PDK_INCLUDE.
.include design.ngspice
.lib sm141064.ngspice noise_corner
.lib sm141064.ngspice nfet_03v3_t
.lib sm141064.ngspice pfet_03v3_t
.lib sm141064.ngspice fets_mm
.lib sm141064.ngspice res_typical
.lib sm141064.ngspice mimcap_typical
.lib sm141064.ngspice cap_mim
.temp 27

.param VDD=3.3
.param VCM=1.4
.param CL=10p

Vdd  vdd 0 dc {VDD}          ; supply quiet — isolate the common-mode path
Vss  vss 0 dc 0
CLoadp voutp 0 {CL}
CLoadn voutn 0 {CL}

* differential unity feedback, CM pinned at VCM (see stb_diff.spice)
Vcm  vcm 0 dc {VCM}
Efbn fbn vcm voutp voutn 0.5
Efbp fbp vcm voutp voutn -0.5

* ... and the SAME +1 V AC lifted onto BOTH inputs: pure common-mode ride, zero differential
Vfbn vinn fbn dc 0 ac 1
Vfbp vinp fbp dc 0 ac 1

XDUT vinp vinn voutp voutn vdd vss amp_031_srmc_core_cmfb

.control
  set filetype=ascii
  ac dec 101 10 1G
  let vodm = v(voutp) - v(voutn)
  let vocm = (v(voutp) + v(voutn))/2
  * 1e-15 magnitude floor: caps the figure at 300 dB = "beyond solver resolution" (see header);
  * also keeps -db() finite on a bit-symmetric netlist whose true response is exactly 0.
  let cmrr   = -db(mag(vodm) + 1e-15)
  let cmrrcm = -db(mag(vocm) + 1e-15)
  meas ac cmrr_db    FIND cmrr   AT=10
  meas ac cmrr_cm_db FIND cmrrcm AT=10
  write
  quit
.endc
.param x_dut_xm3_w=1.9299u
.param x_dut_xm3_l=0.717161u
.param x_dut_xm6_w=4.33352u
.param x_dut_xm6_l=0.554375u
.param x_dut_xm5_w=2.65343u
.param x_dut_xm5_l=0.486286u
.param x_dut_xm8_w=2.86359u
.param x_dut_xm8_l=0.444166u
.param x_dut_xm1_w=2.0224u
.param x_dut_xm1_l=0.427751u
.param x_dut_xm2_w=1.59144u
.param x_dut_xm2_l=0.575725u
.param x_dut_c1_value=2.4e-12
.param x_dut_r1_value=10k
.param x_dut_rm1p_value=1Meg
.param gm_val=100u
.param rout_val=10Meg
.param rin_val=1.0e12
.param cout_val=100f
.param cin_val=10f
.param vb2=1.0
.param vref_cm=1.4
.param x_dut_xm1_m=1
.param x_dut_xm2_m=1
.param x_dut_xm3_m=1
.param x_dut_xm5_m=1
.param x_dut_xm6_m=1
.param x_dut_xm8_m=1
* ---- GENERATED parameter ties (abstract/params.yaml groups/ratios) ----
* Each tied symbol is defined exactly once, by its line below; rewrite that
* .param to untie just that symbol (untying = shadowing, plan D-3).
.param x_dut_xm4_w = {x_dut_xm3_w}
.param x_dut_xm4_l = {x_dut_xm3_l}
.param x_dut_xm4_m = {x_dut_xm3_m}
.param x_dut_xm7_w = {x_dut_xm6_w}
.param x_dut_xm7_l = {x_dut_xm6_l}
.param x_dut_xm7_m = {x_dut_xm6_m}
.param x_dut_xm9_w = {x_dut_xm1_w}
.param x_dut_xm9_l = {x_dut_xm1_l}
.param x_dut_xm9_m = {x_dut_xm1_m}
.param x_dut_xm10_w = {x_dut_xm2_w}
.param x_dut_xm10_l = {x_dut_xm2_l}
.param x_dut_xm10_m = {x_dut_xm2_m}
.param x_dut_c2_value = {x_dut_c1_value}
.param x_dut_r2_value = {x_dut_r1_value}
.param x_dut_rm1n_value = {x_dut_rm1p_value}
.param x_dut_rm2p_value = {x_dut_rm1p_value}
.param x_dut_rm2n_value = {x_dut_rm1p_value}
.subckt amp_031_srmc_core_cmfb vinp vinn voutp voutn vdd vss
C1 vo1n zc_p 'x_dut_c1_value'
C2 vo1p zc_n 'x_dut_c2_value'
CIN1 cm1_det vref_cm1 'cin_val'
CIN2 cm2_det vref_cm2 'cin_val'
COUT1 vss vcmfb1 'cout_val'
COUT2 vss vcmfb2 'cout_val'
GM1 vss vcmfb1 cm1_det vref_cm1 {gm_val}
GM2 vss vcmfb2 cm2_det vref_cm2 {gm_val}
R1 zc_p voutp 'x_dut_r1_value'
R2 zc_n voutn 'x_dut_r2_value'
RIN1 cm1_det vref_cm1 'rin_val'
RIN2 cm2_det vref_cm2 'rin_val'
RM1N vo1n cm1_det 'x_dut_rm1n_value'
RM1P cm1_det vo1p 'x_dut_rm1p_value'
RM2N voutn cm2_det 'x_dut_rm2n_value'
RM2P cm2_det voutp 'x_dut_rm2p_value'
ROUT1 vss vcmfb1 'rout_val'
ROUT2 vss vcmfb2 'rout_val'
VB2 vb2 vss dc {vb2}
VREF1 vref_cm1 vss dc {vref_cm}
VREF2 vref_cm2 vss dc {vref_cm}
XM1 voutp vo1n vss vss nfet_03v3 l=x_dut_xm1_l m=x_dut_xm1_m w=x_dut_xm1_w
XM10 voutn vcmfb2 vdd vdd pfet_03v3 l=x_dut_xm10_l m=x_dut_xm10_m w=x_dut_xm10_w
XM2 voutp vcmfb2 vdd vdd pfet_03v3 l=x_dut_xm2_l m=x_dut_xm2_m w=x_dut_xm2_w
XM3 vo1n vinp ntail vss nfet_03v3 l=x_dut_xm3_l m=x_dut_xm3_m w=x_dut_xm3_w
XM4 vo1p vinn ntail vss nfet_03v3 l=x_dut_xm4_l m=x_dut_xm4_m w=x_dut_xm4_w
XM5 ntail vb2 vss vss nfet_03v3 l=x_dut_xm5_l m=x_dut_xm5_m w=x_dut_xm5_w
XM6 vo1p vinn ptail vdd pfet_03v3 l=x_dut_xm6_l m=x_dut_xm6_m w=x_dut_xm6_w
XM7 vo1n vinp ptail vdd pfet_03v3 l=x_dut_xm7_l m=x_dut_xm7_m w=x_dut_xm7_w
XM8 ptail vcmfb1 vdd vdd pfet_03v3 l=x_dut_xm8_l m=x_dut_xm8_m w=x_dut_xm8_w
XM9 voutn vo1p vss vss nfet_03v3 l=x_dut_xm9_l m=x_dut_xm9_m w=x_dut_xm9_w
.ends
.end
