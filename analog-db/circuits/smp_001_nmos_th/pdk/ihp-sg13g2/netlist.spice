** GENERATED by `analog-db generate` — DO NOT EDIT. Source: abstract/netlist.spice → ihp-sg13g2
* smp_001_nmos_th (emitted by spicexplorer-circuitgraph)
C0 vout vss x_dut_c0_value
XM0 vin clk vout vss sg13_lv_nmos l=x_dut_xm0_l m=x_dut_xm0_m w=x_dut_xm0_w
.end
