* TB[pam4] S22 probe f=5e+10
Vcc vcc 0 PWL(0 0 8n 4)
Vcasc vcasc 0 PWL(0 0 8n 3.25)
Vcmb vcmb 0 PWL(0 0 8n 1.9)
Vblsb blsb 0 PWL(0 0 8n 16)
Vbmsb bmsb 0 PWL(0 0 8n 16)
XDUT lsbp lsbn msbp msbn outp outn vcc vcasc vcmb blsb bmsb pam4drv_pam4
Vslsbp slsbp 0 PWL(0 0 8n 1.9)
Vslsbn slsbn 0 PWL(0 0 8n 1.9)
Rslsbp slsbp lsbp 50
Rslsbn slsbn lsbn 50
Vsmsbp smsbp 0 PWL(0 0 8n 1.9)
Vsmsbn smsbn 0 PWL(0 0 8n 1.9)
Rsmsbp smsbp msbp 50
Rsmsbn smsbn msbn 50
Vsop sop 0 SIN(4 0.002 5e+10 9n)
Vson son 0 SIN(4 -0.002 5e+10 9n)
Rsop sop outp 50
Rson son outn 50
.include ../dut/dut_pam4.spice
.lib "cornerHBT.lib" hbt_typ
.options gmin=1e-12 reltol=1e-3
.control
tran 0.000333333n 9.52n uic
wrdata s22.csv v(outp)-v(outn) v(sop)-v(son)
.endc
.GLOBAL GND
.end
