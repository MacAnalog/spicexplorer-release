** GENERATED by `analog-db export-raw` — DO NOT EDIT.
** circuit=amp_019_ti_ldo_error  class=amplifier  pdk=sky130  testbench=ac_open_loop  corner=tt
** Self-contained deck: testbench + bound params + lowered DUT (.subckt amp_019_ti_ldo_error).
** PDK corner libs resolve by BARE NAME on the image's ngspice sourcepath — run in a
** PDK-enabled env (the base image / api container), NOT a bare host:
**   docker run --rm -i spicexplorer-spice-base:local \
**     bash -lc 'd=$(mktemp -d) && cat > $d/c.spice && cd $d && ngspice -b c.spice' < raw/amp_019_ti_ldo_error/sky130/ac_open_loop.spice
*----------------------------------------------------------*
** params: 19 free + 0 frozen knobs (sizing.yaml) · 10 tied · 0 ratio-derived (abstract/params.yaml) · 4 testbench params
** AUTHORED TEMPLATE — amplifier/ac_open_loop_biaswrap_ibias: the bias-wrap open-loop bench for
** DUTs on the class ibias-port convention (ports vdd vout vinp vinn ibias vss). Same trick as
** ac_open_loop_biaswrap (which hardcodes the 5-port AnalogGym order): a 1 TH inductor DC-shorts
** vout back to the INVERTING input to set the high-gain operating point (mandatory for amps with
** a large systematic offset), while a 1 TF cap AC-opens that loop and injects the stimulus.
** Bindings: DUT PORT_LINE VDD VCM CL IBIAS FSTART FSTOP PPD PDK_INCLUDE.
.lib sky130.lib.spice tt
.temp 27

.param VDD=3.3
.param VCM=1.2
.param CL=10p
.param IBIAS=1m

Vdd  vdd 0 dc {VDD}
Vss  vss 0 dc 0
Ibias vdd ibias dc {IBIAS}
Vcm  vinp 0 dc {VCM}          ; common-mode bias on the non-inverting input
Vac  sigin 0 dc 0 ac 1        ; AC stimulus
Lfb  vout vinn 1T             ; 1 TH: DC short (bias), AC open
Cin  vinn sigin 1T            ; 1 TF: DC open, AC inject into the inverting node
CLoad vout 0 {CL}

XDUT vdd vout vinp vinn ibias vss amp_019_ti_ldo_error

.control
  set filetype=ascii
  ac dec 101 10 100MEG
  meas ac dcgain FIND vdb(vout) AT=10
  meas ac ugf    WHEN vdb(vout)=0 FALL=1
  let phc = cph(vout)*180/3.14159265
  let ph  = 180 + phc - phc[0]
  meas ac pm     FIND ph WHEN vdb(vout)=0 FALL=1
  write
  quit
.endc
.param x_dut_xmb0_w=100
.param x_dut_xmb0_l=0.5
.param x_dut_xmbc_m=1
.param x_dut_xmbo_m=1
.param x_dut_xm1_w=100
.param x_dut_xm1_l=0.5
.param x_dut_xm3_w=40
.param x_dut_xm3_l=1
.param x_dut_xm4_w=10
.param x_dut_xm4_l=0.5
.param x_dut_xm7_w=20
.param x_dut_xm7_l=0.5
.param x_dut_xm6_w=80
.param x_dut_xm6_l=2
.param r_z=3000
.param c_comp=6e-12
.param x_dut_xmbe_w=12
.param x_dut_xmbf_w=25
.param r_nd=500000
* ---- GENERATED parameter ties (abstract/params.yaml groups/ratios) ----
* Each tied symbol is defined exactly once, by its line below; rewrite that
* .param to untie just that symbol (untying = shadowing, plan D-3).
.param x_dut_xmbc_l = {x_dut_xmb0_l}
.param x_dut_xmbf_l = {x_dut_xmb0_l}
.param x_dut_xmbe_l = {x_dut_xmb0_l}
.param x_dut_xmbo_l = {x_dut_xmb0_l}
.param x_dut_xmbc_w = {x_dut_xmb0_w}
.param x_dut_xmbo_w = {x_dut_xmb0_w}
.param x_dut_xm2_w = {x_dut_xm1_w}
.param x_dut_xm2_l = {x_dut_xm1_l}
.param x_dut_xm5_w = {x_dut_xm3_w}
.param x_dut_xm5_l = {x_dut_xm3_l}
.subckt amp_019_ti_ldo_error vdd vout vinp vinn ibias vss
CC ncz vout 'c_comp'
RND na nd 'r_nd'
RZ nb ncz 'r_z'
XM1 na vinn tail vss sky130_fd_pr__nfet_g5v0d10v5 l=x_dut_xm1_l w=x_dut_xm1_w
XM2 nb vinp tail vss sky130_fd_pr__nfet_g5v0d10v5 l=x_dut_xm2_l w=x_dut_xm2_w
XM3 na nd vdd vdd sky130_fd_pr__pfet_g5v0d10v5 l=x_dut_xm3_l w=x_dut_xm3_w
XM4 nlev na nd vdd sky130_fd_pr__pfet_g5v0d10v5 l=x_dut_xm4_l w=x_dut_xm4_w
XM5 nb nd vdd vdd sky130_fd_pr__pfet_g5v0d10v5 l=x_dut_xm5_l w=x_dut_xm5_w
XM6 vout ne vdd vdd sky130_fd_pr__pfet_g5v0d10v5 l=x_dut_xm6_l w=x_dut_xm6_w
XM7 ne ne nb vdd sky130_fd_pr__pfet_g5v0d10v5 l=x_dut_xm7_l w=x_dut_xm7_w
XMB0 ibias ibias vss vss sky130_fd_pr__nfet_g5v0d10v5 l=x_dut_xmb0_l w=x_dut_xmb0_w
XMBC tail ibias vss vss sky130_fd_pr__nfet_g5v0d10v5 l=x_dut_xmbc_l m=x_dut_xmbc_m w=x_dut_xmbc_w
XMBE ne ibias vss vss sky130_fd_pr__nfet_g5v0d10v5 l=x_dut_xmbe_l w=x_dut_xmbe_w
XMBF nlev ibias vss vss sky130_fd_pr__nfet_g5v0d10v5 l=x_dut_xmbf_l w=x_dut_xmbf_w
XMBO vout ibias vss vss sky130_fd_pr__nfet_g5v0d10v5 l=x_dut_xmbo_l m=x_dut_xmbo_m w=x_dut_xmbo_w
.ends
.end
