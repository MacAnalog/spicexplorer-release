** GENERATED by `analog-db export-raw` — DO NOT EDIT.
** circuit=amp_019_ti_ldo_error  class=amplifier  pdk=ihp-sg13g2  testbench=cmrr_vcm  corner=tt
** Self-contained deck: testbench + bound params + lowered DUT (.subckt amp_019_ti_ldo_error).
** PDK corner libs resolve by BARE NAME on the image's ngspice sourcepath — run in a
** PDK-enabled env (the base image / api container), NOT a bare host:
**   docker run --rm -i spicexplorer-spice-base:local \
**     bash -lc 'd=$(mktemp -d) && cat > $d/c.spice && cd $d && ngspice -b c.spice' < raw/amp_019_ti_ldo_error/ihp-sg13g2/cmrr_vcm.spice
*----------------------------------------------------------*
** params: 18 free + 0 frozen knobs (sizing.yaml) · 10 tied · 0 ratio-derived (abstract/params.yaml) · 4 testbench params
** AUTHORED TEMPLATE — amplifier/cmrr_vcm (plan D-4/D-5): common-mode rejection.
** The DUT is closed in a unity-gain buffer and the SAME 1 V AC rides on both inputs:
** Vinp carries ac 1, and the vinn–vout short (Vfb) also carries ac 1, so vinn = vout + vac.
** The differential input is then vinp − vinn = −vout while the common mode moves by a full
** volt; solving vout = Ad·(−vout) + Acm·vac gives vout ≈ (Acm/Ad)·vac = vac/CMRR, so
** CMRR = −20·log10|vout| = −vdb(vout) (vac = 1). Reported at FSTART (the DC-band floor).
** Bindings: DUT PORT_LINE VDD VCM IBIAS CL FSTART FSTOP PPD PDK_INCLUDE.
.lib cornerMOShv.lib mos_tt
.lib cornerRES.lib res_typ
.temp 27

.param VDD=3.3
.param VCM=1.2
.param IBIAS=1m
.param CL=10p

Vdd  vdd 0 dc {VDD}          ; supply quiet — isolate the common-mode path
Vss  vss 0 dc 0
Ibias vdd ibias dc {IBIAS}
CLoad vout 0 {CL}

Vinp vinp 0 dc {VCM} ac 1    ; +1 V AC on the + input ...
Vfb  vinn vout dc 0 ac 1     ; ... and the same +1 V AC lifted onto vinn (unity buffer at DC)

XDUT vdd vout vinp vinn ibias vss amp_019_ti_ldo_error

.control
  set filetype=ascii
  ac dec 101 1k 1G
  let cmrr = -vdb(vout)
  meas ac cmrr_db FIND cmrr AT=1k
  write
  quit
.endc
.param x_dut_xmb0_w=20u
.param x_dut_xmb0_l=2u
.param x_dut_xmbc_m=1
.param x_dut_xmbo_m=1
.param x_dut_xm1_w=40u
.param x_dut_xm1_l=0.7u
.param x_dut_xm3_w=40u
.param x_dut_xm3_l=0.5u
.param x_dut_xm4_w=10u
.param x_dut_xm4_l=0.5u
.param x_dut_xm7_w=20u
.param x_dut_xm7_l=0.5u
.param x_dut_xm6_w=80u
.param x_dut_xm6_l=2u
.param r_z=1k
.param c_comp=2p
.param x_dut_xmbe_w=5u
.param x_dut_xmbf_w=5u
* ---- GENERATED parameter ties (abstract/params.yaml groups/ratios) ----
* Each tied symbol is defined exactly once, by its line below; rewrite that
* .param to untie just that symbol (untying = shadowing, plan D-3).
.param x_dut_xmbc_l = {x_dut_xmb0_l}
.param x_dut_xmbf_l = {x_dut_xmb0_l}
.param x_dut_xmbe_l = {x_dut_xmb0_l}
.param x_dut_xmbo_l = {x_dut_xmb0_l}
.param x_dut_xmbc_w = {x_dut_xmb0_w}
.param x_dut_xmbo_w = {x_dut_xmb0_w}
.param x_dut_xm2_w = {x_dut_xm1_w}
.param x_dut_xm2_l = {x_dut_xm1_l}
.param x_dut_xm5_w = {x_dut_xm3_w}
.param x_dut_xm5_l = {x_dut_xm3_l}
.subckt amp_019_ti_ldo_error vdd vout vinp vinn ibias vss
CC ncz vout 'c_comp'
RZ nb ncz 'r_z'
XM1 na vinn tail vss sg13_hv_nmos l=x_dut_xm1_l w=x_dut_xm1_w
XM2 nb vinp tail vss sg13_hv_nmos l=x_dut_xm2_l w=x_dut_xm2_w
XM3 na nd vdd vdd sg13_hv_pmos l=x_dut_xm3_l w=x_dut_xm3_w
XM4 nlev na nd vdd sg13_hv_pmos l=x_dut_xm4_l w=x_dut_xm4_w
XM5 nb nd vdd vdd sg13_hv_pmos l=x_dut_xm5_l w=x_dut_xm5_w
XM6 vout ne vdd vdd sg13_hv_pmos l=x_dut_xm6_l w=x_dut_xm6_w
XM7 ne ne nb vdd sg13_hv_pmos l=x_dut_xm7_l w=x_dut_xm7_w
XMB0 ibias ibias vss vss sg13_hv_nmos l=x_dut_xmb0_l w=x_dut_xmb0_w
XMBC tail ibias vss vss sg13_hv_nmos l=x_dut_xmbc_l m=x_dut_xmbc_m w=x_dut_xmbc_w
XMBE ne ibias vss vss sg13_hv_nmos l=x_dut_xmbe_l w=x_dut_xmbe_w
XMBF nlev ibias vss vss sg13_hv_nmos l=x_dut_xmbf_l w=x_dut_xmbf_w
XMBO vout ibias vss vss sg13_hv_nmos l=x_dut_xmbo_l m=x_dut_xmbo_m w=x_dut_xmbo_w
.ends
.end
