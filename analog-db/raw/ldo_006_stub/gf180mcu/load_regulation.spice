** GENERATED by `analog-db export-raw` — DO NOT EDIT.
** circuit=ldo_006_stub  class=ldo  pdk=gf180mcu  testbench=load_regulation  corner=tt
** Self-contained deck: testbench + bound params + lowered DUT (.subckt ldo_006_stub).
** PDK corner libs resolve by BARE NAME on the image's ngspice sourcepath — run in a
** PDK-enabled env (the base image / api container), NOT a bare host:
**   docker run --rm -i spicexplorer-spice-base:local \
**     bash -lc 'd=$(mktemp -d) && cat > $d/c.spice && cd $d && ngspice -b c.spice' < raw/ldo_006_stub/gf180mcu/load_regulation.spice
*----------------------------------------------------------*
** params: 4 free + 1 frozen knobs (sizing.yaml) · 0 tied · 0 ratio-derived (abstract/params.yaml) · 1 testbench params
** AUTHORED TEMPLATE — ldo/load_regulation (plan D-10 STUB).
** Placeholder: DC load sweep measuring delta-vout per delta-iload. Completed when the
** first real LDO circuit lands; the stub exists so the class abstraction is exercised
** (template resolution + Tier 2 assembly) by a non-amplifier class.
** Bindings: DUT PORT_LINE VDD ILOAD_START ILOAD_STOP ILOAD_STEP PDK_INCLUDE.
.include design.ngspice
.lib sm141064.ngspice noise_corner
.lib sm141064.ngspice nfet_03v3_t
.lib sm141064.ngspice pfet_03v3_t
.lib sm141064.ngspice fets_mm
.temp 27

.param VDD=1.5

Vdd  vdd 0 dc {VDD}
Vss  vss 0 dc 0
Iload vout 0 dc 0

XDUT vdd vout vss ldo_006_stub

.control
  set filetype=ascii
  dc Iload 0 10m 0.5m
  meas dc vout_max MAX v(vout)
  meas dc vout_min MIN v(vout)
  let load_reg = vout_max - vout_min
  print load_reg
  write
  quit
.endc
.param x_dut_xm1_w=50u
.param x_dut_xm1_l=0.5u
.param r_top=100k
.param r_bot=100k
.param x_dut_xm1_m=1
.subckt ldo_006_stub vdd vout vss
R1 vdd vref r_top
R2 vref vss r_bot
XM1 vdd vref vout vss nfet_03v3 l=x_dut_xm1_l m=x_dut_xm1_m w=x_dut_xm1_w
.ends
.end
