** AUTHORED TEMPLATE — amplifier/ac_open_loop_diff (fully-differential open-loop AC).
** Open-loop DIFFERENTIAL gain/phase of a self-biased FD OTA (internal current reference,
** no external ibias port; e.g. amp_020_two_stage_miller_cmfb). Differential input driven directly
** — no AnalogGym-style bias-wrap needed: unlike a single-ended amp with no output
** feedback of any kind, a genuinely SYMMETRIC differential topology driven by MATCHED
** (vinp=vinn=VCM) inputs gives a well-defined output OFFSET regardless of open-loop gain
** — both branches move together, not apart, so there is nothing for the gain to amplify
** into a rail. (The output COMMON MODE still has to be centered by sizing — see
** pdk/<pdk>/sizing.yaml — but that's a device-sizing concern, not a testbench one.)
**
** Required bindings: DUT (subckt name), PORT_LINE (instance port order = circuit.yaml
**   ports: vinp vinn voutp voutn vdd vss), VDD VCM CL, FSTART FSTOP PPD,
**   PDK_INCLUDE (.lib/.include lines for the bound PDK+corner).
*----------------------------------------------------------*
${PDK_INCLUDE}

.param VDD=${VDD}
.param VCM=${VCM}
.param CL=${CL}

Vdd  vdd 0 dc {VDD}
Vss  vss 0 dc 0
CLoadp voutp 0 {CL}
CLoadn voutn 0 {CL}

* DUT instance (port order = circuit.yaml ports)
${PORT_LINE} ${DUT}

* --- input drive (AC open loop, differential) ---
Vcm  vcm 0 dc {VCM}
Vinp vinp vcm dc 0 ac 0.5
Vinn vinn vcm dc 0 ac -0.5

.control
  set filetype=ascii
  ac dec ${PPD} ${FSTART} ${FSTOP}
  let vodm = v(voutp) - v(voutn)
  * db()/cph() must be precomputed as their own vectors before use in .meas FIND/WHEN —
  * ngspice's vdb()/cph() shorthand only resolves against real circuit nodes, not a
  * `let`-derived vector like vodm, so a bare `FIND db(vodm)` fails to resolve.
  let dbvodm = db(vodm)
  meas ac dcgain  FIND dbvodm  AT=${FSTART}
  meas ac ugf     WHEN dbvodm=0 FALL=1
  * cph() = continuous (unwrapped) phase — vp() wraps at +/-180 and corrupts PM for
  * multi-pole phase trajectories; normalize to the DC phase so PM = 180 - total phase lag.
  let phc = cph(vodm)*180/3.14159265
  let ph = 180 + phc - phc[0]
  meas ac pm      FIND ph WHEN dbvodm=0 FALL=1
  write
  quit
.endc
.end
