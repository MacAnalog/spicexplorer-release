** GENERATED by `analog-db export-raw` — DO NOT EDIT.
** circuit=amp_032_ti_ldo_error_selfbias  class=amplifier  pdk=sky130  testbench=ac_closed_loop  corner=tt
** Self-contained deck: testbench + bound params + lowered DUT (.subckt amp_032_ti_ldo_error_selfbias).
** PDK corner libs resolve by BARE NAME on the image's ngspice sourcepath — run in a
** PDK-enabled env (the base image / api container), NOT a bare host:
**   docker run --rm -i spicexplorer-spice-base:local \
**     bash -lc 'd=$(mktemp -d) && cat > $d/c.spice && cd $d && ngspice -b c.spice' < raw/amp_032_ti_ldo_error_selfbias/sky130/ac_closed_loop.spice
*----------------------------------------------------------*
** params: 18 free + 0 frozen knobs (sizing.yaml) · 9 tied · 0 ratio-derived (abstract/params.yaml) · 3 testbench params
** AUTHORED TEMPLATE — amplifier/ac_closed_loop_selfbias (2026-07-20): unity-gain buffer AC
** response for SELF-BIASED DUTs (no ibias port). Identical to `ac_closed_loop` except there is no
** external bias source — derived exactly as psrr_vdd_selfbias derives from psrr_vdd (drop
** `.param IBIAS` and the `Ibias` line), so a 5-port [vdd vout vinp vinn vss] DUT does not leave a
** current source driving a dangling `ibias` node (which makes the DC solve singular).
** Unity-gain buffer: vinn shorted to vout (0 V source). This is the analog-circuit-design CACE
** "voltage buffer" measurement (gain ~1, -3 dB bandwidth).
** Bindings: DUT PORT_LINE VDD VCM CL FSTART FSTOP PPD PDK_INCLUDE.
.lib sky130.lib.spice tt
.temp 27

.param VDD=1.8
.param VCM=0.9
.param CL=10p

Vdd  vdd 0 dc {VDD}
Vss  vss 0 dc 0
CLoad vout 0 {CL}

Vinp vinp 0 dc {VCM} ac 1
Vfb  vinn vout dc 0

XDUT vdd vout vinp vinn vss amp_032_ti_ldo_error_selfbias

.control
  set filetype=ascii
  ac dec 101 1k 1G
  meas ac gain_cl FIND vmag(vout) AT=1k
  let g3db = gain_cl/sqrt(2)
  meas ac bw_cl WHEN vmag(vout)=g3db FALL=1
  write
  quit
.endc
.param x_dut_xmbp_w=41.49398303677232
.param x_dut_xmbp_l=2.329224498945873
.param x_dut_xmb0_w=58.50180313844321
.param x_dut_xmb0_l=1.482196715977639
.param x_dut_xmbc_m=1
.param x_dut_xmbo_m=1
.param x_dut_xm1_w=54.99700606429666
.param x_dut_xm1_l=0.47938582647537475
.param x_dut_xm3_w=87.01219712226481
.param x_dut_xm3_l=3.4338542074883858
.param x_dut_xm4_w=96.52927518861148
.param x_dut_xm4_l=4.243509159874362
.param x_dut_xm6_w=22.347200240809872
.param x_dut_xm6_l=1.08924987055143
.param r_z=30158.889051230384
.param c_comp=1.0277210259907484e-11
.param x_dut_xmbf_w=9.512915640352748
.param r_nd=7561703.647450356
* ---- GENERATED parameter ties (abstract/params.yaml groups/ratios) ----
* Each tied symbol is defined exactly once, by its line below; rewrite that
* .param to untie just that symbol (untying = shadowing, plan D-3).
.param x_dut_xmbc_l = {x_dut_xmb0_l}
.param x_dut_xmbf_l = {x_dut_xmb0_l}
.param x_dut_xmbo_l = {x_dut_xmb0_l}
.param x_dut_xmbc_w = {x_dut_xmb0_w}
.param x_dut_xmbo_w = {x_dut_xmb0_w}
.param x_dut_xm2_w = {x_dut_xm1_w}
.param x_dut_xm2_l = {x_dut_xm1_l}
.param x_dut_xm5_w = {x_dut_xm3_w}
.param x_dut_xm5_l = {x_dut_xm3_l}
.subckt amp_032_ti_ldo_error_selfbias vdd vout vinp vinn vss
CC ncz vout 'c_comp'
RND na nd 'r_nd'
RZ nb ncz 'r_z'
XM1 na vinn tail vss sky130_fd_pr__nfet_01v8 l=x_dut_xm1_l w=x_dut_xm1_w
XM2 nb vinp tail vss sky130_fd_pr__nfet_01v8 l=x_dut_xm2_l w=x_dut_xm2_w
XM3 na nd vdd vdd sky130_fd_pr__pfet_01v8 l=x_dut_xm3_l w=x_dut_xm3_w
XM4 nlev na nd vdd sky130_fd_pr__pfet_01v8 l=x_dut_xm4_l w=x_dut_xm4_w
XM5 nb nd vdd vdd sky130_fd_pr__pfet_01v8 l=x_dut_xm5_l w=x_dut_xm5_w
XM6 vout nb vdd vdd sky130_fd_pr__pfet_01v8 l=x_dut_xm6_l w=x_dut_xm6_w
XMB0 ibias ibias vss vss sky130_fd_pr__nfet_01v8 l=x_dut_xmb0_l w=x_dut_xmb0_w
XMBC tail ibias vss vss sky130_fd_pr__nfet_01v8 l=x_dut_xmbc_l m=x_dut_xmbc_m w=x_dut_xmbc_w
XMBF nlev ibias vss vss sky130_fd_pr__nfet_01v8 l=x_dut_xmbf_l w=x_dut_xmbf_w
XMBO vout ibias vss vss sky130_fd_pr__nfet_01v8 l=x_dut_xmbo_l m=x_dut_xmbo_m w=x_dut_xmbo_w
XMBP ibias ibias vdd vdd sky130_fd_pr__pfet_01v8 l=x_dut_xmbp_l w=x_dut_xmbp_w
.ends
.end
