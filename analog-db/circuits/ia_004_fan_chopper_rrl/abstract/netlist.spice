** GENERATED by `analog-db generate` — DO NOT EDIT. Source: composition.yaml (composer, plan P4)
** Composite: ia_004_fan_chopper_rrl = cmfb(cmfb_001_ideal_rsense_servo @ 9c8861186398) + main(ia_002_fan_chopper_simple @ db0af98f1e15) + rrl(sup_003_rrl_sc_integrator @ e5616a7d6d6d)
** Fan (JSSC 2011) ripple-reduction architecture: the RRL (sup_003) senses the CCIA output ripple capacitively (its Cs front end on voutp/voutn), demodulates it synchronously (its internal chopper's clk_ch_rrl wired to the SAME clk_chout pair that up-modulates the core's offset — the drawn CLK_CH_RRL_not polarity is baked inside sup_003), integrates it through a two-phase SC network, and injects the DC correction at the first-stage outputs out1_p/out1_n (taps; PRE output chopper — where the input pair's offset current lives). The correction is CROSS-wired to the taps (rrl voutp -> out1_n, voutn -> out1_p) as the intended negative-feedback orientation for sup_003's drawn clock polarity. CORE-CM CLOSURE (P4-4b, 2026-07-27 — supersedes the 2026-07-17 honest limitation): the composed core previously had no common-mode control, so once the SC clocks ran the output CM railed within ~1-2 ms and every clocked transient aborted — the RRL was structurally present but not demonstrable. Now closed with the cmfb_001 ideal resistive-sense servo (amp_030's pattern): Rm/Rm senses voutp/voutn, and the correction injects on the core's Vb4 — the shared PMOS current-source gate (tail + fold + output sources), the node amp_027 exposes as V_cmfb_ref (the vb1-injection attempt could not reach the railing tail). POLARITY IS MEASURED, NOT ASSUMED: on this core d(vocm)/d(vb4) is POSITIVE (vb4 -10 mV rails vocm to 0.009 V, +10 mV rails it to 1.17 V — the two-stage path inverts the naive single-stage sign), so the servo's canonical vcmfb = gm*rout*(vref - vocm) orientation IS negative feedback here. RANGE-REFERENCING (amp_030's principle, TIGHTENED live): the series {vb40} source carries the DC bias point (the block's committed vb4) and the servo contributes only a gain-0.1 correction (rout_val override 1k, gm*rout = 0.1, authority +/-60 mV). Gain 1 was NOT enough here: this core's vb4->vocm map is non-monotone (large vb4 cuts the PMOS sources off and vocm collapses), and the +/-0.6 V drive made the cut-off state self-consistent — a latched dead point, measured live (vocm 0.004, drive saturated +0.596). At +/-60 mV neither rail satisfies the loop equation and only the interior equilibrium survives. The composite, as instantiator, owns vb40/vcm_ref (plan D3).
**.subckt ia_004_fan_chopper_rrl vinp vinn voutp voutn vref clk_chin clk_chin_not clk_chfb clk_chfb_not clk_chout clk_chout_not clk_phi_1 clk_phi_2 vdd vss
* --- instance cmfb: cmfb_001_ideal_rsense_servo @ 9c8861186398 ---
Gm_servo_CMFB vss vcmfb_raw vref_cm cmfb__cm_sense {gm_val_cmfb}
Rout_servo_CMFB vss vcmfb_raw 'rout_val_cmfb'
Cout_servo_CMFB vss vcmfb_raw 'cout_val_cmfb'
Rin_servo_CMFB cmfb__cm_sense vref_cm 'rin_val_cmfb'
Cin_servo_CMFB cmfb__cm_sense vref_cm 'cin_val_cmfb'
Rmp_CMFB cmfb__cm_sense voutp 'x_dut_rmp_cmfb_value'
Rmn_CMFB voutn cmfb__cm_sense 'x_dut_rmn_cmfb_value'
* --- instance main: ia_002_fan_chopper_simple @ db0af98f1e15 (omit: Vb4) ---
XM1_MAIN main__tail vb4_ctl vdd vdd pmos w=x_dut_xm1_main_w l=x_dut_xm1_main_l m=x_dut_xm1_main_m
XM2_MAIN main__fold_p main__vsum_p main__tail vdd pmos w=x_dut_xm2_main_w l=x_dut_xm2_main_l m=x_dut_xm2_main_m
XM3_MAIN main__fold_n main__vsum_n main__tail vdd pmos w=x_dut_xm3_main_w l=x_dut_xm3_main_l m=x_dut_xm3_main_m
XM4_MAIN main__fold_p main__vb1 vss vss nmos w=x_dut_xm4_main_w l=x_dut_xm4_main_l m=x_dut_xm4_main_m
XM5_MAIN main__fold_n main__vb1 vss vss nmos w=x_dut_xm5_main_w l=x_dut_xm5_main_l m=x_dut_xm5_main_m
XM12_MAIN out1_p main__vb2 main__fold_p vss nmos w=x_dut_xm12_main_w l=x_dut_xm12_main_l m=x_dut_xm12_main_m
XM13_MAIN out1_n main__vb2 main__fold_n vss nmos w=x_dut_xm13_main_w l=x_dut_xm13_main_l m=x_dut_xm13_main_m
XM6_MAIN main__casc_src_n vb4_ctl vdd vdd pmos w=x_dut_xm6_main_w l=x_dut_xm6_main_l m=x_dut_xm6_main_m
XM7_MAIN main__casc_src_p vb4_ctl vdd vdd pmos w=x_dut_xm7_main_w l=x_dut_xm7_main_l m=x_dut_xm7_main_m
XM10_MAIN out1_n main__vb3 main__casc_src_n vdd pmos w=x_dut_xm10_main_w l=x_dut_xm10_main_l m=x_dut_xm10_main_m
XM11_MAIN out1_p main__vb3 main__casc_src_p vdd pmos w=x_dut_xm11_main_w l=x_dut_xm11_main_l m=x_dut_xm11_main_m
XM16_MAIN out1_n clk_chout main__g2_n vss nmos w=x_dut_xm16_main_w l=x_dut_xm16_main_l m=x_dut_xm16_main_m
XM17_MAIN main__g2_n clk_chout_not out1_n vdd pmos w=x_dut_xm17_main_w l=x_dut_xm17_main_l m=x_dut_xm17_main_m
XM18_MAIN out1_p clk_chout main__g2_p vss nmos w=x_dut_xm18_main_w l=x_dut_xm18_main_l m=x_dut_xm18_main_m
XM19_MAIN main__g2_p clk_chout_not out1_p vdd pmos w=x_dut_xm19_main_w l=x_dut_xm19_main_l m=x_dut_xm19_main_m
XM28_MAIN out1_n clk_chout_not main__g2_p vss nmos w=x_dut_xm28_main_w l=x_dut_xm28_main_l m=x_dut_xm28_main_m
XM29_MAIN main__g2_p clk_chout out1_n vdd pmos w=x_dut_xm29_main_w l=x_dut_xm29_main_l m=x_dut_xm29_main_m
XM30_MAIN out1_p clk_chout_not main__g2_n vss nmos w=x_dut_xm30_main_w l=x_dut_xm30_main_l m=x_dut_xm30_main_m
XM31_MAIN main__g2_n clk_chout out1_p vdd pmos w=x_dut_xm31_main_w l=x_dut_xm31_main_l m=x_dut_xm31_main_m
XM8_MAIN voutp vb4_ctl vdd vdd pmos w=x_dut_xm8_main_w l=x_dut_xm8_main_l m=x_dut_xm8_main_m
XM14_MAIN voutp main__g2_p vss vss nmos w=x_dut_xm14_main_w l=x_dut_xm14_main_l m=x_dut_xm14_main_m
XM9_MAIN voutn vb4_ctl vdd vdd pmos w=x_dut_xm9_main_w l=x_dut_xm9_main_l m=x_dut_xm9_main_m
XM15_MAIN voutn main__g2_n vss vss nmos w=x_dut_xm15_main_w l=x_dut_xm15_main_l m=x_dut_xm15_main_m
Cm1_MAIN main__g2_p voutp 'x_dut_cm1_main_value'
Cm2_MAIN main__g2_n voutn 'x_dut_cm2_main_value'
Vb1_MAIN main__vb1 vss dc {vb1_main}
Vb2_MAIN main__vb2 vss dc {vb2_main}
Vb3_MAIN main__vb3 vss dc {vb3_main}
XM24_MAIN vinn clk_chin main__inch_n vss nmos w=x_dut_xm24_main_w l=x_dut_xm24_main_l m=x_dut_xm24_main_m
XM25_MAIN main__inch_n clk_chin_not vinn vdd pmos w=x_dut_xm25_main_w l=x_dut_xm25_main_l m=x_dut_xm25_main_m
XM26_MAIN vinp clk_chin main__inch_p vss nmos w=x_dut_xm26_main_w l=x_dut_xm26_main_l m=x_dut_xm26_main_m
XM27_MAIN main__inch_p clk_chin_not vinp vdd pmos w=x_dut_xm27_main_w l=x_dut_xm27_main_l m=x_dut_xm27_main_m
XM32_MAIN vinn clk_chin_not main__inch_p vss nmos w=x_dut_xm32_main_w l=x_dut_xm32_main_l m=x_dut_xm32_main_m
XM33_MAIN main__inch_p clk_chin vinn vdd pmos w=x_dut_xm33_main_w l=x_dut_xm33_main_l m=x_dut_xm33_main_m
XM34_MAIN vinp clk_chin_not main__inch_n vss nmos w=x_dut_xm34_main_w l=x_dut_xm34_main_l m=x_dut_xm34_main_m
XM35_MAIN main__inch_n clk_chin vinp vdd pmos w=x_dut_xm35_main_w l=x_dut_xm35_main_l m=x_dut_xm35_main_m
Cin1_MAIN main__vsum_n main__inch_n 'x_dut_cin1_main_value'
Cin2_MAIN main__vsum_p main__inch_p 'x_dut_cin2_main_value'
Rb1_MAIN main__vsum_n vref 'x_dut_rb1_main_value'
Rb2_MAIN main__vsum_p vref 'x_dut_rb2_main_value'
XM20_MAIN main__fbch_p clk_chfb voutp vss nmos w=x_dut_xm20_main_w l=x_dut_xm20_main_l m=x_dut_xm20_main_m
XM21_MAIN voutp clk_chfb_not main__fbch_p vdd pmos w=x_dut_xm21_main_w l=x_dut_xm21_main_l m=x_dut_xm21_main_m
XM22_MAIN main__fbch_n clk_chfb voutn vss nmos w=x_dut_xm22_main_w l=x_dut_xm22_main_l m=x_dut_xm22_main_m
XM23_MAIN voutn clk_chfb_not main__fbch_n vdd pmos w=x_dut_xm23_main_w l=x_dut_xm23_main_l m=x_dut_xm23_main_m
XM36_MAIN main__fbch_p clk_chfb_not voutn vss nmos w=x_dut_xm36_main_w l=x_dut_xm36_main_l m=x_dut_xm36_main_m
XM37_MAIN voutn clk_chfb main__fbch_p vdd pmos w=x_dut_xm37_main_w l=x_dut_xm37_main_l m=x_dut_xm37_main_m
XM38_MAIN main__fbch_n clk_chfb_not voutp vss nmos w=x_dut_xm38_main_w l=x_dut_xm38_main_l m=x_dut_xm38_main_m
XM39_MAIN voutp clk_chfb main__fbch_n vdd pmos w=x_dut_xm39_main_w l=x_dut_xm39_main_l m=x_dut_xm39_main_m
Cfb1_MAIN main__fbch_p main__vsum_n 'x_dut_cfb1_main_value'
Cfb2_MAIN main__fbch_n main__vsum_p 'x_dut_cfb2_main_value'
* --- instance rrl: sup_003_rrl_sc_integrator @ e5616a7d6d6d ---
XM1_CHRRL_1_RRL rrl__sum_p clk_chout rrl__sc_p vss nmos w=x_dut_xm1_chrrl_1_rrl_w l=x_dut_xm1_chrrl_1_rrl_l m=x_dut_xm1_chrrl_1_rrl_m
XM2_CHRRL_1_RRL rrl__sc_p clk_chout_not rrl__sum_p vdd pmos w=x_dut_xm2_chrrl_1_rrl_w l=x_dut_xm2_chrrl_1_rrl_l m=x_dut_xm2_chrrl_1_rrl_m
XM1_CHRRL_2_RRL rrl__sum_n clk_chout rrl__sc_n vss nmos w=x_dut_xm1_chrrl_2_rrl_w l=x_dut_xm1_chrrl_2_rrl_l m=x_dut_xm1_chrrl_2_rrl_m
XM2_CHRRL_2_RRL rrl__sc_n clk_chout_not rrl__sum_n vdd pmos w=x_dut_xm2_chrrl_2_rrl_w l=x_dut_xm2_chrrl_2_rrl_l m=x_dut_xm2_chrrl_2_rrl_m
XM1_CHRRL_3_RRL rrl__sum_p clk_chout_not rrl__sc_n vss nmos w=x_dut_xm1_chrrl_3_rrl_w l=x_dut_xm1_chrrl_3_rrl_l m=x_dut_xm1_chrrl_3_rrl_m
XM2_CHRRL_3_RRL rrl__sc_n clk_chout rrl__sum_p vdd pmos w=x_dut_xm2_chrrl_3_rrl_w l=x_dut_xm2_chrrl_3_rrl_l m=x_dut_xm2_chrrl_3_rrl_m
XM1_CHRRL_4_RRL rrl__sum_n clk_chout_not rrl__sc_p vss nmos w=x_dut_xm1_chrrl_4_rrl_w l=x_dut_xm1_chrrl_4_rrl_l m=x_dut_xm1_chrrl_4_rrl_m
XM2_CHRRL_4_RRL rrl__sc_p clk_chout rrl__sum_n vdd pmos w=x_dut_xm2_chrrl_4_rrl_w l=x_dut_xm2_chrrl_4_rrl_l m=x_dut_xm2_chrrl_4_rrl_m
Cs1_RRL voutp rrl__sc_p 'x_dut_cs1_rrl_value'
Cs2_RRL voutn rrl__sc_n 'x_dut_cs2_rrl_value'
XM1_S2_RRL rrl__sc_p clk_phi_2 vss vss nmos w=x_dut_xm1_s2_rrl_w l=x_dut_xm1_s2_rrl_l m=x_dut_xm1_s2_rrl_m
XM2_S2_RRL vss clk_phi_1 rrl__sc_p vdd pmos w=x_dut_xm2_s2_rrl_w l=x_dut_xm2_s2_rrl_l m=x_dut_xm2_s2_rrl_m
XM1_S1_RRL rrl__sc_n clk_phi_2 vss vss nmos w=x_dut_xm1_s1_rrl_w l=x_dut_xm1_s1_rrl_l m=x_dut_xm1_s1_rrl_m
XM2_S1_RRL vss clk_phi_1 rrl__sc_n vdd pmos w=x_dut_xm2_s1_rrl_w l=x_dut_xm2_s1_rrl_l m=x_dut_xm2_s1_rrl_m
Caz1_RRL rrl__sum_p rrl__oa_inp 'x_dut_caz1_rrl_value'
Caz2_RRL rrl__sum_n rrl__oa_inn 'x_dut_caz2_rrl_value'
XM1_S3_RRL rrl__oa_inp clk_phi_2 rrl__oa_outn vss nmos w=x_dut_xm1_s3_rrl_w l=x_dut_xm1_s3_rrl_l m=x_dut_xm1_s3_rrl_m
XM2_S3_RRL rrl__oa_outn clk_phi_1 rrl__oa_inp vdd pmos w=x_dut_xm2_s3_rrl_w l=x_dut_xm2_s3_rrl_l m=x_dut_xm2_s3_rrl_m
XM1_S4_RRL rrl__oa_inn clk_phi_2 rrl__oa_outp vss nmos w=x_dut_xm1_s4_rrl_w l=x_dut_xm1_s4_rrl_l m=x_dut_xm1_s4_rrl_m
XM2_S4_RRL rrl__oa_outp clk_phi_1 rrl__oa_inn vdd pmos w=x_dut_xm2_s4_rrl_w l=x_dut_xm2_s4_rrl_l m=x_dut_xm2_s4_rrl_m
XM1_S5_RRL rrl__oa_outn clk_phi_1 rrl__int_p vss nmos w=x_dut_xm1_s5_rrl_w l=x_dut_xm1_s5_rrl_l m=x_dut_xm1_s5_rrl_m
XM2_S5_RRL rrl__int_p clk_phi_2 rrl__oa_outn vdd pmos w=x_dut_xm2_s5_rrl_w l=x_dut_xm2_s5_rrl_l m=x_dut_xm2_s5_rrl_m
XM1_S6_RRL rrl__oa_outp clk_phi_1 rrl__int_n vss nmos w=x_dut_xm1_s6_rrl_w l=x_dut_xm1_s6_rrl_l m=x_dut_xm1_s6_rrl_m
XM2_S6_RRL rrl__int_n clk_phi_2 rrl__oa_outp vdd pmos w=x_dut_xm2_s6_rrl_w l=x_dut_xm2_s6_rrl_l m=x_dut_xm2_s6_rrl_m
Cint1_RRL rrl__sum_p rrl__int_p 'x_dut_cint1_rrl_value'
Cint2_RRL rrl__sum_n rrl__int_n 'x_dut_cint2_rrl_value'
XM1_OPAMP_RRL rrl__oa_tail rrl__vb3 vdd vdd pmos w=x_dut_xm1_opamp_rrl_w l=x_dut_xm1_opamp_rrl_l m=x_dut_xm1_opamp_rrl_m
XM2_OPAMP_RRL rrl__oa_d1n rrl__oa_inp rrl__oa_tail vdd pmos w=x_dut_xm2_opamp_rrl_w l=x_dut_xm2_opamp_rrl_l m=x_dut_xm2_opamp_rrl_m
XM3_OPAMP_RRL rrl__oa_d1p rrl__oa_inn rrl__oa_tail vdd pmos w=x_dut_xm3_opamp_rrl_w l=x_dut_xm3_opamp_rrl_l m=x_dut_xm3_opamp_rrl_m
XM9_OPAMP_RRL rrl__oa_outn rrl__vb1 rrl__oa_d1n vdd pmos w=x_dut_xm9_opamp_rrl_w l=x_dut_xm9_opamp_rrl_l m=x_dut_xm9_opamp_rrl_m
XM10_OPAMP_RRL rrl__oa_outp rrl__vb1 rrl__oa_d1p vdd pmos w=x_dut_xm10_opamp_rrl_w l=x_dut_xm10_opamp_rrl_l m=x_dut_xm10_opamp_rrl_m
XM11_OPAMP_RRL rrl__oa_outn rrl__vb2 rrl__oa_csrc_n vss nmos w=x_dut_xm11_opamp_rrl_w l=x_dut_xm11_opamp_rrl_l m=x_dut_xm11_opamp_rrl_m
XM12_OPAMP_RRL rrl__oa_outp rrl__vb2 rrl__oa_csrc_p vss nmos w=x_dut_xm12_opamp_rrl_w l=x_dut_xm12_opamp_rrl_l m=x_dut_xm12_opamp_rrl_m
XM13_OPAMP_RRL rrl__oa_csrc_n rrl__oa_cm_bias vss vss nmos w=x_dut_xm13_opamp_rrl_w l=x_dut_xm13_opamp_rrl_l m=x_dut_xm13_opamp_rrl_m
XM14_OPAMP_RRL rrl__oa_csrc_p rrl__oa_cm_bias vss vss nmos w=x_dut_xm14_opamp_rrl_w l=x_dut_xm14_opamp_rrl_l m=x_dut_xm14_opamp_rrl_m
XM4_OPAMP_RRL rrl__oa_cm_tail rrl__vb3 vdd vdd pmos w=x_dut_xm4_opamp_rrl_w l=x_dut_xm4_opamp_rrl_l m=x_dut_xm4_opamp_rrl_m
XM5_OPAMP_RRL rrl__oa_cm_sense rrl__oa_outn rrl__oa_cm_tail vdd pmos w=x_dut_xm5_opamp_rrl_w l=x_dut_xm5_opamp_rrl_l m=x_dut_xm5_opamp_rrl_m
XM7_OPAMP_RRL rrl__oa_cm_sense rrl__oa_outp rrl__oa_cm_tail vdd pmos w=x_dut_xm7_opamp_rrl_w l=x_dut_xm7_opamp_rrl_l m=x_dut_xm7_opamp_rrl_m
XM6_OPAMP_RRL rrl__oa_cm_bias rrl__vb4 rrl__oa_cm_tail vdd pmos w=x_dut_xm6_opamp_rrl_w l=x_dut_xm6_opamp_rrl_l m=x_dut_xm6_opamp_rrl_m
XM8_OPAMP_RRL rrl__oa_cm_bias rrl__vb4 rrl__oa_cm_tail vdd pmos w=x_dut_xm8_opamp_rrl_w l=x_dut_xm8_opamp_rrl_l m=x_dut_xm8_opamp_rrl_m
XM15_OPAMP_RRL rrl__oa_cm_bias rrl__oa_cm_bias vss vss nmos w=x_dut_xm15_opamp_rrl_w l=x_dut_xm15_opamp_rrl_l m=x_dut_xm15_opamp_rrl_m
XM16_OPAMP_RRL rrl__oa_cm_sense rrl__oa_cm_sense vss vss nmos w=x_dut_xm16_opamp_rrl_w l=x_dut_xm16_opamp_rrl_l m=x_dut_xm16_opamp_rrl_m
Vb1_RRL rrl__vb1 vss dc {vb1_rrl}
Vb2_RRL rrl__vb2 vss dc {vb2_rrl}
Vb3_RRL rrl__vb3 vss dc {vb3_rrl}
Vb4_RRL rrl__vb4 vss dc {vb4_rrl}
Gm_1_RRL out1_p out1_n rrl__int_p rrl__int_n {gm_val_rrl}
Rout_1_RRL out1_p out1_n 'rout_val_rrl'
Rin_1_RRL rrl__int_p rrl__int_n 'rin_val_rrl'
Cout_1_RRL out1_p out1_n 'cout_val_rrl'
Cin_1_RRL rrl__int_p rrl__int_n 'cin_val_rrl'
* --- composite-owned nets ---
Vrefcm vref_cm vss dc {vcm_ref}
Vb40 vb4_ctl vcmfb_raw dc {vb40}
**.ends
.end
