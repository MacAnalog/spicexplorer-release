** AUTHORED TEMPLATE — amplifier/cmrr_vcm_selfbias (plan D-4/D-5): common-mode rejection
** for self-biased DUTs (no ibias port — the AnalogGym amplifiers). Identical to cmrr_vcm
** except there is no external bias source. The DUT is closed in a unity-gain buffer and the
** SAME 1 V AC rides on both inputs (Vinp ac 1, and the vinn–vout short also ac 1, so
** vinn = vout + vac); the differential input is −vout while the common mode moves by a full
** volt, giving vout ≈ (Acm/Ad)·vac = vac/CMRR and CMRR = −vdb(vout). Reported at FSTART.
** The unity-buffer DC op point is the same one the ac_open_loop_biaswrap bench already
** proves out for these DUTs, so biasing is safe.
** Bindings: DUT PORT_LINE VDD VCM CL FSTART FSTOP PPD PDK_INCLUDE.
${PDK_INCLUDE}

.param VDD=${VDD}
.param VCM=${VCM}
.param CL=${CL}

Vdd  vdd 0 dc {VDD}          ; supply quiet — isolate the common-mode path
Vss  vss 0 dc 0
CLoad vout 0 {CL}

Vinp vinp 0 dc {VCM} ac 1    ; +1 V AC on the + input ...
Vfb  vinn vout dc 0 ac 1     ; ... and the same +1 V AC lifted onto vinn (unity buffer at DC)

${PORT_LINE} ${DUT}

.control
  set filetype=ascii
  ac dec ${PPD} ${FSTART} ${FSTOP}
  let cmrr = -vdb(vout)
  meas ac cmrr_db FIND cmrr AT=${FSTART}
  write
  quit
.endc
.end
