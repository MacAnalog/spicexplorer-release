** Abstract two-stage fully-differential OTA with per-side Monticelli class-AB output
** stages and a behavioral (VCCS-macromodel) CMFB servo — the class-AB OTA core of the
** Hsu bandpass instrumentation amplifier (see provenance in circuit.yaml). AUTHORED
** source of truth (plan D-2). PDK-neutral model tokens (nmos/pmos); per-PDK device
** names + geometry come from circuitgraph lowering + pdk/<pdk>/{devices.map,sizing}.yaml.
** Subckt port order (= circuit.yaml ports): vinp vinn voutp voutn vdd vss
**
** Topology (from drawings/ccia-01-YuPinHsu-bandpass-class-ab-output/simulation/
** ccia-dut.spice, subckt two-stage-ota-core, flattened by hand after xschem netlisting):
**   stage 1 — PMOS input pair XM2/XM3 (tail XM1, gate vb1) with NMOS diode loads
**     XM4/XM5.
**   stage 2 — NMOS mirrors XM6/XM8 (gates on the stage-1 diodes) cascoded by XM7/XM9
**     (gate vb3), folded against PMOS cascodes XM10/XM11 (gate vb2) that are fed by the
**     CMFB-controlled sources XM12/XM13 (gates on the servo output vcmfb). The cascode
**     drain pairs are the high-impedance class-AB drive nodes drv_p/drv_n.
**   output — per-side Monticelli-style class-AB stages. voutp: current source XM14
**     (gate vb1) through the stacked level-shifter diodes XM15 (NMOS) / XM17 (PMOS)
**     down to the sink XM19 (gate drv_p); push-pull followers XM16 (NMOS, gate gnf_p)
**     / XM18 (PMOS, gate gpf_p); Miller C1+R1 from the class-AB battery midnode abm_p
**     to drv_p. voutn: XM20-XM25 mirror image (C2+R2 from abm_n to drv_n).
**   CMFB — resistive CM detector Rmp/Rmn on voutp/voutn (node cm_det) into a behavioral
**     servo: flattened ideal-amp-fully-diff macromodel (VCCS Gm + Rout/Cout on the
**     output, Rin/Cin across the sense pair) whose output vcmfb drives XM12/XM13.
**   drawing conformance + entry-level deviations:
**     - the drawn subckt ports Vb1/Vb2/Vb3 and vcmfb_ref become internal knob-driven
**       dc sources {vb1}/{vb2}/{vb3}/{vcmfb_ref} (instantiator owns bias); the old
**       drawn port-name typo vcmbf_ref is FIXED IN THE DRAWING (DRAWING_REVIEW
**       item 5) — the entry's vcmfb_ref matches the drawing.
**     - R1/R2 both carry the shared symbol Rz — the old Rz/RZ case collision is
**       FIXED IN THE DRAWING (DRAWING_REVIEW item 5); atomized here as
**       x_dut_r1_value/x_dut_r2_value + a shared_geometry tie (likewise C1/C2
**       value Cc), the standard per-device-symbol + tie parameterization.
**     - CMFB servo polarity MATCHES the drawing (DRAWING_REVIEW item 3 FIXED:
**       owner re-routed cmfb-output-ideal-amp so vref drives the + input and the
**       CM detector the - input). The Gm card's {ctrl+ = vcmfb_ref,
**       ctrl- = cm_det} is exactly the fixed drawing's hookup: the CM loop's
**       inversion count is odd (XM12/13 pmos CS -> drv, XM19/25 nmos CS -> gate
**       stacks, followers non-inverting) and the servo regulates.
**     - the cmfb-output-ideal-amp / ideal-amp-fully-diff / vcm-detector-simple hierarchy
**       is flattened into this body (the ideal amp's unused inverting output is the
**       drawn tie to VSS — Gm/Rout/Cout keep that node). Nets renamed for readability
**       (net1->tail, net2->mir_p, net3->mir_n, net4->csrc_n, net5->csrc_p,
**       net6->psrc_n, net7->psrc_p, net8->drv_n, net_A->drv_p, net9->gnf_p,
**       net_B->abm_p, net10->zc_p, net11->gpf_p, net12->gnf_n, net13->abm_n,
**       net14->gpf_n, net15->zc_n, v_cmfb_out->vcmfb, cmfb net1->cm_det).
**.subckt amp_025_hsu_classab_ota vinp vinn voutp voutn vdd vss
* --- stage 1: PMOS input pair + tail, NMOS diode loads ---
XM1 tail vb1 vdd vdd pmos w=x_dut_xm1_w l=x_dut_xm1_l m=x_dut_xm1_m
XM2 mir_p vinn tail vdd pmos w=x_dut_xm2_w l=x_dut_xm2_l m=x_dut_xm2_m
XM3 mir_n vinp tail vdd pmos w=x_dut_xm3_w l=x_dut_xm3_l m=x_dut_xm3_m
XM4 mir_p mir_p vss vss nmos w=x_dut_xm4_w l=x_dut_xm4_l m=x_dut_xm4_m
XM5 mir_n mir_n vss vss nmos w=x_dut_xm5_w l=x_dut_xm5_l m=x_dut_xm5_m
* --- stage 2: NMOS mirrors under NMOS cascodes (gate vb3) ---
XM6 csrc_n mir_n vss vss nmos w=x_dut_xm6_w l=x_dut_xm6_l m=x_dut_xm6_m
XM7 drv_n vb3 csrc_n vss nmos w=x_dut_xm7_w l=x_dut_xm7_l m=x_dut_xm7_m
XM8 csrc_p mir_p vss vss nmos w=x_dut_xm8_w l=x_dut_xm8_l m=x_dut_xm8_m
XM9 drv_p vb3 csrc_p vss nmos w=x_dut_xm9_w l=x_dut_xm9_l m=x_dut_xm9_m
* --- stage 2: folded PMOS cascodes (gate vb2) fed by the CMFB-controlled sources ---
XM10 drv_n vb2 psrc_n vdd pmos w=x_dut_xm10_w l=x_dut_xm10_l m=x_dut_xm10_m
XM11 drv_p vb2 psrc_p vdd pmos w=x_dut_xm11_w l=x_dut_xm11_l m=x_dut_xm11_m
XM12 psrc_n vcmfb vdd vdd pmos w=x_dut_xm12_w l=x_dut_xm12_l m=x_dut_xm12_m
XM13 psrc_p vcmfb vdd vdd pmos w=x_dut_xm13_w l=x_dut_xm13_l m=x_dut_xm13_m
* --- class-AB output, voutp side: battery stack + push-pull followers ---
XM14 gnf_p vb1 vdd vdd pmos w=x_dut_xm14_w l=x_dut_xm14_l m=x_dut_xm14_m
XM15 gnf_p gnf_p abm_p vss nmos w=x_dut_xm15_w l=x_dut_xm15_l m=x_dut_xm15_m
XM16 vdd gnf_p voutp vss nmos w=x_dut_xm16_w l=x_dut_xm16_l m=x_dut_xm16_m
XM17 gpf_p gpf_p abm_p vdd pmos w=x_dut_xm17_w l=x_dut_xm17_l m=x_dut_xm17_m
XM18 vss gpf_p voutp vdd pmos w=x_dut_xm18_w l=x_dut_xm18_l m=x_dut_xm18_m
XM19 gpf_p drv_p vss vss nmos w=x_dut_xm19_w l=x_dut_xm19_l m=x_dut_xm19_m
C1 abm_p zc_p 'x_dut_c1_value'
R1 zc_p drv_p 'x_dut_r1_value'
* --- class-AB output, voutn side (mirror image) ---
XM20 gnf_n vb1 vdd vdd pmos w=x_dut_xm20_w l=x_dut_xm20_l m=x_dut_xm20_m
XM21 gnf_n gnf_n abm_n vss nmos w=x_dut_xm21_w l=x_dut_xm21_l m=x_dut_xm21_m
XM22 vdd gnf_n voutn vss nmos w=x_dut_xm22_w l=x_dut_xm22_l m=x_dut_xm22_m
XM23 gpf_n gpf_n abm_n vdd pmos w=x_dut_xm23_w l=x_dut_xm23_l m=x_dut_xm23_m
XM24 vss gpf_n voutn vdd pmos w=x_dut_xm24_w l=x_dut_xm24_l m=x_dut_xm24_m
XM25 gpf_n drv_n vss vss nmos w=x_dut_xm25_w l=x_dut_xm25_l m=x_dut_xm25_m
C2 abm_n zc_n 'x_dut_c2_value'
R2 drv_n zc_n 'x_dut_r2_value'
* --- CMFB: resistive CM detector on the outputs (flattened vcm-detector-simple) ---
Rmp cm_det voutp 'x_dut_rmp_value'
Rmn voutn cm_det 'x_dut_rmn_value'
* --- CMFB: behavioral servo (flattened ideal-amp-fully-diff VCCS macromodel;
* --- control pair (vcmfb_ref, cm_det) = the fixed drawing's +/- hookup) ---
Gm vss vcmfb vcmfb_ref cm_det {gm_val}
Rout vss vcmfb 'rout_val'
Cout vss vcmfb 'cout_val'
Rin cm_det vcmfb_ref 'rin_val'
Cin cm_det vcmfb_ref 'cin_val'
* --- internal bias levels (the drawn Vb1..Vb3 + vcmbf_ref ports; instantiator-owned knobs) ---
Vb1 vb1 vss dc {vb1}
Vb2 vb2 vss dc {vb2}
Vb3 vb3 vss dc {vb3}
Vcmfb_ref vcmfb_ref vss dc {vcmfb_ref}
**.ends
.end
