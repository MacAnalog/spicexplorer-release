** GENERATED by `analog-db export-raw` — DO NOT EDIT.
** circuit=ldo_009_fer_5t_pass  class=ldo  pdk=sky130  testbench=tran_line_step  corner=tt
** Self-contained deck: testbench + bound params + lowered DUT (.subckt ldo_009_fer_5t_pass).
** PDK corner libs resolve by BARE NAME on the image's ngspice sourcepath — run in a
** PDK-enabled env (the base image / api container), NOT a bare host:
**   docker run --rm -i spicexplorer-spice-base:local \
**     bash -lc 'd=$(mktemp -d) && cat > $d/c.spice && cd $d && ngspice -b c.spice' < raw/ldo_009_fer_5t_pass/sky130/tran_line_step.spice
*----------------------------------------------------------*
** params: 12 free + 9 frozen knobs (sizing.yaml) · 6 tied · 0 ratio-derived (abstract/params.yaml) · 0 testbench params
** AUTHORED TEMPLATE — ldo/tran_line_step: fast lo->hi->lo supply step at fixed load;
** peak-to-peak output deviation. The time-domain complement of line_regulation's DC sweep,
** following the vendored "Line Transient" benches (circuits/ldo_004_basic_pmos/reference/ltspice/
** Line Transient_6p27..28.asc): the p2p window spans both supply edges, so v_line_pp includes
** the transient spikes AND any DC line-regulation shift between the two rails — keep both
** rails above the dropout knee.
** Bindings: DUT PORT_LINE VDD_LO VDD_HI ILOAD COUT TSTART TEDGE TPULSE TPER TSTEP TSTOP
**   PDK_INCLUDE.
.lib sky130.lib.spice tt
.temp 27

Vdd  vdd 0 pulse(1.6 2.0 5u 100n 100n 20u 50u)
Vss  vss 0 dc 0
Iload vout 0 dc 1m
CLoad vout 0 1u

XDUT vdd vout vss ldo_009_fer_5t_pass

.control
  set filetype=ascii
  tran 50n 45u
  meas tran vout_max MAX v(vout) from=5u to=45u
  meas tran vout_min MIN v(vout) from=5u to=45u
  let v_line_pp = vout_max - vout_min
  print v_line_pp
  write
  quit
.endc
.param x_dut_xmnb_w=4
.param x_dut_xmnb_l=0.4
.param x_dut_xmip_w=8
.param x_dut_xmip_l=0.2
.param x_dut_xmld_w=32
.param x_dut_xmld_l=0.4
.param x_dut_xmp_w=20
.param x_dut_xmp_l=0.2
.param x_cmil=2e-12
.param x_cout=50e-12
.param x_rbleed=1e5
.param x_rref=10000
.param x_vref_val=0.9
.param x_ibias_val=20e-6
.param x_dut_xmnb_m=1
.param x_dut_xmnt_m=2
.param x_dut_xmip_m=2
.param x_dut_xmin_m=2
.param x_dut_xmld_m=1
.param x_dut_xmlm_m=1
.param x_dut_xmp_m=20
* ---- GENERATED parameter ties (abstract/params.yaml groups/ratios) ----
* Each tied symbol is defined exactly once, by its line below; rewrite that
* .param to untie just that symbol (untying = shadowing, plan D-3).
.param x_dut_xmnt_w = {x_dut_xmnb_w}
.param x_dut_xmnt_l = {x_dut_xmnb_l}
.param x_dut_xmin_w = {x_dut_xmip_w}
.param x_dut_xmin_l = {x_dut_xmip_l}
.param x_dut_xmlm_w = {x_dut_xmld_w}
.param x_dut_xmlm_l = {x_dut_xmld_l}
.subckt ldo_009_fer_5t_pass vdd vout vss
CMIL vout otao x_cmil
COUT vout vss x_cout
IBI vdd nbias dc {x_ibias_val}
RBLD vout vss x_rbleed
RREF ref0 vref x_rref
VLP lp_brk vout dc 0
VREF ref0 vss dc {x_vref_val}
XMIN otao vref tail vss sky130_fd_pr__nfet_01v8 l=x_dut_xmin_l m=x_dut_xmin_m w=x_dut_xmin_w
XMIP otax lp_brk tail vss sky130_fd_pr__nfet_01v8 l=x_dut_xmip_l m=x_dut_xmip_m w=x_dut_xmip_w
XMLD otax otax vdd vdd sky130_fd_pr__pfet_01v8 l=x_dut_xmld_l m=x_dut_xmld_m w=x_dut_xmld_w
XMLM otao otax vdd vdd sky130_fd_pr__pfet_01v8 l=x_dut_xmlm_l m=x_dut_xmlm_m w=x_dut_xmlm_w
XMNB nbias nbias vss vss sky130_fd_pr__nfet_01v8 l=x_dut_xmnb_l m=x_dut_xmnb_m w=x_dut_xmnb_w
XMNT tail nbias vss vss sky130_fd_pr__nfet_01v8 l=x_dut_xmnt_l m=x_dut_xmnt_m w=x_dut_xmnt_w
XMP vout otao vdd vdd sky130_fd_pr__pfet_01v8 l=x_dut_xmp_l m=x_dut_xmp_m w=x_dut_xmp_w
.ends
.end
