** AUTHORED TEMPLATE — amplifier/stb_selfbias (2026-08-01): TRUE loop gain, phase margin and
** gain margin of the unity-gain buffer by Middlebrook voltage injection at the VIPRB marker,
** for SELF-BIASED DUTs (no ibias port — the TI-LDO error amps amp_032/033). Identical to
** `stb` except there is no external bias source — derived exactly as psrr_vdd_selfbias
** derives from psrr_vdd (drop `.param IBIAS` and the `Ibias` line), so a 5-port
** [vdd vout vinp vinn vss] DUT does not leave a current source driving a dangling `ibias`
** node (which makes the DC solve singular). Injecting at the DC-short keeps the operating
** point the CLOSED-loop buffer one — the same op point ac_closed_loop_selfbias already proves
** out for these DUTs, so biasing is safe (amp_032's designed-in systematic offset rails an
** UNWRAPPED open-loop bias, which is exactly why its ac_open_loop needs biaswrap; this bench
** never leaves the closed loop, so it needs no wrap).
** EVERYTHING measurement-side is grafted from stb.spice UNCHANGED — that header carries the
** full audited story (math, phase-reference snap + guard, crossing convention, seed
** discipline) and is the reference for any future edit here; the load-bearing invariants:
**   * VIPRB stays a plain 0 V source in the NETLIST — the marker the Spectre emitter maps to
**     `iprobe` for `stb stb probe=VIPRB`; only this .control turns it into the generator via
**     `alter`. Same netlist bytes, same probe, both lanes.
**   * MATH is exact: the marker forces V(vinn) - V(vout) = 1 V AC, so T = v(vout)/v(vinn) = G
**     identically; the only assumption is Middlebrook's impedance condition (low-Z DUT output
**     driving a purely capacitive gate), satisfied by orders of magnitude here.
**   * PHASE REFERENCE snapped to the nearest multiple of 180 at FSTART; |phref_dev| <= 30 or
**     the guard blanks every phase-derived measure to the 999 sentinel (past 90 the branch
**     flips and every margin would be 180 deg out — measured, not hypothetical). Bind the
**     class FSTART = 0.01 Hz (the value at which every single-ended amp of this corpus clears
**     the guard — amp_032/033 @ gf180mcu were part of that measured sweep).
**   * pm_loop at the LAST 0 dB crossing (first-crossing pm certifies unstable loops — the
**     PM-rescue finding); pm_loop_first emitted beside it, gm_loop at the FIRST -180 deg
**     crossing.
**   * SEEDS are the bare -999 sentinel, never a plausible reduction: the only way
**     pm_loop / pm_loop_first / gm_loop carry a number is an actually-interpolated crossing.
**     -999, never +999 — ppa._spec_verdict fails value<min / value>max only, so +999 PASSES
**     every min-bound margin spec silently; -999 fails it (the honest verdict). ugf_loop
**     keeps its reduction seed because its degenerate values (FSTOP / 0) are real information.
**   * No `>` inside a `let` — the .control preprocessor strips it as an output redirection
**     and silently truncates the RHS; masks use `<=` and 1 - mask.
**   * Measure names match the ibias sibling EXACTLY (loopgain_db, ugf_loop, pm_loop, gm_loop,
**     pm_loop_first, phref_dev, phref_ok) so datasheet wiring stays uniform across variants.
** Bindings: DUT PORT_LINE VDD VCM CL FSTART FSTOP PPD PDK_INCLUDE.
${PDK_INCLUDE}

.param VDD=${VDD}
.param VCM=${VCM}
.param CL=${CL}

Vdd  vdd 0 dc {VDD}
Vss  vss 0 dc 0
CLoad vout 0 {CL}

Vinp vinp 0 dc {VCM} ac 1
VIPRB vinn vout dc 0

${PORT_LINE} ${DUT}

.control
  set filetype=ascii
  * break the loop: VIPRB becomes the 1 V AC generator, the forward input goes AC-silent.
  * (Vinp's `ac 1` is left on the netlist line for the Spectre lane; if it stayed live here it
  * would sum into the loop and v(vout)/v(vinn) would not be the loop gain.)
  alter @Vinp[acmag] = 0
  alter @VIPRB[acmag] = 1
  ac dec ${PPD} ${FSTART} ${FSTOP}

  let tloop = v(vout)/v(vinn)
  let tdb   = db(tloop)
  let ntdb  = 0 - tdb
  let f     = real(frequency)
  let tphc  = cph(tloop)*180/3.14159265
  * snap the DC phase reference to the exact 0/+-180 the loop must have at DC (see header)
  let ph0   = 180*floor(tphc[0]/180 + 0.5)
  let phref_dev = tphc[0] - ph0

  * PHASE-REFERENCE GUARD (see header). |phref_dev| <= 90 by construction, and the snap changes
  * branch at 90, so |phref_dev| IS the distance to the ambiguity. Below 30 deg the branch is
  * unique with 60 deg to spare; at or above it the deck refuses to pick one and blanks the
  * phase vector to the 999 sentinel, which propagates into every phase-derived measure below.
  let phref_ok  = (abs(phref_dev) <= 30)
  let phref_bad = 1 - phref_ok
  let tph = (180 + tphc - ph0)*phref_ok + (-999)*phref_bad

  * mask (no `>` — see the parser gotcha in the header)
  let mb = (tdb <= 0)
  let ma = 1 - mb

  * seeds. ugf_loop's reduction is itself information (FSTOP = |T| > 1 everywhere, 0 = never
  * reaches unity). The margins get the bare sentinel: a seed must never look like a reading.
  let loopgain_db   = tdb[0]
  let ugf_loop      = maximum(f*ma)
  let pm_loop       = -999
  let gm_loop       = -999
  let pm_loop_first = -999

  * interpolated refinements; each silently leaves its seed in place if it finds no crossing
  meas ac loopgain_db FIND tdb  AT=${FSTART}
  meas ac ugf_loop    WHEN tdb=0 FALL=LAST
  meas ac pm_loop     FIND tph  WHEN tdb=0 FALL=LAST
  meas ac gm_loop     FIND ntdb WHEN tph=0 FALL=1
  meas ac pm_loop_first FIND tph WHEN tdb=0 FALL=1

  print loopgain_db ugf_loop pm_loop gm_loop pm_loop_first phref_dev phref_ok
  write
  quit
.endc
.end
