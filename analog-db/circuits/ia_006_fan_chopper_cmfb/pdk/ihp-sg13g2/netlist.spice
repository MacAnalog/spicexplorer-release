** GENERATED by `analog-db generate` — DO NOT EDIT. Source: abstract/netlist.spice → ihp-sg13g2
* ia_006_fan_chopper_cmfb (emitted by spicexplorer-circuitgraph)
CCM vb4o vss 'c_cm'
CFB1_CORE core__fbch_p core__vsum_n 'x_dut_cfb1_core_value'
CFB2_CORE core__fbch_n core__vsum_p 'x_dut_cfb2_core_value'
CIN1_CORE core__vsum_n core__inch_n 'x_dut_cin1_core_value'
CIN2_CORE core__vsum_p core__inch_p 'x_dut_cin2_core_value'
CM1_CORE core__g2_p voutp 'x_dut_cm1_core_value'
CM2_CORE core__g2_n voutn 'x_dut_cm2_core_value'
RB1_CORE core__vsum_n vref 'x_dut_rb1_core_value'
RB2_CORE core__vsum_p vref 'x_dut_rb2_core_value'
RMN_CMFB voutn cmfb__cm_sense 'x_dut_rmn_cmfb_value'
RMP_CMFB cmfb__cm_sense voutp 'x_dut_rmp_cmfb_value'
VB1_CORE core__vb1 vss dc {vb1_core}
VB2_CORE core__vb2 vss dc {vb2_core}
VB3_CORE core__vb3 vss dc {vb3_core}
VB4_CORE core__vb4 vss dc {vb4_core}
VREFCM vref_cm vss dc {vcm_ref}
XM10_CORE core__out1_n core__vb3 core__casc_src_n vdd sg13_lv_pmos l=x_dut_xm10_core_l m=x_dut_xm10_core_m w=x_dut_xm10_core_w
XM11_CORE core__out1_p core__vb3 core__casc_src_p vdd sg13_lv_pmos l=x_dut_xm11_core_l m=x_dut_xm11_core_m w=x_dut_xm11_core_w
XM12_CORE core__out1_p core__vb2 core__fold_p vss sg13_lv_nmos l=x_dut_xm12_core_l m=x_dut_xm12_core_m w=x_dut_xm12_core_w
XM13_CORE core__out1_n core__vb2 core__fold_n vss sg13_lv_nmos l=x_dut_xm13_core_l m=x_dut_xm13_core_m w=x_dut_xm13_core_w
XM14_CORE voutp core__g2_p vss vss sg13_lv_nmos l=x_dut_xm14_core_l m=x_dut_xm14_core_m w=x_dut_xm14_core_w
XM15_CORE voutn core__g2_n vss vss sg13_lv_nmos l=x_dut_xm15_core_l m=x_dut_xm15_core_m w=x_dut_xm15_core_w
XM16_CORE core__out1_n clk_chout core__g2_n vss sg13_lv_nmos l=x_dut_xm16_core_l m=x_dut_xm16_core_m w=x_dut_xm16_core_w
XM17_CORE core__g2_n clk_chout_not core__out1_n vdd sg13_lv_pmos l=x_dut_xm17_core_l m=x_dut_xm17_core_m w=x_dut_xm17_core_w
XM18_CORE core__out1_p clk_chout core__g2_p vss sg13_lv_nmos l=x_dut_xm18_core_l m=x_dut_xm18_core_m w=x_dut_xm18_core_w
XM19_CORE core__g2_p clk_chout_not core__out1_p vdd sg13_lv_pmos l=x_dut_xm19_core_l m=x_dut_xm19_core_m w=x_dut_xm19_core_w
XM1_CMFB cmfb__ptail cmfb__bias vdd vdd sg13_lv_pmos l=x_dut_xm1_cmfb_l m=x_dut_xm1_cmfb_m w=x_dut_xm1_cmfb_w
XM1_CORE core__tail core__vb4 vdd vdd sg13_lv_pmos l=x_dut_xm1_core_l m=x_dut_xm1_core_m w=x_dut_xm1_core_w
XM20_CORE core__fbch_p clk_chfb voutp vss sg13_lv_nmos l=x_dut_xm20_core_l m=x_dut_xm20_core_m w=x_dut_xm20_core_w
XM21_CORE voutp clk_chfb_not core__fbch_p vdd sg13_lv_pmos l=x_dut_xm21_core_l m=x_dut_xm21_core_m w=x_dut_xm21_core_w
XM22_CORE core__fbch_n clk_chfb voutn vss sg13_lv_nmos l=x_dut_xm22_core_l m=x_dut_xm22_core_m w=x_dut_xm22_core_w
XM23_CORE voutn clk_chfb_not core__fbch_n vdd sg13_lv_pmos l=x_dut_xm23_core_l m=x_dut_xm23_core_m w=x_dut_xm23_core_w
XM24_CORE vinn clk_chin core__inch_n vss sg13_lv_nmos l=x_dut_xm24_core_l m=x_dut_xm24_core_m w=x_dut_xm24_core_w
XM25_CORE core__inch_n clk_chin_not vinn vdd sg13_lv_pmos l=x_dut_xm25_core_l m=x_dut_xm25_core_m w=x_dut_xm25_core_w
XM26_CORE vinp clk_chin core__inch_p vss sg13_lv_nmos l=x_dut_xm26_core_l m=x_dut_xm26_core_m w=x_dut_xm26_core_w
XM27_CORE core__inch_p clk_chin_not vinp vdd sg13_lv_pmos l=x_dut_xm27_core_l m=x_dut_xm27_core_m w=x_dut_xm27_core_w
XM28_CORE core__out1_n clk_chout_not core__g2_p vss sg13_lv_nmos l=x_dut_xm28_core_l m=x_dut_xm28_core_m w=x_dut_xm28_core_w
XM29_CORE core__g2_p clk_chout core__out1_n vdd sg13_lv_pmos l=x_dut_xm29_core_l m=x_dut_xm29_core_m w=x_dut_xm29_core_w
XM2_CMFB vb4o cmfb__mirr vss vss sg13_lv_nmos l=x_dut_xm2_cmfb_l m=x_dut_xm2_cmfb_m w=x_dut_xm2_cmfb_w
XM2_CORE core__fold_p core__vsum_p core__tail vdd sg13_lv_pmos l=x_dut_xm2_core_l m=x_dut_xm2_core_m w=x_dut_xm2_core_w
XM30_CORE core__out1_p clk_chout_not core__g2_n vss sg13_lv_nmos l=x_dut_xm30_core_l m=x_dut_xm30_core_m w=x_dut_xm30_core_w
XM31_CORE core__g2_n clk_chout core__out1_p vdd sg13_lv_pmos l=x_dut_xm31_core_l m=x_dut_xm31_core_m w=x_dut_xm31_core_w
XM32_CORE vinn clk_chin_not core__inch_p vss sg13_lv_nmos l=x_dut_xm32_core_l m=x_dut_xm32_core_m w=x_dut_xm32_core_w
XM33_CORE core__inch_p clk_chin vinn vdd sg13_lv_pmos l=x_dut_xm33_core_l m=x_dut_xm33_core_m w=x_dut_xm33_core_w
XM34_CORE vinp clk_chin_not core__inch_n vss sg13_lv_nmos l=x_dut_xm34_core_l m=x_dut_xm34_core_m w=x_dut_xm34_core_w
XM35_CORE core__inch_n clk_chin vinp vdd sg13_lv_pmos l=x_dut_xm35_core_l m=x_dut_xm35_core_m w=x_dut_xm35_core_w
XM36_CORE core__fbch_p clk_chfb_not voutn vss sg13_lv_nmos l=x_dut_xm36_core_l m=x_dut_xm36_core_m w=x_dut_xm36_core_w
XM37_CORE voutn clk_chfb core__fbch_p vdd sg13_lv_pmos l=x_dut_xm37_core_l m=x_dut_xm37_core_m w=x_dut_xm37_core_w
XM38_CORE core__fbch_n clk_chfb_not voutp vss sg13_lv_nmos l=x_dut_xm38_core_l m=x_dut_xm38_core_m w=x_dut_xm38_core_w
XM39_CORE voutp clk_chfb core__fbch_n vdd sg13_lv_pmos l=x_dut_xm39_core_l m=x_dut_xm39_core_m w=x_dut_xm39_core_w
XM3_CMFB cmfb__bias cmfb__bias vdd vdd sg13_lv_pmos l=x_dut_xm3_cmfb_l m=x_dut_xm3_cmfb_m w=x_dut_xm3_cmfb_w
XM3_CORE core__fold_n core__vsum_n core__tail vdd sg13_lv_pmos l=x_dut_xm3_core_l m=x_dut_xm3_core_m w=x_dut_xm3_core_w
XM4_CMFB cmfb__mirr cmfb__cm_sense cmfb__ptail vdd sg13_lv_pmos l=x_dut_xm4_cmfb_l m=x_dut_xm4_cmfb_m w=x_dut_xm4_cmfb_w
XM4_CORE core__fold_p core__vb1 vss vss sg13_lv_nmos l=x_dut_xm4_core_l m=x_dut_xm4_core_m w=x_dut_xm4_core_w
XM5_CMFB vb4o vref_cm cmfb__ptail vdd sg13_lv_pmos l=x_dut_xm5_cmfb_l m=x_dut_xm5_cmfb_m w=x_dut_xm5_cmfb_w
XM5_CORE core__fold_n core__vb1 vss vss sg13_lv_nmos l=x_dut_xm5_core_l m=x_dut_xm5_core_m w=x_dut_xm5_core_w
XM6_CMFB cmfb__mirr cmfb__mirr vss vss sg13_lv_nmos l=x_dut_xm6_cmfb_l m=x_dut_xm6_cmfb_m w=x_dut_xm6_cmfb_w
XM6_CORE core__casc_src_n core__vb4 vdd vdd sg13_lv_pmos l=x_dut_xm6_core_l m=x_dut_xm6_core_m w=x_dut_xm6_core_w
XM7_CMFB cmfb__bias cmfb__bias vss vss sg13_lv_nmos l=x_dut_xm7_cmfb_l m=x_dut_xm7_cmfb_m w=x_dut_xm7_cmfb_w
XM7_CORE core__casc_src_p core__vb4 vdd vdd sg13_lv_pmos l=x_dut_xm7_core_l m=x_dut_xm7_core_m w=x_dut_xm7_core_w
XM8O voutp vb4o vdd vdd sg13_lv_pmos l=x_dut_xm8o_l m=x_dut_xm8o_m w=x_dut_xm8o_w
XM9O voutn vb4o vdd vdd sg13_lv_pmos l=x_dut_xm9o_l m=x_dut_xm9o_m w=x_dut_xm9o_w
.end
