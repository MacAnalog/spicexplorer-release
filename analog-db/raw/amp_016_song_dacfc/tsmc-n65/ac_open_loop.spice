** GENERATED by `analog-db export-raw` — DO NOT EDIT.
** circuit=amp_016_song_dacfc  class=amplifier  pdk=tsmc-n65  testbench=ac_open_loop  corner=tt
** Self-contained deck: testbench + bound params + lowered DUT (.subckt amp_016_song_dacfc).
** PDK corner libs resolve by BARE NAME on the image's ngspice sourcepath — run in a
** PDK-enabled env (the base image / api container), NOT a bare host:
**   docker run --rm -i spicexplorer-spice-base:local \
**     bash -lc 'd=$(mktemp -d) && cat > $d/c.spice && cd $d && ngspice -b c.spice' < raw/amp_016_song_dacfc/tsmc-n65/ac_open_loop.spice
*----------------------------------------------------------*
** params: 33 free + 0 frozen knobs (sizing.yaml) · 58 tied · 23 ratio-derived (abstract/params.yaml) · 3 testbench params
** AUTHORED TEMPLATE — amplifier/ac_open_loop_biaswrap (plan D-4; the AnalogGym bias-wrap).
** Open-loop gain measured in closed-loop bias (analoggym-amplifiers skill §5): a 1 TH inductor
** DC-shorts the output back to the inverting input — setting the high-gain operating point —
** while a 1 TF cap AC-opens that feedback and injects the AC input. This is the only way a
** high-gain 3-stage amp biases stably while still exposing its open-loop AC response.
**
** Assumes the AnalogGym canonical DUT port order (self-biased; NO ibias port):
**   .subckt <id> vss vdd vinn vinp vout
** Bindings: DUT VDD VCM CL FSTART FSTOP PPD PDK_INCLUDE.
** FIXED 2026-07-20: this template used to hardcode `X1 0 vdd opout_dc opin opout amp_016_song_dacfc`,
** which silently assumed the AnalogGym port order [vss vdd vinn vinp vout] and MIS-WIRED any
** DUT declaring a different order (e.g. the amplifier-class [vdd vout vinp vinn vss] swaps
** vdd<->vss). It now uses XDUT vss vdd vinn vinp vout with canonical node names, exactly like the
** *_biaswrap_ibias sibling. For the AnalogGym DUTs this is a no-op: their vss port binds to
** node `vss`, which `Vss vss 0 dc 0` ties to ground just as the old direct-to-0 wiring did.
.lib tsmc_n65_models.scs tt
.temp 27

.param VDD=1.8
.param VCM=300m
.param CL=500p

Vdd  vdd 0 dc {VDD}
Vss  vss 0 dc 0
Vcm  vinp 0 dc {VCM}          ; common-mode bias on the non-inverting input
Vac  sigin 0 dc 0 ac 1        ; AC stimulus
Lfb  vout vinn 1T        ; 1 TH: DC short (bias), AC open
Cin  vinn sigin 1T        ; 1 TF: DC open, AC inject into the inverting node
CLoad vout 0 {CL}

XDUT vss vdd vinn vinp vout amp_016_song_dacfc
.control
  set filetype=ascii
  ac dec 50 0.1 1G
  meas ac dcgain FIND vdb(vout) AT=0.1
  meas ac ugf    WHEN vdb(vout)=0 FALL=1
  let phc = cph(vout)*180/3.14159265
  let ph  = 180 + phc - phc[0]
  meas ac pm     FIND ph WHEN vdb(vout)=0 FALL=1
  write
  quit
.endc
.param CAPACITOR_0=1.5p
.param CAPACITOR_1=0.7p
.param CURRENT_0_BIAS=5u
.param x_dut_xm69_l=1u
.param x_dut_xm2_m=4
.param x_dut_xm69_w=1u
.param x_dut_xm10_l=1u
.param x_dut_xm10_m=4
.param x_dut_xm10_w=1u
.param x_dut_xm11_l=1u
.param x_dut_xm11_m=4
.param x_dut_xm11_w=1u
.param x_dut_xm71_l=1u
.param x_dut_xm14_m=4
.param x_dut_xm71_w=1u
.param x_dut_xm21_l=1u
.param x_dut_xm21_m=4
.param x_dut_xm21_w=1u
.param x_dut_xm23_l=1u
.param x_dut_xm23_m=4
.param x_dut_xm23_w=1u
.param x_dut_xm58_l=1u
.param x_dut_xm58_m=4
.param x_dut_xm58_w=1u
.param x_dut_xm6_l=1u
.param x_dut_xm6_m=4
.param x_dut_xm6_w=1u
.param x_dut_xm7_l=1u
.param x_dut_xm7_m=4
.param x_dut_xm7_w=1u
.param x_dut_xm9_l=1u
.param x_dut_xm9_m=4
.param x_dut_xm9_w=1u
* ---- GENERATED parameter ties (abstract/params.yaml groups/ratios) ----
* Each tied symbol is defined exactly once, by its line below; rewrite that
* .param to untie just that symbol (untying = shadowing, plan D-3).
.param x_dut_xm68_w = {x_dut_xm69_w}
.param x_dut_xm63_w = {x_dut_xm69_w}
.param x_dut_xm62_w = {x_dut_xm69_w}
.param x_dut_xm61_w = {x_dut_xm69_w}
.param x_dut_xm60_w = {x_dut_xm69_w}
.param x_dut_xm59_w = {x_dut_xm69_w}
.param x_dut_xm4_w = {x_dut_xm69_w}
.param x_dut_xm3_w = {x_dut_xm69_w}
.param x_dut_xm2_w = {x_dut_xm69_w}
.param x_dut_xm1_w = {x_dut_xm69_w}
.param x_dut_xm0_w = {x_dut_xm69_w}
.param x_dut_xm68_l = {x_dut_xm69_l}
.param x_dut_xm63_l = {x_dut_xm69_l}
.param x_dut_xm62_l = {x_dut_xm69_l}
.param x_dut_xm61_l = {x_dut_xm69_l}
.param x_dut_xm60_l = {x_dut_xm69_l}
.param x_dut_xm59_l = {x_dut_xm69_l}
.param x_dut_xm4_l = {x_dut_xm69_l}
.param x_dut_xm3_l = {x_dut_xm69_l}
.param x_dut_xm2_l = {x_dut_xm69_l}
.param x_dut_xm1_l = {x_dut_xm69_l}
.param x_dut_xm0_l = {x_dut_xm69_l}
.param x_dut_xm57_w = {x_dut_xm58_w}
.param x_dut_xm57_l = {x_dut_xm58_l}
.param x_dut_xm57_m = {x_dut_xm58_m}
.param x_dut_xm5_w = {x_dut_xm6_w}
.param x_dut_xm5_l = {x_dut_xm6_l}
.param x_dut_xm5_m = {x_dut_xm6_m}
.param x_dut_xm8_w = {x_dut_xm9_w}
.param x_dut_xm8_l = {x_dut_xm9_l}
.param x_dut_xm8_m = {x_dut_xm9_m}
.param x_dut_xm70_w = {x_dut_xm71_w}
.param x_dut_xm65_w = {x_dut_xm71_w}
.param x_dut_xm64_w = {x_dut_xm71_w}
.param x_dut_xm19_w = {x_dut_xm71_w}
.param x_dut_xm15_w = {x_dut_xm71_w}
.param x_dut_xm20_w = {x_dut_xm71_w}
.param x_dut_xm16_w = {x_dut_xm71_w}
.param x_dut_xm17_w = {x_dut_xm71_w}
.param x_dut_xm14_w = {x_dut_xm71_w}
.param x_dut_xm12_w = {x_dut_xm71_w}
.param x_dut_xm18_w = {x_dut_xm71_w}
.param x_dut_xm13_w = {x_dut_xm71_w}
.param x_dut_xm70_l = {x_dut_xm71_l}
.param x_dut_xm65_l = {x_dut_xm71_l}
.param x_dut_xm64_l = {x_dut_xm71_l}
.param x_dut_xm19_l = {x_dut_xm71_l}
.param x_dut_xm15_l = {x_dut_xm71_l}
.param x_dut_xm20_l = {x_dut_xm71_l}
.param x_dut_xm16_l = {x_dut_xm71_l}
.param x_dut_xm17_l = {x_dut_xm71_l}
.param x_dut_xm14_l = {x_dut_xm71_l}
.param x_dut_xm12_l = {x_dut_xm71_l}
.param x_dut_xm18_l = {x_dut_xm71_l}
.param x_dut_xm13_l = {x_dut_xm71_l}
.param x_dut_xm22_w = {x_dut_xm21_w}
.param x_dut_xm22_l = {x_dut_xm21_l}
.param x_dut_xm22_m = {x_dut_xm21_m}
.param x_dut_xm69_m = {x_dut_xm2_m*4}
.param x_dut_xm68_m = {x_dut_xm2_m*4}
.param x_dut_xm63_m = {x_dut_xm2_m*4}
.param x_dut_xm62_m = {x_dut_xm2_m*4}
.param x_dut_xm61_m = {x_dut_xm2_m*4}
.param x_dut_xm60_m = {x_dut_xm2_m*4}
.param x_dut_xm59_m = {x_dut_xm2_m*2}
.param x_dut_xm4_m = {x_dut_xm2_m*2}
.param x_dut_xm3_m = {x_dut_xm2_m*4}
.param x_dut_xm1_m = {x_dut_xm2_m*4}
.param x_dut_xm0_m = {x_dut_xm2_m*4}
.param x_dut_xm71_m = {x_dut_xm14_m*4}
.param x_dut_xm70_m = {x_dut_xm14_m*4}
.param x_dut_xm65_m = {x_dut_xm14_m*8}
.param x_dut_xm64_m = {x_dut_xm14_m*8}
.param x_dut_xm19_m = {x_dut_xm14_m*8}
.param x_dut_xm15_m = {x_dut_xm14_m*4}
.param x_dut_xm20_m = {x_dut_xm14_m*8}
.param x_dut_xm16_m = {x_dut_xm14_m*4}
.param x_dut_xm17_m = {x_dut_xm14_m*4}
.param x_dut_xm12_m = {x_dut_xm14_m*4}
.param x_dut_xm18_m = {x_dut_xm14_m*4}
.param x_dut_xm13_m = {x_dut_xm14_m*4}
.subckt amp_016_song_dacfc vss vdd vinn vinp vout
C0 VOUT net70 'CAPACITOR_0'
C2 net4 vss 'CAPACITOR_1'
I0 net013 vss 'CURRENT_0_BIAS'
XM0 net013 net013 vdd vdd pch_lvt l=x_dut_xm0_l m=x_dut_xm0_m w=x_dut_xm0_w
XM1 VB4 net013 vdd vdd pch_lvt l=x_dut_xm1_l m=x_dut_xm1_m w=x_dut_xm1_w
XM10 net043 net4 vdd vdd pch_lvt l=x_dut_xm10_l m=x_dut_xm10_m w=x_dut_xm10_w
XM11 VOUT net4 vdd vdd pch_lvt l=x_dut_xm11_l m=x_dut_xm11_m w=x_dut_xm11_w
XM12 VB4 VB3 net54 vss nch_lvt l=x_dut_xm12_l m=x_dut_xm12_m w=x_dut_xm12_w
XM13 DM_1 VB3 net56 vss nch_lvt l=x_dut_xm13_l m=x_dut_xm13_m w=x_dut_xm13_w
XM14 VB3 VB3 vss vss nch_lvt l=x_dut_xm14_l m=x_dut_xm14_m w=x_dut_xm14_w
XM15 VOUTN VB3 DM_2 vss nch_lvt l=x_dut_xm15_l m=x_dut_xm15_m w=x_dut_xm15_w
XM16 net4 VB3 net063 vss nch_lvt l=x_dut_xm16_l m=x_dut_xm16_m w=x_dut_xm16_w
XM17 net54 VB4 vss vss nch_lvt l=x_dut_xm17_l m=x_dut_xm17_m w=x_dut_xm17_w
XM18 net56 VB4 vss vss nch_lvt l=x_dut_xm18_l m=x_dut_xm18_m w=x_dut_xm18_w
XM19 DM_2 VB4 vss vss nch_lvt l=x_dut_xm19_l m=x_dut_xm19_m w=x_dut_xm19_w
XM2 DM_1 DM_1 vdd vdd pch_lvt l=x_dut_xm2_l m=x_dut_xm2_m w=x_dut_xm2_w
XM20 net063 VB4 vss vss nch_lvt l=x_dut_xm20_l m=x_dut_xm20_m w=x_dut_xm20_w
XM21 net043 net043 vss vss nch_lvt l=x_dut_xm21_l m=x_dut_xm21_m w=x_dut_xm21_w
XM22 net049 net043 vss vss nch_lvt l=x_dut_xm22_l m=x_dut_xm22_m w=x_dut_xm22_w
XM23 VOUT net049 vss vss nch_lvt l=x_dut_xm23_l m=x_dut_xm23_m w=x_dut_xm23_w
XM3 VB3 net013 vdd vdd pch_lvt l=x_dut_xm3_l m=x_dut_xm3_m w=x_dut_xm3_w
XM4 net31 net013 vdd vdd pch_lvt l=x_dut_xm4_l m=x_dut_xm4_m w=x_dut_xm4_w
XM5 net5 VOUTN vdd vdd pch_lvt l=x_dut_xm5_l m=x_dut_xm5_m w=x_dut_xm5_w
XM57 net043 VINN net1 net1 pch_lvt l=x_dut_xm57_l m=x_dut_xm57_m w=x_dut_xm57_w
XM58 net049 VINP net1 net1 pch_lvt l=x_dut_xm58_l m=x_dut_xm58_m w=x_dut_xm58_w
XM59 net1 net013 vdd vdd pch_lvt l=x_dut_xm59_l m=x_dut_xm59_m w=x_dut_xm59_w
XM6 net050 VOUTN vdd vdd pch_lvt l=x_dut_xm6_l m=x_dut_xm6_m w=x_dut_xm6_w
XM60 VOUTN DM_1 net5 vdd pch_lvt l=x_dut_xm60_l m=x_dut_xm60_m w=x_dut_xm60_w
XM61 net4 DM_1 net050 vdd pch_lvt l=x_dut_xm61_l m=x_dut_xm61_m w=x_dut_xm61_w
XM62 VOUTN DM_1 net3 vdd pch_lvt l=x_dut_xm62_l m=x_dut_xm62_m w=x_dut_xm62_w
XM63 net70 DM_1 net2 vdd pch_lvt l=x_dut_xm63_l m=x_dut_xm63_m w=x_dut_xm63_w
XM64 net85 VB4 vss vss nch_lvt l=x_dut_xm64_l m=x_dut_xm64_m w=x_dut_xm64_w
XM65 net69 VB4 vss vss nch_lvt l=x_dut_xm65_l m=x_dut_xm65_m w=x_dut_xm65_w
XM68 net2 net70 vdd vdd pch_lvt l=x_dut_xm68_l m=x_dut_xm68_m w=x_dut_xm68_w
XM69 net3 net70 vdd vdd pch_lvt l=x_dut_xm69_l m=x_dut_xm69_m w=x_dut_xm69_w
XM7 net049 VOUTN vdd vdd pch_lvt l=x_dut_xm7_l m=x_dut_xm7_m w=x_dut_xm7_w
XM70 net70 VB3 net69 vss nch_lvt l=x_dut_xm70_l m=x_dut_xm70_m w=x_dut_xm70_w
XM71 VOUTN VB3 net85 vss nch_lvt l=x_dut_xm71_l m=x_dut_xm71_m w=x_dut_xm71_w
XM8 DM_2 VINN net31 net31 pch_lvt l=x_dut_xm8_l m=x_dut_xm8_m w=x_dut_xm8_w
XM9 net063 VINP net31 net31 pch_lvt l=x_dut_xm9_l m=x_dut_xm9_m w=x_dut_xm9_w
.ends
.end
