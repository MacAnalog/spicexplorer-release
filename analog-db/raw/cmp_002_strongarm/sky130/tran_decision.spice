** GENERATED by `analog-db export-raw` — DO NOT EDIT.
** circuit=cmp_002_strongarm  class=comparator  pdk=sky130  testbench=tran_decision  corner=tt
** Self-contained deck: testbench + bound params + lowered DUT (.subckt cmp_002_strongarm).
** PDK corner libs resolve by BARE NAME on the image's ngspice sourcepath — run in a
** PDK-enabled env (the base image / api container), NOT a bare host:
**   docker run --rm -i spicexplorer-spice-base:local \
**     bash -lc 'd=$(mktemp -d) && cat > $d/c.spice && cd $d && ngspice -b c.spice' < raw/cmp_002_strongarm/sky130/tran_decision.spice
*----------------------------------------------------------*
** params: 7 free + 15 frozen knobs (sizing.yaml) · 23 tied · 0 ratio-derived (abstract/params.yaml) · 3 testbench params
** AUTHORED TEMPLATE — comparator/tran_decision: clocked decision transient (StrongARM-style).
** A fixed differential overdrive VOD straddles VCM; the clock runs two full periods and the
** SECOND rising edge (a settled, post-startup evaluation) is measured: clk->voutp propagation
** delay, decided output levels mid-evaluation (AT=TMEAS, inside the clk-high window), and the
** clock-period average supply current. TRIG/TARG + AVG meas lines carry suffixes the result
** parser skips, so scalars are re-printed clean.
** Port convention: vdd voutp voutn vinp vinn clk vss. voutp is the side that decides HIGH for
** vinp > vinn.
** Bindings: DUT PORT_LINE VDD VCM VOD TEDGE TDELAY THI TPER TSTEP TSTOP TMEAS PDK_INCLUDE.
.lib sky130.lib.spice tt
.temp 27

.param VDD=1.5
.param VCM=0.75
.param VOD=0.05

Vdd  vdd 0 dc {VDD}
Vss  vss 0 dc 0
Vinp vinp 0 dc {VCM+VOD/2}
Vinn vinn 0 dc {VCM-VOD/2}
Vclk clk 0 dc 0 pulse(0 {VDD} 10n 1n 1n 50n 100n)

XDUT vdd voutp voutn vinp vinn clk vss cmp_002_strongarm

.control
  set filetype=ascii
  let vmid = 1.5/2
  tran 50p 250n
  meas tran t_prop TRIG v(clk) VAL=vmid RISE=2 TARG v(voutp) VAL=vmid RISE=2
  meas tran v_out_high FIND v(voutp) AT=150n
  meas tran v_out_low  FIND v(voutn) AT=150n
  meas tran i_avg AVG i(Vdd) FROM=10n TO=250n
  let i_supply = abs(i_avg)
  print t_prop i_supply
  write
  quit
.endc
.param x_dut_xmtail_w=4
.param x_dut_xminn_w=8
.param x_dut_xmlem_w=4
.param x_dut_xmpc1_w=2
.param x_dut_xmobn1_w=1.5
.param x_dut_xmobp1_w=3
.param x_dut_xmtail_l=0.15
.param x_dut_xmtail_m=1
.param x_dut_xminn_m=2
.param x_dut_xminp_m=2
.param x_dut_xmlem_m=1
.param x_dut_xmlep_m=1
.param x_dut_xmlum_m=1
.param x_dut_xmlup_m=1
.param x_dut_xmpc1_m=1
.param x_dut_xmpc2_m=1
.param x_dut_xmpc3_m=1
.param x_dut_xmpc4_m=1
.param x_dut_xmobn1_m=1
.param x_dut_xmobp1_m=1
.param x_dut_xmobn2_m=1
.param x_dut_xmobp2_m=1
* ---- GENERATED parameter ties (abstract/params.yaml groups/ratios) ----
* Each tied symbol is defined exactly once, by its line below; rewrite that
* .param to untie just that symbol (untying = shadowing, plan D-3).
.param x_dut_xminn_l = {x_dut_xmtail_l}
.param x_dut_xminp_l = {x_dut_xmtail_l}
.param x_dut_xmlem_l = {x_dut_xmtail_l}
.param x_dut_xmlep_l = {x_dut_xmtail_l}
.param x_dut_xmlum_l = {x_dut_xmtail_l}
.param x_dut_xmlup_l = {x_dut_xmtail_l}
.param x_dut_xmpc1_l = {x_dut_xmtail_l}
.param x_dut_xmpc2_l = {x_dut_xmtail_l}
.param x_dut_xmpc3_l = {x_dut_xmtail_l}
.param x_dut_xmpc4_l = {x_dut_xmtail_l}
.param x_dut_xmobn1_l = {x_dut_xmtail_l}
.param x_dut_xmobp1_l = {x_dut_xmtail_l}
.param x_dut_xmobn2_l = {x_dut_xmtail_l}
.param x_dut_xmobp2_l = {x_dut_xmtail_l}
.param x_dut_xminp_w = {x_dut_xminn_w}
.param x_dut_xmlep_w = {x_dut_xmlem_w}
.param x_dut_xmlum_w = {x_dut_xmlem_w}
.param x_dut_xmlup_w = {x_dut_xmlem_w}
.param x_dut_xmpc2_w = {x_dut_xmpc1_w}
.param x_dut_xmpc3_w = {x_dut_xmpc1_w}
.param x_dut_xmpc4_w = {x_dut_xmpc1_w}
.param x_dut_xmobn2_w = {x_dut_xmobn1_w}
.param x_dut_xmobp2_w = {x_dut_xmobp1_w}
.subckt cmp_002_strongarm vdd voutp voutn vinp vinn clk vss
XMINN sp vinn tail vss sky130_fd_pr__nfet_01v8 l=x_dut_xminn_l m=x_dut_xminn_m w=x_dut_xminn_w
XMINP sn vinp tail vss sky130_fd_pr__nfet_01v8 l=x_dut_xminp_l m=x_dut_xminp_m w=x_dut_xminp_w
XMLEM lm lp sn vss sky130_fd_pr__nfet_01v8 l=x_dut_xmlem_l m=x_dut_xmlem_m w=x_dut_xmlem_w
XMLEP lp lm sp vss sky130_fd_pr__nfet_01v8 l=x_dut_xmlep_l m=x_dut_xmlep_m w=x_dut_xmlep_w
XMLUM lm lp vdd vdd sky130_fd_pr__pfet_01v8 l=x_dut_xmlum_l m=x_dut_xmlum_m w=x_dut_xmlum_w
XMLUP lp lm vdd vdd sky130_fd_pr__pfet_01v8 l=x_dut_xmlup_l m=x_dut_xmlup_m w=x_dut_xmlup_w
XMOBN1 voutp lm vss vss sky130_fd_pr__nfet_01v8 l=x_dut_xmobn1_l m=x_dut_xmobn1_m w=x_dut_xmobn1_w
XMOBN2 voutn lp vss vss sky130_fd_pr__nfet_01v8 l=x_dut_xmobn2_l m=x_dut_xmobn2_m w=x_dut_xmobn2_w
XMOBP1 voutp lm vdd vdd sky130_fd_pr__pfet_01v8 l=x_dut_xmobp1_l m=x_dut_xmobp1_m w=x_dut_xmobp1_w
XMOBP2 voutn lp vdd vdd sky130_fd_pr__pfet_01v8 l=x_dut_xmobp2_l m=x_dut_xmobp2_m w=x_dut_xmobp2_w
XMPC1 sp clk vdd vdd sky130_fd_pr__pfet_01v8 l=x_dut_xmpc1_l m=x_dut_xmpc1_m w=x_dut_xmpc1_w
XMPC2 sn clk vdd vdd sky130_fd_pr__pfet_01v8 l=x_dut_xmpc2_l m=x_dut_xmpc2_m w=x_dut_xmpc2_w
XMPC3 lp clk vdd vdd sky130_fd_pr__pfet_01v8 l=x_dut_xmpc3_l m=x_dut_xmpc3_m w=x_dut_xmpc3_w
XMPC4 lm clk vdd vdd sky130_fd_pr__pfet_01v8 l=x_dut_xmpc4_l m=x_dut_xmpc4_m w=x_dut_xmpc4_w
XMTAIL tail clk vss vss sky130_fd_pr__nfet_01v8 l=x_dut_xmtail_l m=x_dut_xmtail_m w=x_dut_xmtail_w
.ends
.end
