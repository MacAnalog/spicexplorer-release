** GENERATED by `analog-db generate` — DO NOT EDIT. Source: abstract/netlist.spice → gf180mcu
* buf_001_super_follower (emitted by spicexplorer-circuitgraph)
CC na vss x_cc
XM1 na vin vout vss nfet_03v3 l=x_dut_xm1_l m=x_dut_xm1_m w=x_dut_xm1_w
XM2 vout na vss vss nfet_03v3 l=x_dut_xm2_l m=x_dut_xm2_m w=x_dut_xm2_w
XMNS pd ibias vss vss nfet_03v3 l=x_dut_xmns_l m=x_dut_xmns_m w=x_dut_xmns_w
XMPB na pd vdd vdd pfet_03v3 l=x_dut_xmpb_l m=x_dut_xmpb_m w=x_dut_xmpb_w
XMPD pd pd vdd vdd pfet_03v3 l=x_dut_xmpd_l m=x_dut_xmpd_m w=x_dut_xmpd_w
XMRN ibias ibias vss vss nfet_03v3 l=x_dut_xmrn_l m=x_dut_xmrn_m w=x_dut_xmrn_w
.end
