** GENERATED by `analog-db export-raw` — DO NOT EDIT.
** circuit=amp_011_peng_iac  class=amplifier  pdk=gf180mcu  testbench=tran_step  corner=tt
** Self-contained deck: testbench + bound params + lowered DUT (.subckt amp_011_peng_iac).
** PDK corner libs resolve by BARE NAME on the image's ngspice sourcepath — run in a
** PDK-enabled env (the base image / api container), NOT a bare host:
**   docker run --rm -i spicexplorer-spice-base:local \
**     bash -lc 'd=$(mktemp -d) && cat > $d/c.spice && cd $d && ngspice -b c.spice' < raw/amp_011_peng_iac/gf180mcu/tran_step.spice
*----------------------------------------------------------*
** params: 31 free + 0 frozen knobs (sizing.yaml) · 52 tied · 23 ratio-derived (abstract/params.yaml) · 4 testbench params
** AUTHORED TEMPLATE — amplifier/tran_step_biaswrap: unity-gain step settling for DUTs on the
** AnalogGym self-bias convention (ports vss vdd vinn vinp vout; NO ibias port). Single-ended
** companion of tran_step_diff (M4 follow-up). Unlike the AC/noise bias-wraps — which AC-open the
** loop with Lfb/Cin — a settling measurement WANTS the real closed loop: wire the inverting input
** directly to the output (unity-gain follower) and step the non-inverting input. Settle to the
** FINAL output value, not the input step, so a systematic offset can't hold a fixed-tolerance band
** open forever (see universal/tran_step for the rationale). These are compensated multistage OTAs,
** designed stable in unity feedback.
**
** Assumes the AnalogGym canonical DUT port order (self-biased; NO ibias port):
**   .subckt <id> vss vdd vinn vinp vout
** Bindings: DUT VDD VCM CL VSTEP TSTART TSTEP TSTOP VTOL PDK_INCLUDE.
** FIXED 2026-07-20: this template used to hardcode `X1 0 vdd opout_dc opin opout amp_011_peng_iac`,
** which silently assumed the AnalogGym port order [vss vdd vinn vinp vout] and MIS-WIRED any
** DUT declaring a different order (e.g. the amplifier-class [vdd vout vinp vinn vss] swaps
** vdd<->vss). It now uses XDUT vss vdd vinn vinp vout with canonical node names, exactly like the
** *_biaswrap_ibias sibling. For the AnalogGym DUTs this is a no-op: their vss port binds to
** node `vss`, which `Vss vss 0 dc 0` ties to ground just as the old direct-to-0 wiring did.
.include design.ngspice
.lib sm141064.ngspice noise_corner
.lib sm141064.ngspice nfet_03v3_t
.lib sm141064.ngspice pfet_03v3_t
.lib sm141064.ngspice fets_mm
.temp 27

.param VDD=1.8
.param VCM=240m
.param CL=150p
.param VSTEP=0.2

Vdd  vdd 0 dc {VDD}
Vss  vss 0 dc 0
CLoad vout 0 {CL}
Vinp vinp 0 dc {VCM} pulse({VCM} {VCM+VSTEP} 1u 1n 1n 1 1)
Vfb  vinn vout dc 0          ; unity-gain feedback wire (vinn <- vout; 0 V source = ideal wire)

XDUT vss vdd vinn vinp vout amp_011_peng_iac
.control
  set filetype=ascii
  tran 10n 200u
  * settle to the FINAL value, not the input step — a follower's systematic offset would
  * otherwise keep |vout - vfinal| outside a tight tolerance band forever.
  meas tran vfinal FIND v(vout) AT=200u
  let verr = abs(v(vout) - vfinal)
  meas tran tcross WHEN verr=2m FALL=LAST
  let t_settle = tcross - 1u
  print t_settle
  write
  quit
.endc
.param CAPACITOR_0=0.5p
.param CAPACITOR_1=1.1p
.param CURRENT_0_BIAS=1.25u
.param x_dut_xm7_l=1u
.param x_dut_xm65_m=4
.param x_dut_xm7_w=1u
.param x_dut_xm10_l=0.35u
.param x_dut_xm10_m=24
.param x_dut_xm10_w=1u
.param x_dut_xm11_l=0.35u
.param x_dut_xm11_m=9
.param x_dut_xm11_w=1u
.param x_dut_xm19_l=0.35u
.param x_dut_xm14_m=2
.param x_dut_xm19_w=1u
.param x_dut_xm23_l=0.35u
.param x_dut_xm23_m=3
.param x_dut_xm23_w=1u
.param x_dut_xm66_l=1u
.param x_dut_xm66_m=16
.param x_dut_xm66_w=1u
.param x_dut_xm68_l=0.35u
.param x_dut_xm68_m=3
.param x_dut_xm68_w=1u
.param x_dut_xm70_l=0.35u
.param x_dut_xm70_m=3
.param x_dut_xm70_w=1u
.param x_dut_xm9_l=0.35u
.param x_dut_xm9_m=3
.param x_dut_xm9_w=1u
.param RESISTOR_0=750k
* ---- GENERATED parameter ties (abstract/params.yaml groups/ratios) ----
* Each tied symbol is defined exactly once, by its line below; rewrite that
* .param to untie just that symbol (untying = shadowing, plan D-3).
.param x_dut_xm57_w = {x_dut_xm7_w}
.param x_dut_xm65_w = {x_dut_xm7_w}
.param x_dut_xm6_w = {x_dut_xm7_w}
.param x_dut_xm5_w = {x_dut_xm7_w}
.param x_dut_xm4_w = {x_dut_xm7_w}
.param x_dut_xm62_w = {x_dut_xm7_w}
.param x_dut_xm3_w = {x_dut_xm7_w}
.param x_dut_xm61_w = {x_dut_xm7_w}
.param x_dut_xm2_w = {x_dut_xm7_w}
.param x_dut_xm58_w = {x_dut_xm7_w}
.param x_dut_xm1_w = {x_dut_xm7_w}
.param x_dut_xm0_w = {x_dut_xm7_w}
.param x_dut_xm57_l = {x_dut_xm7_l}
.param x_dut_xm65_l = {x_dut_xm7_l}
.param x_dut_xm6_l = {x_dut_xm7_l}
.param x_dut_xm5_l = {x_dut_xm7_l}
.param x_dut_xm4_l = {x_dut_xm7_l}
.param x_dut_xm62_l = {x_dut_xm7_l}
.param x_dut_xm3_l = {x_dut_xm7_l}
.param x_dut_xm61_l = {x_dut_xm7_l}
.param x_dut_xm2_l = {x_dut_xm7_l}
.param x_dut_xm58_l = {x_dut_xm7_l}
.param x_dut_xm1_l = {x_dut_xm7_l}
.param x_dut_xm0_l = {x_dut_xm7_l}
.param x_dut_xm8_w = {x_dut_xm9_w}
.param x_dut_xm8_l = {x_dut_xm9_l}
.param x_dut_xm8_m = {x_dut_xm9_m}
.param x_dut_xm69_w = {x_dut_xm70_w}
.param x_dut_xm69_l = {x_dut_xm70_l}
.param x_dut_xm69_m = {x_dut_xm70_m}
.param x_dut_xm15_w = {x_dut_xm19_w}
.param x_dut_xm20_w = {x_dut_xm19_w}
.param x_dut_xm16_w = {x_dut_xm19_w}
.param x_dut_xm17_w = {x_dut_xm19_w}
.param x_dut_xm67_w = {x_dut_xm19_w}
.param x_dut_xm14_w = {x_dut_xm19_w}
.param x_dut_xm12_w = {x_dut_xm19_w}
.param x_dut_xm18_w = {x_dut_xm19_w}
.param x_dut_xm13_w = {x_dut_xm19_w}
.param x_dut_xm64_w = {x_dut_xm19_w}
.param x_dut_xm63_w = {x_dut_xm19_w}
.param x_dut_xm15_l = {x_dut_xm19_l}
.param x_dut_xm20_l = {x_dut_xm19_l}
.param x_dut_xm16_l = {x_dut_xm19_l}
.param x_dut_xm17_l = {x_dut_xm19_l}
.param x_dut_xm67_l = {x_dut_xm19_l}
.param x_dut_xm14_l = {x_dut_xm19_l}
.param x_dut_xm12_l = {x_dut_xm19_l}
.param x_dut_xm18_l = {x_dut_xm19_l}
.param x_dut_xm13_l = {x_dut_xm19_l}
.param x_dut_xm64_l = {x_dut_xm19_l}
.param x_dut_xm63_l = {x_dut_xm19_l}
.param x_dut_xm7_m = {x_dut_xm65_m*16}
.param x_dut_xm57_m = {x_dut_xm65_m*4}
.param x_dut_xm6_m = {x_dut_xm65_m*4}
.param x_dut_xm5_m = {x_dut_xm65_m*4}
.param x_dut_xm4_m = {x_dut_xm65_m*8}
.param x_dut_xm62_m = {x_dut_xm65_m*4}
.param x_dut_xm3_m = {x_dut_xm65_m*4}
.param x_dut_xm61_m = {x_dut_xm65_m*4}
.param x_dut_xm2_m = {x_dut_xm65_m*4}
.param x_dut_xm58_m = {x_dut_xm65_m*4}
.param x_dut_xm1_m = {x_dut_xm65_m*4}
.param x_dut_xm0_m = {x_dut_xm65_m*4}
.param x_dut_xm19_m = {x_dut_xm14_m*8}
.param x_dut_xm15_m = {x_dut_xm14_m*8}
.param x_dut_xm20_m = {x_dut_xm14_m*8}
.param x_dut_xm16_m = {x_dut_xm14_m*8}
.param x_dut_xm17_m = {x_dut_xm14_m*4}
.param x_dut_xm67_m = {x_dut_xm14_m*32}
.param x_dut_xm12_m = {x_dut_xm14_m*4}
.param x_dut_xm18_m = {x_dut_xm14_m*4}
.param x_dut_xm13_m = {x_dut_xm14_m*4}
.param x_dut_xm64_m = {x_dut_xm14_m*4}
.param x_dut_xm63_m = {x_dut_xm14_m*4}
.subckt amp_011_peng_iac vss vdd vinn vinp vout
C0 VOUTP VOUT 'CAPACITOR_0'
C1 net10 net4 'CAPACITOR_1'
I0 VB1 vss 'CURRENT_0_BIAS'
R0 net4 vss 'RESISTOR_0'
XM0 net2 VB1 vdd vdd pfet_03v3 l=x_dut_xm0_l m=x_dut_xm0_m w=x_dut_xm0_w
XM1 net3 VB1 vdd vdd pfet_03v3 l=x_dut_xm1_l m=x_dut_xm1_m w=x_dut_xm1_w
XM10 net043 VOUTP vdd vdd pfet_03v3 l=x_dut_xm10_l m=x_dut_xm10_m w=x_dut_xm10_w
XM11 VOUT VOUTP vdd vdd pfet_03v3 l=x_dut_xm11_l m=x_dut_xm11_m w=x_dut_xm11_w
XM12 VB4 VB3 net54 vss nfet_03v3 l=x_dut_xm12_l m=x_dut_xm12_m w=x_dut_xm12_w
XM13 net7 VB3 net56 vss nfet_03v3 l=x_dut_xm13_l m=x_dut_xm13_m w=x_dut_xm13_w
XM14 VB3 VB3 vss vss nfet_03v3 l=x_dut_xm14_l m=x_dut_xm14_m w=x_dut_xm14_w
XM15 VOUTN VB3 DM_2 vss nfet_03v3 l=x_dut_xm15_l m=x_dut_xm15_m w=x_dut_xm15_w
XM16 VOUTP VB3 net063 vss nfet_03v3 l=x_dut_xm16_l m=x_dut_xm16_m w=x_dut_xm16_w
XM17 net54 VB4 vss vss nfet_03v3 l=x_dut_xm17_l m=x_dut_xm17_m w=x_dut_xm17_w
XM18 net56 VB4 vss vss nfet_03v3 l=x_dut_xm18_l m=x_dut_xm18_m w=x_dut_xm18_w
XM19 DM_2 VB4 vss vss nfet_03v3 l=x_dut_xm19_l m=x_dut_xm19_m w=x_dut_xm19_w
XM2 net6 VB1 vdd vdd pfet_03v3 l=x_dut_xm2_l m=x_dut_xm2_m w=x_dut_xm2_w
XM20 net063 VB4 vss vss nfet_03v3 l=x_dut_xm20_l m=x_dut_xm20_m w=x_dut_xm20_w
XM23 VOUT net10 vss vss nfet_03v3 l=x_dut_xm23_l m=x_dut_xm23_m w=x_dut_xm23_w
XM3 net8 VB1 vdd vdd pfet_03v3 l=x_dut_xm3_l m=x_dut_xm3_m w=x_dut_xm3_w
XM4 net31 VB1 vdd vdd pfet_03v3 l=x_dut_xm4_l m=x_dut_xm4_m w=x_dut_xm4_w
XM5 VOUTN VOUTN vdd vdd pfet_03v3 l=x_dut_xm5_l m=x_dut_xm5_m w=x_dut_xm5_w
XM57 VB1 VB2 net2 vdd pfet_03v3 l=x_dut_xm57_l m=x_dut_xm57_m w=x_dut_xm57_w
XM58 VB4 VB2 net3 vdd pfet_03v3 l=x_dut_xm58_l m=x_dut_xm58_m w=x_dut_xm58_w
XM6 VOUTP VOUTN vdd vdd pfet_03v3 l=x_dut_xm6_l m=x_dut_xm6_m w=x_dut_xm6_w
XM61 net7 VB2 net6 vdd pfet_03v3 l=x_dut_xm61_l m=x_dut_xm61_m w=x_dut_xm61_w
XM62 VB3 VB2 net8 vdd pfet_03v3 l=x_dut_xm62_l m=x_dut_xm62_m w=x_dut_xm62_w
XM63 VB2 VB3 net9 vss nfet_03v3 l=x_dut_xm63_l m=x_dut_xm63_m w=x_dut_xm63_w
XM64 net9 VB4 vss vss nfet_03v3 l=x_dut_xm64_l m=x_dut_xm64_m w=x_dut_xm64_w
XM65 VB2 VB2 vdd vdd pfet_03v3 l=x_dut_xm65_l m=x_dut_xm65_m w=x_dut_xm65_w
XM66 net10 VB2 net049 vdd pfet_03v3 l=x_dut_xm66_l m=x_dut_xm66_m w=x_dut_xm66_w
XM67 net043 VB3 net1 vss nfet_03v3 l=x_dut_xm67_l m=x_dut_xm67_m w=x_dut_xm67_w
XM68 net1 VB4 vss vss nfet_03v3 l=x_dut_xm68_l m=x_dut_xm68_m w=x_dut_xm68_w
XM69 net10 net043 vss vss nfet_03v3 l=x_dut_xm69_l m=x_dut_xm69_m w=x_dut_xm69_w
XM7 net049 VB1 vdd vdd pfet_03v3 l=x_dut_xm7_l m=x_dut_xm7_m w=x_dut_xm7_w
XM70 net1 net043 vss vss nfet_03v3 l=x_dut_xm70_l m=x_dut_xm70_m w=x_dut_xm70_w
XM8 DM_2 VINN net31 net31 pfet_03v3 l=x_dut_xm8_l m=x_dut_xm8_m w=x_dut_xm8_w
XM9 net063 VINP net31 net31 pfet_03v3 l=x_dut_xm9_l m=x_dut_xm9_m w=x_dut_xm9_w
.ends
.end
