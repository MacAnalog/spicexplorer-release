** GENERATED by `analog-db export-raw` — DO NOT EDIT.
** circuit=amp_002_alfio_raffc  class=amplifier  pdk=sky130  testbench=iip3  corner=tt
** Self-contained deck: testbench + bound params + lowered DUT (.subckt amp_002_alfio_raffc).
** PDK corner libs resolve by BARE NAME on the image's ngspice sourcepath — run in a
** PDK-enabled env (the base image / api container), NOT a bare host:
**   docker run --rm -i spicexplorer-spice-base:local \
**     bash -lc 'd=$(mktemp -d) && cat > $d/c.spice && cd $d && ngspice -b c.spice' < raw/amp_002_alfio_raffc/sky130/iip3.spice
*----------------------------------------------------------*
** params: 27 free + 0 frozen knobs (sizing.yaml) · 35 tied · 13 ratio-derived (abstract/params.yaml) · 4 testbench params
** AUTHORED TEMPLATE — amplifier/iip3_selfbias (2026-08-01): two-tone third-order intercept in
** the unity buffer for SELF-BIASED DUTs (no ibias port — the TI-LDO error amps amp_032/033).
** Identical to `iip3` except there is no external bias source — derived exactly as
** psrr_vdd_selfbias derives from psrr_vdd (drop `.param IBIAS` and the `Ibias` line), so a
** 5-port [vdd vout vinp vinn vss] DUT does not leave a current source driving a dangling
** `ibias` node (which makes the DC solve singular). The unity-buffer DC op point is the same
** one ac_closed_loop_selfbias / linearity_selfbias already prove out for these DUTs, so
** biasing is safe. EVERYTHING measurement-side is grafted from iip3.spice UNCHANGED — that
** header carries the full audited story and is the reference for any future edit here; the
** load-bearing invariants it establishes (do not relax ANY of them):
**   * BIN PLACEMENT: F1/F2 MUST be integer multiples of F0 = gcd(F1,F2) so the tones AND both
**     IM3 products (2F1-F2, 2F2-F1) AND both IM5 products (3F1-2F2, 3F2-2F1) land on exact
**     bins — zero scalloping/leakage in the rectangular-window DFT.
**   * COHERENCE + SETTLING: BOTH TSTART and (TSTOP-TSTART) must be integer numbers of BEAT
**     periods 1/F0; TSTEP <= 1/(200*F2). The startup transient leaks into every bin otherwise
**     and buries the uV-scale IM3 products.
**   * ENDPOINT-DUPLICATION CORRECTION: `linearize` returns np = nd+1 points whose last sample
**     repeats the first; every bin is (mean(vac*c)*np - vac[0]*c[0])/nd. The naive mean() bias
**     WAS this deck's whole noise floor (measured: 2.3e-7 V, only 11 dB under the real IM3;
**     corrected 1.6e-11 V). a_floor (bin 5*F0 — lowest-order product there is NINTH order) is
**     the trust check: a_im3 must sit well above it or the tones/window are wrong.
**   * DRIVE: default ASIG = 6.25 mV per tone — the geometric centre of the measured valid
**     window (compression bounds it above at ~14 mV, the deck's own floor below at ~2.5 mV;
**     the old 50 mV read up to 1.40 dB optimistic). iip3_comp_db estimates the residual
**     |IIP3 error| from the IM5/IM3 ratio — an ESTIMATE, not a bound; usable one-sided only
**     at the shipped drive.
**   * `write` BEFORE `linearize` (linearize swaps the current plot and would gut the raw).
**   * DEAD-OUTPUT GUARD: MEASURED worst-side tone gain off the drive bins (a_drv), threshold
**     0.5 = the |A| = 1 line of gain_tone = A/(1+A). On a fail iip3_dbv = -999 and
**     im3_dbc = +999 — both bad-direction sentinels, NOT NaN (a NaN makes the runner discard
**     the whole analysis). It is a SCREEN, not a proof.
**   * No `>` inside a `let` — the .control preprocessor strips it as an output redirection
**     and silently truncates the RHS; masks use `<=` and 1 - mask.
**   * BINDING FORM: ASIG, F0, F1, F2 reach control-language ARITHMETIC — plain decimals /
**     scientific notation only (0.00625, 0.9e6), NEVER SPICE suffixes (6.25m, 900k).
**     TSTEP/TSTART/TSTOP only reach the `tran` card, so suffixes are fine there.
**   * Measure names match the ibias sibling EXACTLY (a_f1, a_f2, a_drv, gain_tone,
**     gain_tone_db, a_im3l/h, a_im5l/h, a_floor, im3_dbc, iip3_dbv, im5_im3_db, iip3_comp_db)
**     so datasheet wiring stays uniform across template variants; none is in
**     raw_project._SPEC_REGISTRY (in particular the buffer gain is `gain_tone`, NOT the
**     registry's `gain_cl`).
** Bindings: DUT PORT_LINE VDD VCM CL ASIG F0 F1 F2 TSTEP TSTART TSTOP PDK_INCLUDE.
.lib sky130.lib.spice tt
.temp 27

.param VDD=1.8
.param VCM=300m
.param CL=10p
.param ASIG=0.00625

Vdd  vdd 0 dc {VDD}
Vss  vss 0 dc 0
CLoad vout 0 {CL}

* unity buffer; two series-stacked tones — the lower source carries the VCM offset
Vton vinp mid sin(0 {ASIG} 0.09e6)
Vtwo mid  0   sin({VCM} {ASIG} 0.1e6)
Vfb  vinn vout dc 0

XDUT vss vdd vinn vinp vout amp_002_alfio_raffc

.control
  set filetype=ascii
  tran 50n 2.1m 100u
  * raw first — `linearize` below switches the current plot to its interpolated scratch
  * copy, so a trailing `write` guts the raw to the DFT leftovers instead of the full
  * node set (thd.spice's header has the measured story)
  write
  let vo = v(vout)
  let vi = v(vinp)
  linearize vo vi
  let t = time
  let vac = vo - mean(vo)
  let vin_ac = vi - mean(vi)
  let np = length(vac)
  let nd = np - 1
* --- coherent single-bin DFT: amplitude at f is 2*|(1/N) sum vac*e^-jwt| over the N
* --- NON-redundant samples. `linearize` returns N+1 points spanning exactly 20 beat
* --- periods, so its last sample REPEATS its first; leaving it in biases every bin by
* --- |vac[0]|/N — measured, that bias WAS this deck's whole noise floor (it fell exactly
* --- as 1/N under both TSTEP and window scaling). mean()*np recovers the sum; the
* --- vac[0]*c[0] term drops the duplicate, making the window exactly rectangular.
  let c_f1 = cos(2*pi*0.09e6*t)
  let s_f1 = sin(2*pi*0.09e6*t)
  let re_f1 = (mean(vac*c_f1)*np - vac[0]*c_f1[0])/nd
  let im_f1 = (mean(vac*s_f1)*np - vac[0]*s_f1[0])/nd
  let a_f1  = 2*sqrt(re_f1^2+im_f1^2)
* --- the SAME bin taken on the DRIVE v(vinp) — the reference for the dead-output guard ---
  let rd_f1 = (mean(vin_ac*c_f1)*np - vin_ac[0]*c_f1[0])/nd
  let id_f1 = (mean(vin_ac*s_f1)*np - vin_ac[0]*s_f1[0])/nd
  let a_dr1 = 2*sqrt(rd_f1^2+id_f1^2)
  let c_f2 = cos(2*pi*0.1e6*t)
  let s_f2 = sin(2*pi*0.1e6*t)
  let re_f2 = (mean(vac*c_f2)*np - vac[0]*c_f2[0])/nd
  let im_f2 = (mean(vac*s_f2)*np - vac[0]*s_f2[0])/nd
  let a_f2  = 2*sqrt(re_f2^2+im_f2^2)
  let rd_f2 = (mean(vin_ac*c_f2)*np - vin_ac[0]*c_f2[0])/nd
  let id_f2 = (mean(vin_ac*s_f2)*np - vin_ac[0]*s_f2[0])/nd
  let a_dr2 = 2*sqrt(rd_f2^2+id_f2^2)
  let c_3l = cos(2*pi*(2*0.09e6-0.1e6)*t)
  let s_3l = sin(2*pi*(2*0.09e6-0.1e6)*t)
  let re_3l = (mean(vac*c_3l)*np - vac[0]*c_3l[0])/nd
  let im_3l = (mean(vac*s_3l)*np - vac[0]*s_3l[0])/nd
  let a_im3l = 2*sqrt(re_3l^2+im_3l^2)
  let c_3h = cos(2*pi*(2*0.1e6-0.09e6)*t)
  let s_3h = sin(2*pi*(2*0.1e6-0.09e6)*t)
  let re_3h = (mean(vac*c_3h)*np - vac[0]*c_3h[0])/nd
  let im_3h = (mean(vac*s_3h)*np - vac[0]*s_3h[0])/nd
  let a_im3h = 2*sqrt(re_3h^2+im_3h^2)
* --- 5th-order products at 3F1-2F2 and 3F2-2F1 — the COMPRESSION INDICATOR (see the
* --- iip3.spice header). They ride the same coherent grid as everything else, so they cost
* --- two bin pairs and no extra simulation.
  let c_5l = cos(2*pi*(3*0.09e6-2*0.1e6)*t)
  let s_5l = sin(2*pi*(3*0.09e6-2*0.1e6)*t)
  let re_5l = (mean(vac*c_5l)*np - vac[0]*c_5l[0])/nd
  let im_5l = (mean(vac*s_5l)*np - vac[0]*s_5l[0])/nd
  let a_im5l = 2*sqrt(re_5l^2+im_5l^2)
  let c_5h = cos(2*pi*(3*0.1e6-2*0.09e6)*t)
  let s_5h = sin(2*pi*(3*0.1e6-2*0.09e6)*t)
  let re_5h = (mean(vac*c_5h)*np - vac[0]*c_5h[0])/nd
  let im_5h = (mean(vac*s_5h)*np - vac[0]*s_5h[0])/nd
  let a_im5h = 2*sqrt(re_5h^2+im_5h^2)
  let c_fl = cos(2*pi*5*0.01e6*t)
  let s_fl = sin(2*pi*5*0.01e6*t)
  let re_fl = (mean(vac*c_fl)*np - vac[0]*c_fl[0])/nd
  let im_fl = (mean(vac*s_fl)*np - vac[0]*s_fl[0])/nd
  let a_floor = 2*sqrt(re_fl^2+im_fl^2)
* --- worst-side IM3/IM5 over the weaker tone; min/max of two scalars without branching ---
  let a_fund = 0.5*(a_f1+a_f2 - abs(a_f1-a_f2))
  let a_im3  = 0.5*(a_im3l+a_im3h + abs(a_im3l-a_im3h))
  let a_im5  = 0.5*(a_im5l+a_im5h + abs(a_im5l-a_im5h))
  let a_drv  = 0.5*(a_dr1+a_dr2 - abs(a_dr1-a_dr2))
* --- floors keep log10() finite when a bin lands on zero (a NaN aborts the run) ---
  let a_fund_g = a_fund + 1e-15
  let a_im3_g  = a_im3 + 1e-15
* --- DEAD-OUTPUT GUARD (see the header): a MEASURED gain, not a NaN check. Do NOT write
* --- `>` inside a `let` — the control preprocessor strips it as an output redirection and
* --- silently truncates the RHS. Masks use `<=`, inverted with 1 - mask.
  let gain_tone = a_fund/(a_drv + 1e-18)
  let gain_tone_db = 20*log10(gain_tone + 1e-18)
  let dead = (gain_tone <= 0.5)
  let live = 1 - dead
* input-referred: OIP3 = 20log10(a_fund) - im3_dbc/2, and the measured buffer gain is
* a_fund/ASIG, so IIP3 = OIP3 - 20log10(a_fund/ASIG) = 20log10(ASIG) - im3_dbc/2.
* ASIG (the BINDING, not a_drv) is the reference on purpose: the Spectre lane's
* calculator.yaml iip3_dbv passes the same `AMPL: 0.00625`, so both lanes stay identical.
* a_drv is printed beside it — if it disagrees with ASIG, the stimulus is mis-bound.
  let im3_raw  = 20*log10(a_im3_g/a_fund_g)
  let iip3_raw = 20*log10(0.00625) - im3_raw/2
  let im3_dbc  = live*im3_raw  + dead*999
  let iip3_dbv = live*iip3_raw - dead*999
* --- COMPRESSION INDICATOR (see the header): |IIP3 error| ~ 21.7 * a_im5/a_im3 dB.
  let im5_im3_db  = 20*log10((a_im5 + 1e-18)/a_im3_g)
  let iip3_comp_db = live*21.71*a_im5/a_im3_g
  print a_f1 a_f2 a_drv gain_tone gain_tone_db a_im3l a_im3h a_im5l a_im5h a_floor
  print im3_dbc iip3_dbv im5_im3_db iip3_comp_db
  quit
.endc
.param CAPACITOR_0=1.3e-11
.param CAPACITOR_1=3.75e-13
.param CURRENT_0_BIAS=2.8e-05
.param x_dut_xm6_l=6.0745
.param x_dut_xm3_m=2
.param x_dut_xm6_w=83.9081
.param x_dut_xm10_l=1
.param x_dut_xm10_m=2
.param x_dut_xm10_w=20.7315
.param x_dut_xm11_l=2.6754
.param x_dut_xm11_m=2
.param x_dut_xm11_w=40
.param x_dut_xm15_l=6.3215
.param x_dut_xm15_m=4
.param x_dut_xm15_w=56.9217
.param x_dut_xm59_l=2
.param x_dut_xm14_m=2
.param x_dut_xm59_w=14.5237
.param x_dut_xm21_l=1
.param x_dut_xm21_m=6
.param x_dut_xm21_w=12
.param x_dut_xm7_l=0.6033
.param x_dut_xm7_m=2
.param x_dut_xm7_w=8
.param x_dut_xm9_l=0.797
.param x_dut_xm9_m=2
.param x_dut_xm9_w=8.0125
* ---- GENERATED parameter ties (abstract/params.yaml groups/ratios) ----
* Each tied symbol is defined exactly once, by its line below; rewrite that
* .param to untie just that symbol (untying = shadowing, plan D-3).
.param x_dut_xm5_w = {x_dut_xm6_w}
.param x_dut_xm4_w = {x_dut_xm6_w}
.param x_dut_xm3_w = {x_dut_xm6_w}
.param x_dut_xm2_w = {x_dut_xm6_w}
.param x_dut_xm1_w = {x_dut_xm6_w}
.param x_dut_xm0_w = {x_dut_xm6_w}
.param x_dut_xm5_l = {x_dut_xm6_l}
.param x_dut_xm4_l = {x_dut_xm6_l}
.param x_dut_xm3_l = {x_dut_xm6_l}
.param x_dut_xm2_l = {x_dut_xm6_l}
.param x_dut_xm1_l = {x_dut_xm6_l}
.param x_dut_xm0_l = {x_dut_xm6_l}
.param x_dut_xm8_w = {x_dut_xm9_w}
.param x_dut_xm8_l = {x_dut_xm9_l}
.param x_dut_xm8_m = {x_dut_xm9_m}
.param x_dut_xm19_w = {x_dut_xm59_w}
.param x_dut_xm20_w = {x_dut_xm59_w}
.param x_dut_xm17_w = {x_dut_xm59_w}
.param x_dut_xm14_w = {x_dut_xm59_w}
.param x_dut_xm12_w = {x_dut_xm59_w}
.param x_dut_xm18_w = {x_dut_xm59_w}
.param x_dut_xm13_w = {x_dut_xm59_w}
.param x_dut_xm19_l = {x_dut_xm59_l}
.param x_dut_xm20_l = {x_dut_xm59_l}
.param x_dut_xm17_l = {x_dut_xm59_l}
.param x_dut_xm14_l = {x_dut_xm59_l}
.param x_dut_xm12_l = {x_dut_xm59_l}
.param x_dut_xm18_l = {x_dut_xm59_l}
.param x_dut_xm13_l = {x_dut_xm59_l}
.param x_dut_xm22_w = {x_dut_xm21_w}
.param x_dut_xm22_l = {x_dut_xm21_l}
.param x_dut_xm22_m = {x_dut_xm21_m}
.param x_dut_xm16_w = {x_dut_xm15_w}
.param x_dut_xm16_l = {x_dut_xm15_l}
.param x_dut_xm16_m = {x_dut_xm15_m}
.param x_dut_xm6_m = {x_dut_xm3_m*8}
.param x_dut_xm5_m = {x_dut_xm3_m*8}
.param x_dut_xm4_m = {x_dut_xm3_m*2}
.param x_dut_xm2_m = {x_dut_xm3_m*1}
.param x_dut_xm1_m = {x_dut_xm3_m*1}
.param x_dut_xm0_m = {x_dut_xm3_m*1}
.param x_dut_xm59_m = {x_dut_xm14_m*8}
.param x_dut_xm19_m = {x_dut_xm14_m*8}
.param x_dut_xm20_m = {x_dut_xm14_m*8}
.param x_dut_xm17_m = {x_dut_xm14_m*4}
.param x_dut_xm12_m = {x_dut_xm14_m*4}
.param x_dut_xm18_m = {x_dut_xm14_m*4}
.param x_dut_xm13_m = {x_dut_xm14_m*4}
.subckt amp_002_alfio_raffc vss vdd vinn vinp vout
C0 net063 VOUT 'CAPACITOR_0'
C1 net050 net013 'CAPACITOR_1'
I0 net1 vss 'CURRENT_0_BIAS'
XM0 net1 net1 vdd vdd sky130_fd_pr__pfet_01v8 l=x_dut_xm0_l m=x_dut_xm0_m w=x_dut_xm0_w
XM1 VB4 net1 vdd vdd sky130_fd_pr__pfet_01v8 l=x_dut_xm1_l m=x_dut_xm1_m w=x_dut_xm1_w
XM10 net013 net050 vdd vdd sky130_fd_pr__pfet_01v8 l=x_dut_xm10_l m=x_dut_xm10_m w=x_dut_xm10_w
XM11 VOUT net050 vdd vdd sky130_fd_pr__pfet_01v8 l=x_dut_xm11_l m=x_dut_xm11_m w=x_dut_xm11_w
XM12 VB4 VB3 net54 vss sky130_fd_pr__nfet_01v8 l=x_dut_xm12_l m=x_dut_xm12_m w=x_dut_xm12_w
XM13 DM_1 VB3 net56 vss sky130_fd_pr__nfet_01v8 l=x_dut_xm13_l m=x_dut_xm13_m w=x_dut_xm13_w
XM14 VB3 VB3 vss vss sky130_fd_pr__nfet_01v8 l=x_dut_xm14_l m=x_dut_xm14_m w=x_dut_xm14_w
XM15 VOUTN VB3 DM_2 vss sky130_fd_pr__nfet_01v8 l=x_dut_xm15_l m=x_dut_xm15_m w=x_dut_xm15_w
XM16 net050 VB3 net063 vss sky130_fd_pr__nfet_01v8 l=x_dut_xm16_l m=x_dut_xm16_m w=x_dut_xm16_w
XM17 net54 VB4 vss vss sky130_fd_pr__nfet_01v8 l=x_dut_xm17_l m=x_dut_xm17_m w=x_dut_xm17_w
XM18 net56 VB4 vss vss sky130_fd_pr__nfet_01v8 l=x_dut_xm18_l m=x_dut_xm18_m w=x_dut_xm18_w
XM19 DM_2 VB4 vss vss sky130_fd_pr__nfet_01v8 l=x_dut_xm19_l m=x_dut_xm19_m w=x_dut_xm19_w
XM2 DM_1 net1 vdd vdd sky130_fd_pr__pfet_01v8 l=x_dut_xm2_l m=x_dut_xm2_m w=x_dut_xm2_w
XM20 net063 VB4 vss vss sky130_fd_pr__nfet_01v8 l=x_dut_xm20_l m=x_dut_xm20_m w=x_dut_xm20_w
XM21 net043 net043 vss vss sky130_fd_pr__nfet_01v8 l=x_dut_xm21_l m=x_dut_xm21_m w=x_dut_xm21_w
XM22 VOUT net043 vss vss sky130_fd_pr__nfet_01v8 l=x_dut_xm22_l m=x_dut_xm22_m w=x_dut_xm22_w
XM3 VB3 net1 vdd vdd sky130_fd_pr__pfet_01v8 l=x_dut_xm3_l m=x_dut_xm3_m w=x_dut_xm3_w
XM4 net31 net1 vdd vdd sky130_fd_pr__pfet_01v8 l=x_dut_xm4_l m=x_dut_xm4_m w=x_dut_xm4_w
XM5 VOUTN VOUTN vdd vdd sky130_fd_pr__pfet_01v8 l=x_dut_xm5_l m=x_dut_xm5_m w=x_dut_xm5_w
XM59 net013 VB4 vss vss sky130_fd_pr__nfet_01v8 l=x_dut_xm59_l m=x_dut_xm59_m w=x_dut_xm59_w
XM6 net050 VOUTN vdd vdd sky130_fd_pr__pfet_01v8 l=x_dut_xm6_l m=x_dut_xm6_m w=x_dut_xm6_w
XM7 net043 net013 vdd vdd sky130_fd_pr__pfet_01v8 l=x_dut_xm7_l m=x_dut_xm7_m w=x_dut_xm7_w
XM8 DM_2 VINN net31 net31 sky130_fd_pr__pfet_01v8 l=x_dut_xm8_l m=x_dut_xm8_m w=x_dut_xm8_w
XM9 net063 VINP net31 net31 sky130_fd_pr__pfet_01v8 l=x_dut_xm9_l m=x_dut_xm9_m w=x_dut_xm9_w
.ends
.end
