** GENERATED by `analog-db export-raw` — DO NOT EDIT.
** circuit=amp_033_ti_ldo_ref_selfbias  class=amplifier  pdk=sky130  testbench=psrr_vdd  corner=tt
** Self-contained deck: testbench + bound params + lowered DUT (.subckt amp_033_ti_ldo_ref_selfbias).
** PDK corner libs resolve by BARE NAME on the image's ngspice sourcepath — run in a
** PDK-enabled env (the base image / api container), NOT a bare host:
**   docker run --rm -i spicexplorer-spice-base:local \
**     bash -lc 'd=$(mktemp -d) && cat > $d/c.spice && cd $d && ngspice -b c.spice' < raw/amp_033_ti_ldo_ref_selfbias/sky130/psrr_vdd.spice
*----------------------------------------------------------*
** params: 16 free + 0 frozen knobs (sizing.yaml) · 6 tied · 0 ratio-derived (abstract/params.yaml) · 3 testbench params
** AUTHORED TEMPLATE — amplifier/psrr_vdd_selfbias (plan D-4/D-5): positive-supply rejection
** for self-biased DUTs (no ibias port — the AnalogGym amplifiers). Identical to psrr_vdd
** except there is no external bias source. The DUT is closed in a unity-gain buffer (vinn
** shorted to vout, vinp held at VCM with NO ac) and the supply Vdd carries a 1 V AC ripple;
** with the signal input quiet, every AC volt at vout is supply feed-through, so
** PSRR+ = −20·log10|vout/vdd| = −vdb(vout). Reported at FSTART (the DC-band floor).
** The unity-buffer DC op point is the same one the ac_open_loop_biaswrap bench already
** proves out for these DUTs (Lfb shorts vout→vinn at DC), so biasing is safe.
** Bindings: DUT PORT_LINE VDD VCM CL FSTART FSTOP PPD PDK_INCLUDE.
.lib sky130.lib.spice tt
.temp 27

.param VDD=1.8
.param VCM=0.9
.param CL=10p

Vdd  vdd 0 dc {VDD} ac 1     ; 1 V supply-ripple stimulus
Vss  vss 0 dc 0
CLoad vout 0 {CL}

Vinp vinp 0 dc {VCM}         ; signal input held quiet (no ac) — isolate the supply path
Vfb  vinn vout dc 0          ; unity-gain buffer: vinn shorted to vout

XDUT vdd vout vinp vinn vss amp_033_ti_ldo_ref_selfbias

.control
  set filetype=ascii
  ac dec 101 1k 1G
  let psrr = -vdb(vout)
  meas ac psrr_vdd_db FIND psrr AT=1k
  write
  quit
.endc
.param x_dut_xmbp_w=23.71339160604486
.param x_dut_xmbp_l=1.1974442129526897
.param x_dut_xmb0_w=14.316321410441935
.param x_dut_xmb0_l=4.017319560601552
.param x_dut_xmbc_w=26.895472565757352
.param x_dut_xmbc_m=1
.param x_dut_xmbo_w=17.003801287035284
.param x_dut_xmbo_m=1
.param x_dut_xm1_w=13.80211797930676
.param x_dut_xm1_l=0.8298635361175917
.param x_dut_xm3_w=12.154294570182673
.param x_dut_xm3_l=1.159444890985505
.param x_dut_xm5_w=9.903158187330707
.param x_dut_xm5_l=2.949529504310346
.param r_z=49350.31244197376
.param c_comp=5.9836450528951e-12
* ---- GENERATED parameter ties (abstract/params.yaml groups/ratios) ----
* Each tied symbol is defined exactly once, by its line below; rewrite that
* .param to untie just that symbol (untying = shadowing, plan D-3).
.param x_dut_xm4_w = {x_dut_xm3_w}
.param x_dut_xm4_l = {x_dut_xm3_l}
.param x_dut_xm2_w = {x_dut_xm1_w}
.param x_dut_xm2_l = {x_dut_xm1_l}
.param x_dut_xmbc_l = {x_dut_xmb0_l}
.param x_dut_xmbo_l = {x_dut_xmb0_l}
.subckt amp_033_ti_ldo_ref_selfbias vdd vout vinp vinn vss
CC ncz vout 'c_comp'
RZ nb ncz 'r_z'
XM1 na vinn tail vss sky130_fd_pr__nfet_01v8 l=x_dut_xm1_l w=x_dut_xm1_w
XM2 nb vinp tail vss sky130_fd_pr__nfet_01v8 l=x_dut_xm2_l w=x_dut_xm2_w
XM3 na na vdd vdd sky130_fd_pr__pfet_01v8 l=x_dut_xm3_l w=x_dut_xm3_w
XM4 nb na vdd vdd sky130_fd_pr__pfet_01v8 l=x_dut_xm4_l w=x_dut_xm4_w
XM5 vout nb vdd vdd sky130_fd_pr__pfet_01v8 l=x_dut_xm5_l w=x_dut_xm5_w
XMB0 ibias ibias vss vss sky130_fd_pr__nfet_01v8 l=x_dut_xmb0_l w=x_dut_xmb0_w
XMBC tail ibias vss vss sky130_fd_pr__nfet_01v8 l=x_dut_xmbc_l m=x_dut_xmbc_m w=x_dut_xmbc_w
XMBO vout ibias vss vss sky130_fd_pr__nfet_01v8 l=x_dut_xmbo_l m=x_dut_xmbo_m w=x_dut_xmbo_w
XMBP ibias ibias vdd vdd sky130_fd_pr__pfet_01v8 l=x_dut_xmbp_l w=x_dut_xmbp_w
.ends
.end
