** GENERATED by `analog-db generate` — DO NOT EDIT. Source: abstract/netlist.spice → gf180mcu
* dp_001_resistive_load (emitted by spicexplorer-circuitgraph)
RN vdd voutn x_dut_rn_value
RP vdd voutp x_dut_rp_value
XMN voutn vinn tail vss nfet_03v3 l=x_dut_xmn_l m=x_dut_xmn_m w=x_dut_xmn_w
XMP voutp vinp tail vss nfet_03v3 l=x_dut_xmp_l m=x_dut_xmp_m w=x_dut_xmp_w
XMR ibias ibias vss vss nfet_03v3 l=x_dut_xmr_l m=x_dut_xmr_m w=x_dut_xmr_w
XMT tail ibias vss vss nfet_03v3 l=x_dut_xmt_l m=x_dut_xmt_m w=x_dut_xmt_w
.end
