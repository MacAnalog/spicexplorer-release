** GENERATED by `analog-db export-raw` — DO NOT EDIT.
** circuit=amp_026_fan_chopper_ota  class=amplifier  pdk=ihp-sg13g2  testbench=thd  corner=tt
** Self-contained deck: testbench + bound params + lowered DUT (.subckt amp_026_fan_chopper_ota).
** PDK corner libs resolve by BARE NAME on the image's ngspice sourcepath — run in a
** PDK-enabled env (the base image / api container), NOT a bare host:
**   docker run --rm -i spicexplorer-spice-base:local \
**     bash -lc 'd=$(mktemp -d) && cat > $d/c.spice && cd $d && ngspice -b c.spice' < raw/amp_026_fan_chopper_ota/ihp-sg13g2/thd.spice
*----------------------------------------------------------*
** params: 23 free + 10 frozen knobs (sizing.yaml) · 42 tied · 0 ratio-derived (abstract/params.yaml) · 4 testbench params
** AUTHORED TEMPLATE — amplifier/thd_diff: large-signal harmonic distortion of a
** FULLY-DIFFERENTIAL amplifier in the differential unity-feedback (follower) connection.
** A single tone at F0 (differential amplitude ASIG, split +/- ASIG/2 antiphase about VCM)
** drives the closed loop; THD of the DIFFERENTIAL output v(voutp)-v(voutn) is computed
** IN-DECK by the same coherent single-bin DFT (harmonics 2..5, endpoint-duplication
** corrected) that thd.spice carries, so the runner's measure parser picks up thd_pct/thd_db
** directly. This is the structural fix thd.spice's dead-output guard points at: an FD member
** (voutp/voutn, no vout port) run through the single-ended deck leaves node `vout`
** capacitively fed and returns numbers from nothing — measured there: amp_023_fer_fd2s@ihp
** "thd_pct = 5.372 %", amp_027_fan_rrl_ota@ihp "3.537 %", all `status: ok`. This template
** gives those cells a real bench instead.
**
** THE FEEDBACK NETWORK IS tran_step_diff's, NOT A NEW ONE. The closed-loop operating point
** is held exactly the way tran_step_diff holds it: ONE feedback path, vinn <- voutp (a 0 V
** DC source = ideal wire), input common mode set by VCM on the vinp side. At DC this deck's
** two sin sources are 0 V, so the bias network below is tran_step_diff's network verbatim
** and the DUT sits at the SAME operating point its settling bench certifies (that is also
** where TSTART comes from — see the binding: TSTART >> that bench's t_settle).
** The tone is then split per the FD drive convention: +ASIG/2 rides the vinp side about
** VCM, and -ASIG/2 rides IN SERIES with the feedback wire (about voutp). The differential
** error the DUT sees is identical to putting the full ASIG on vinp, but the split HALVES
** the input common-mode wobble the one-wire follower unavoidably produces (vinn follows
** voutp, so the input CM moves with the signal; full-tone-on-vinp wobbles it at ~ASIG,
** the split at ~ASIG/2) — less CM pumping of the DUT's CMFB inside the measured window.
**
** CLOSED-LOOP GAIN IS 2, NOT 1 — READ gain_tone ACCORDINGLY. Only voutp is fed back, so
** the loop divider is vod/2 (feedback factor 1/2): vod = A*(VCM + ASIG*sin - vocm - vod/2)
** -> vod ~ 2*(VCM - vocm) + 2*ASIG*sin for large A. Three consequences, all deliberate:
**   1. gain_tone (a1/a1_in) ideally reads 2.0, and the dead-output threshold is 2/3 — the
**      |A| = 1 physical line for THIS configuration (gain_tone = 2A/(2+A), = 2/3 at A = 1),
**      the exact analogue of thd.spice's 0.5 = A/(1+A) line for the unity buffer.
**   2. The PER-SIDE output swing is ASIG (voutp = vocm' + ASIG*sin, voutn antiphase), i.e.
**      each output node swings exactly as far as the SE bench's vout does at the same ASIG
**      binding — that per-side-swing match is what makes thd_pct comparable across the SE
**      and FD variants. ASIG keeps its SE meaning: the applied differential stimulus peak.
**   3. vod carries a real DC term 2*(VCM - vocm) — the follower drags voutp to VCM while
**      the CMFB holds the output common mode at ITS reference, so voutn takes the offset.
**      It is reported as vod_op and stripped before the DFT (exactly cancelled by the
**      endpoint correction anyway — see thd.spice's measured proof); pick ASIG so
**      |vod_op|/2 + ASIG stays inside the per-side output swing, or the bench measures
**      clipping (which is honest, but not the small-signal-linearity number you wanted).
**
** DFT: byte-for-byte the thd.spice estimator — coherent single-bin DFT on an integer-period
** window WITH the endpoint-duplication correction ((mean(v*c)*np - v[0]*c[0])/nd). The full
** measured justification (window-phase null test: naive thd swings 2.95x / a3 41x with
** opening phase, corrected 1.000x; TSTEP convergence; the a4/a5 ~ 2|vac[0]|/np artifact
** tell) lives in thd.spice's header — it is the audited reference, do not fork the math.
** Requirements carried over unchanged: (TSTOP-TSTART) MUST be a whole number of F0 periods
** (a half-period mismatch is fatal even corrected — measured 63x on the SE bench), TSTART
** need not be phase-aligned but MUST clear the closed-loop settling transient, >= 8 measured
** periods, TSTEP <= 1/(200*F0). One FD-specific note, MEASURED on both pilots: do NOT
** expect the textbook "balanced FD cancels even harmonics" here — a2 DOMINATES thd_pct on
** both (amp_023@ihp a2 = 2.45e-5 vs a3 = 9.69e-7 at ASIG = 0.1; amp_027@ihp 2.54e-3 vs
** 1.83e-4 at 0.05), and it scales exactly as a real second-order term (a2/a1 halves per
** drive halving, 2.001x/1.998x measured; a3/a1 quarters, 4.02x/4.11x). The reason is this
** CONFIGURATION, not a broken DUT: the follower's own DC term vod_op parks voutp and voutn
** at DIFFERENT operating points (consequence 3 above), so branch symmetry — the thing that
** cancels even orders — is broken by the bench's operating point itself. The even
** harmonics are therefore real and belong in thd_pct; just don't read a2 > a3 as a defect.
**
** OUTPUT COMMON-MODE DRIFT (cm_drift_v) — THE TRUST CHECK THIS BENCH ADDS. An FD
** large-signal number taken while the output common mode is still walking is meaningless:
** the operating point (headroom, per-device gm) changes THROUGH the DFT window, so the
** "harmonics" partly measure the walk. The drift is measured from the same linearized
** record: vcm_rec = (voutp+voutn)/2, and cm_drift_v = mean(vcm_rec over the SECOND half of
** the window) - mean(over the FIRST half). Each half is an integer number of F0 periods
** whenever the window holds an EVEN number of periods (bind it so — e.g. 16), which makes
** the halves' means exactly tone-blind (a coherent sinusoid sums to zero over whole periods
** on the uniform post-linearize grid); a smooth settling drift survives as ~half the full
** start-to-end walk. Read it against ASIG: cm_drift_v << ASIG or the record is not
** stationary and thd_pct is not trustworthy — lengthen TSTART, don't explain the number.
** vocm_op (the full-record mean CM) is printed beside it as the achieved CM level.
**
** `write` runs BEFORE `linearize` (linearize swaps the current plot for its interpolated
** scratch copy and would gut the raw to the DFT leftovers — thd.spice's header has the
** measured story); the DFT basis vectors created after it never reach the raw, so no unlet
** is needed. Sentinels are the loud 999 (bad direction for thd_pct's minimize intent), NOT
** NaN (a NaN makes the runner discard the whole analysis). No `>` inside any `let` — the
** control preprocessor strips it as an output redirection and silently truncates the RHS;
** masks use `<=` and 1-mask.
**
** Measures: a1 a2 a3 a4 a5 (differential harmonic amplitudes, V), a1_in (measured
** differential drive), gain_tone (~2 when live), thd_pct, thd_db, vod_op (differential
** output DC term), vocm_op, cm_drift_v. Only thd_pct/thd_db are canonical metrics; every
** diagnostic name is deliberately OUT of raw_project._SPEC_REGISTRY (`vod_op` not
** `vout_dc`, `gain_tone` not `gain_cl`) so none silently becomes an optimizer objective.
** BINDING FORM: ASIG and F0 reach control-language arithmetic below, so they must be plain
** decimals / scientific notation (0.1, 1.0e6) — NOT SPICE suffixes (100m, 1Meg). TSTEP/
** TSTART/TSTOP only reach the `tran` card, so suffixes are fine there.
**
** Assumes a self-biased, differential-in/differential-out DUT port order:
**   .subckt <id> vinp vinn voutp voutn vdd vss
** Required bindings: DUT PORT_LINE VDD VCM CL ASIG F0 TSTEP TSTART TSTOP PDK_INCLUDE.
.lib cornerMOSlv.lib mos_tt
.temp 27

.param VDD=1.2
.param VCM=0.6
.param CL=10p
.param ASIG=0.1

Vdd  vdd 0 dc {VDD}
Vss  vss 0 dc 0
CLoadp voutp 0 {CL}
CLoadn voutn 0 {CL}
Vcm  vcm 0 dc {VCM}
* Seed the DC solve at the intended output common mode. An FD core whose CM loop has more
* than one equilibrium (a one-sided / behavioral CMFB actuator can wind its output far past
* the rails and sit there) otherwise lands in whichever basin the solver walks into, and the
* answer becomes a function of the bench topology instead of the circuit. MEASURED: a no-op
* on 18 of the 19 open-PDK cells (bit-identical measures) and the difference between a dead
* and a live amp_025@ihp-sg13g2 on the 19th.
.nodeset v(voutp)=0.6 v(voutn)=0.6

* DIFFERENTIAL-ONLY feedback (see header). Each input rides on a VCVS that carries ONLY the
* differential half of the output, referenced to VCM: vfbp = VCM - vod/4, vfbn = VCM + vod/4.
* So vid = ASIG*sin - vod/2 (feedback factor 1/2, closed-loop gain 2 — UNCHANGED) while the
* input common mode is pinned at VCM and carries no signal. The DUT's own CM control — or
* its absence — is then what sets vocm, which is the thing this bench is supposed to report.
Efbp vfbp vcm  voutn voutp 0.25
Efbn vfbn vcm  voutp voutn 0.25
Vinp vinp vfbp sin(0 {ASIG/2}  1.0e5)
Vinn vinn vfbn sin(0 {-ASIG/2} 1.0e5)

XDUT vinp vinn voutp voutn vdd vss amp_026_fan_chopper_ota

.control
  set filetype=ascii
  tran 20n 180u 20u
  * raw first — see the header; linearize below switches the current plot
  write
  let vd = v(voutp) - v(voutn)
  * the applied differential stimulus, reconstructed from its two halves: (vinp - vfbp) is
  * the +ASIG/2 source EMF, (vinn - vfbn) the -ASIG/2 one; their difference is the full
  * ASIG-peak differential drive — the dead-output guard's reference, measured, so a
  * mis-bound stimulus shows up as a1_in disagreeing with the ASIG binding.
  let vdrv = v(vinp) - v(vfbp) - v(vinn) + v(vfbn)
  * output common mode, for vocm_op + cm_drift_v
  let vcmr = 0.5*(v(voutp) + v(voutn))
  linearize vd vdrv vcmr
  let t = time
* --- endpoint-duplication correction (thd.spice's, verbatim): `linearize` hands back
* --- np = nd+1 points whose last sample repeats the first; mean()*np recovers the sum,
* --- subtracting v[0]*c[0] drops the duplicate, /nd gives the true rectangular-window
* --- average over one whole number of periods.
  let np = length(vd)
  let nd = np - 1
  let vod_op = (mean(vd)*np - vd[0])/nd
  * the DC strip is exactly cancelled by the correction (measured bit-identical on the SE
  * bench); kept because vod_op is reported anyway and `vac` reads clearer
  let vac = vd - vod_op
  let vin_ac = vdrv - mean(vdrv)
  let w = 2*pi*1.0e5
  let c1 = cos(w*t)
  let s1 = sin(w*t)
  let re1 = (mean(vac*c1)*np - vac[0]*c1[0])/nd
  let im1 = (mean(vac*s1)*np - vac[0]*s1[0])/nd
  let a1 = 2*sqrt(re1^2+im1^2)
* --- the SAME bin taken on the measured DRIVE — the dead-output guard's reference ---
  let rei = (mean(vin_ac*c1)*np - vin_ac[0]*c1[0])/nd
  let imi = (mean(vin_ac*s1)*np - vin_ac[0]*s1[0])/nd
  let a1_in = 2*sqrt(rei^2+imi^2)
  let c2 = cos(2*w*t)
  let s2 = sin(2*w*t)
  let re2 = (mean(vac*c2)*np - vac[0]*c2[0])/nd
  let im2 = (mean(vac*s2)*np - vac[0]*s2[0])/nd
  let a2 = 2*sqrt(re2^2+im2^2)
  let c3 = cos(3*w*t)
  let s3 = sin(3*w*t)
  let re3 = (mean(vac*c3)*np - vac[0]*c3[0])/nd
  let im3 = (mean(vac*s3)*np - vac[0]*s3[0])/nd
  let a3 = 2*sqrt(re3^2+im3^2)
  let c4 = cos(4*w*t)
  let s4 = sin(4*w*t)
  let re4 = (mean(vac*c4)*np - vac[0]*c4[0])/nd
  let im4 = (mean(vac*s4)*np - vac[0]*s4[0])/nd
  let a4 = 2*sqrt(re4^2+im4^2)
  let c5 = cos(5*w*t)
  let s5 = sin(5*w*t)
  let re5 = (mean(vac*c5)*np - vac[0]*c5[0])/nd
  let im5 = (mean(vac*s5)*np - vac[0]*s5[0])/nd
  let a5 = 2*sqrt(re5^2+im5^2)
* --- output common-mode drift over the record (see the header): half-window means, each an
* --- integer number of periods when the bound window is an even period count, so the tone
* --- cancels exactly and only the walk survives. Full-record mean = vocm_op.
  let vocm_op = (mean(vcmr)*np - vcmr[0])/nd
  let nh = floor(nd/2)
  let cm_first = mean(vcmr[0, nh-1])
  let cm_last  = mean(vcmr[nd-nh, nd-1])
  let cm_drift_v = cm_last - cm_first
* --- DEAD-OUTPUT GUARD (see the header): a MEASURED gain, not a NaN check. Threshold 2/3 =
* --- the |A| = 1 line for this gain-2 configuration (gain_tone = 2A/(2+A)). Do NOT write
* --- `>` inside a `let` — the control preprocessor strips it as an output redirection and
* --- silently truncates the RHS. Masks use `<=`, inverted with 1 - mask.
  let gain_tone = a1/(a1_in + 1e-18)
  let dead = (gain_tone <= 0.6667)
  let live = 1 - dead
  * the 1e-18 floors keep a dead output (a1 == 0) from emitting inf/NaN, which makes the
  * runner throw away the WHOLE analysis; they sit 12+ decades below any real amplitude
  let thd_raw = 100*sqrt(a2^2+a3^2+a4^2+a5^2)/(a1+1e-18)
  let thd_pct = live*thd_raw + dead*999
  let thd_db = 20*log10(thd_pct/100 + 1e-18)
  print a1 a2 a3 a4 a5 a1_in gain_tone thd_pct thd_db vod_op vocm_op cm_drift_v
  quit
.endc
.param x_dut_xm1_w=20u
.param x_dut_xm1_l=1u
.param x_dut_xm2_w=20u
.param x_dut_xm2_l=0.5u
.param x_dut_xm4_w=10u
.param x_dut_xm4_l=1u
.param x_dut_xm6_w=10u
.param x_dut_xm8_w=20u
.param x_dut_xm10_w=10u
.param x_dut_xm10_l=0.3u
.param x_dut_xm12_w=5u
.param x_dut_xm12_l=0.3u
.param x_dut_xm14_w=20u
.param x_dut_xm14_l=0.25u
.param x_dut_xm16_w=2u
.param x_dut_xm16_l=0.13u
.param x_dut_xm17_w=2u
.param x_dut_xm17_l=0.13u
.param x_dut_cm1_value=6p
.param vb1=0.3983759766
.param vb2=0.65
.param vb3=0.45
.param vb4=0.55
.param x_dut_xm1_m=1
.param x_dut_xm2_m=1
.param x_dut_xm4_m=1
.param x_dut_xm6_m=1
.param x_dut_xm8_m=1
.param x_dut_xm10_m=1
.param x_dut_xm12_m=1
.param x_dut_xm14_m=1
.param x_dut_xm16_m=1
.param x_dut_xm17_m=1
* ---- GENERATED parameter ties (abstract/params.yaml groups/ratios) ----
* Each tied symbol is defined exactly once, by its line below; rewrite that
* .param to untie just that symbol (untying = shadowing, plan D-3).
.param x_dut_xm3_w = {x_dut_xm2_w}
.param x_dut_xm3_l = {x_dut_xm2_l}
.param x_dut_xm3_m = {x_dut_xm2_m}
.param x_dut_xm5_w = {x_dut_xm4_w}
.param x_dut_xm5_l = {x_dut_xm4_l}
.param x_dut_xm5_m = {x_dut_xm4_m}
.param x_dut_xm13_w = {x_dut_xm12_w}
.param x_dut_xm13_l = {x_dut_xm12_l}
.param x_dut_xm13_m = {x_dut_xm12_m}
.param x_dut_xm11_w = {x_dut_xm10_w}
.param x_dut_xm11_l = {x_dut_xm10_l}
.param x_dut_xm11_m = {x_dut_xm10_m}
.param x_dut_xm7_w = {x_dut_xm6_w}
.param x_dut_xm7_m = {x_dut_xm6_m}
.param x_dut_xm9_w = {x_dut_xm8_w}
.param x_dut_xm9_m = {x_dut_xm8_m}
.param x_dut_xm6_l = {x_dut_xm1_l}
.param x_dut_xm7_l = {x_dut_xm1_l}
.param x_dut_xm8_l = {x_dut_xm1_l}
.param x_dut_xm9_l = {x_dut_xm1_l}
.param x_dut_xm15_w = {x_dut_xm14_w}
.param x_dut_xm15_l = {x_dut_xm14_l}
.param x_dut_xm15_m = {x_dut_xm14_m}
.param x_dut_xm18_w = {x_dut_xm16_w}
.param x_dut_xm20_w = {x_dut_xm16_w}
.param x_dut_xm22_w = {x_dut_xm16_w}
.param x_dut_xm18_l = {x_dut_xm16_l}
.param x_dut_xm20_l = {x_dut_xm16_l}
.param x_dut_xm22_l = {x_dut_xm16_l}
.param x_dut_xm18_m = {x_dut_xm16_m}
.param x_dut_xm20_m = {x_dut_xm16_m}
.param x_dut_xm22_m = {x_dut_xm16_m}
.param x_dut_xm19_w = {x_dut_xm17_w}
.param x_dut_xm21_w = {x_dut_xm17_w}
.param x_dut_xm23_w = {x_dut_xm17_w}
.param x_dut_xm19_l = {x_dut_xm17_l}
.param x_dut_xm21_l = {x_dut_xm17_l}
.param x_dut_xm23_l = {x_dut_xm17_l}
.param x_dut_xm19_m = {x_dut_xm17_m}
.param x_dut_xm21_m = {x_dut_xm17_m}
.param x_dut_xm23_m = {x_dut_xm17_m}
.param x_dut_cm2_value = {x_dut_cm1_value}
.subckt amp_026_fan_chopper_ota vinp vinn voutp voutn vdd vss
CM1 g2_p voutp 'x_dut_cm1_value'
CM2 g2_n voutn 'x_dut_cm2_value'
VB1 vb1 vss dc {vb1}
VB2 vb2 vss dc {vb2}
VB3 vb3 vss dc {vb3}
VB4 vb4 vss dc {vb4}
XM1 tail vb4 vdd vdd sg13_lv_pmos l=x_dut_xm1_l m=x_dut_xm1_m w=x_dut_xm1_w
XM10 out1_n vb3 casc_src_n vdd sg13_lv_pmos l=x_dut_xm10_l m=x_dut_xm10_m w=x_dut_xm10_w
XM11 out1_p vb3 casc_src_p vdd sg13_lv_pmos l=x_dut_xm11_l m=x_dut_xm11_m w=x_dut_xm11_w
XM12 out1_p vb2 fold_p vss sg13_lv_nmos l=x_dut_xm12_l m=x_dut_xm12_m w=x_dut_xm12_w
XM13 out1_n vb2 fold_n vss sg13_lv_nmos l=x_dut_xm13_l m=x_dut_xm13_m w=x_dut_xm13_w
XM14 voutp g2_p vss vss sg13_lv_nmos l=x_dut_xm14_l m=x_dut_xm14_m w=x_dut_xm14_w
XM15 voutn g2_n vss vss sg13_lv_nmos l=x_dut_xm15_l m=x_dut_xm15_m w=x_dut_xm15_w
XM16 out1_n vdd g2_n vss sg13_lv_nmos l=x_dut_xm16_l m=x_dut_xm16_m w=x_dut_xm16_w
XM17 g2_n vss out1_n vdd sg13_lv_pmos l=x_dut_xm17_l m=x_dut_xm17_m w=x_dut_xm17_w
XM18 out1_p vdd g2_p vss sg13_lv_nmos l=x_dut_xm18_l m=x_dut_xm18_m w=x_dut_xm18_w
XM19 g2_p vss out1_p vdd sg13_lv_pmos l=x_dut_xm19_l m=x_dut_xm19_m w=x_dut_xm19_w
XM2 fold_p vinp tail vdd sg13_lv_pmos l=x_dut_xm2_l m=x_dut_xm2_m w=x_dut_xm2_w
XM20 out1_p vss g2_n vss sg13_lv_nmos l=x_dut_xm20_l m=x_dut_xm20_m w=x_dut_xm20_w
XM21 g2_n vdd out1_p vdd sg13_lv_pmos l=x_dut_xm21_l m=x_dut_xm21_m w=x_dut_xm21_w
XM22 out1_n vss g2_p vss sg13_lv_nmos l=x_dut_xm22_l m=x_dut_xm22_m w=x_dut_xm22_w
XM23 g2_p vdd out1_n vdd sg13_lv_pmos l=x_dut_xm23_l m=x_dut_xm23_m w=x_dut_xm23_w
XM3 fold_n vinn tail vdd sg13_lv_pmos l=x_dut_xm3_l m=x_dut_xm3_m w=x_dut_xm3_w
XM4 fold_p vb1 vss vss sg13_lv_nmos l=x_dut_xm4_l m=x_dut_xm4_m w=x_dut_xm4_w
XM5 fold_n vb1 vss vss sg13_lv_nmos l=x_dut_xm5_l m=x_dut_xm5_m w=x_dut_xm5_w
XM6 casc_src_n vb4 vdd vdd sg13_lv_pmos l=x_dut_xm6_l m=x_dut_xm6_m w=x_dut_xm6_w
XM7 casc_src_p vb4 vdd vdd sg13_lv_pmos l=x_dut_xm7_l m=x_dut_xm7_m w=x_dut_xm7_w
XM8 voutp vb4 vdd vdd sg13_lv_pmos l=x_dut_xm8_l m=x_dut_xm8_m w=x_dut_xm8_w
XM9 voutn vb4 vdd vdd sg13_lv_pmos l=x_dut_xm9_l m=x_dut_xm9_m w=x_dut_xm9_w
.ends
.end
