** GENERATED by `analog-db generate` — DO NOT EDIT. Source: abstract/netlist.spice → ihp-sg13g2
* ia_004_fan_chopper_rrl (emitted by spicexplorer-circuitgraph)
CAZ1_RRL rrl__sum_p rrl__oa_inp 'x_dut_caz1_rrl_value'
CAZ2_RRL rrl__sum_n rrl__oa_inn 'x_dut_caz2_rrl_value'
CFB1_MAIN main__fbch_p main__vsum_n 'x_dut_cfb1_main_value'
CFB2_MAIN main__fbch_n main__vsum_p 'x_dut_cfb2_main_value'
CIN1_MAIN main__vsum_n main__inch_n 'x_dut_cin1_main_value'
CIN2_MAIN main__vsum_p main__inch_p 'x_dut_cin2_main_value'
CINT1_RRL rrl__sum_p rrl__int_p 'x_dut_cint1_rrl_value'
CINT2_RRL rrl__sum_n rrl__int_n 'x_dut_cint2_rrl_value'
CIN_1_RRL rrl__int_p rrl__int_n 'cin_val_rrl'
CIN_SERVO_CMFB cmfb__cm_sense vref_cm 'cin_val_cmfb'
CM1_MAIN main__g2_p voutp 'x_dut_cm1_main_value'
CM2_MAIN main__g2_n voutn 'x_dut_cm2_main_value'
COUT_1_RRL out1_p out1_n 'cout_val_rrl'
COUT_SERVO_CMFB vss vcmfb_raw 'cout_val_cmfb'
CS1_RRL voutp rrl__sc_p 'x_dut_cs1_rrl_value'
CS2_RRL voutn rrl__sc_n 'x_dut_cs2_rrl_value'
GM_1_RRL out1_p out1_n rrl__int_p rrl__int_n {gm_val_rrl}
GM_SERVO_CMFB vss vcmfb_raw vref_cm cmfb__cm_sense {gm_val_cmfb}
RB1_MAIN main__vsum_n vref 'x_dut_rb1_main_value'
RB2_MAIN main__vsum_p vref 'x_dut_rb2_main_value'
RIN_1_RRL rrl__int_p rrl__int_n 'rin_val_rrl'
RIN_SERVO_CMFB cmfb__cm_sense vref_cm 'rin_val_cmfb'
RMN_CMFB voutn cmfb__cm_sense 'x_dut_rmn_cmfb_value'
RMP_CMFB cmfb__cm_sense voutp 'x_dut_rmp_cmfb_value'
ROUT_1_RRL out1_p out1_n 'rout_val_rrl'
ROUT_SERVO_CMFB vss vcmfb_raw 'rout_val_cmfb'
VB1_MAIN main__vb1 vss dc {vb1_main}
VB1_RRL rrl__vb1 vss dc {vb1_rrl}
VB2_MAIN main__vb2 vss dc {vb2_main}
VB2_RRL rrl__vb2 vss dc {vb2_rrl}
VB3_MAIN main__vb3 vss dc {vb3_main}
VB3_RRL rrl__vb3 vss dc {vb3_rrl}
VB40 vb4_ctl vcmfb_raw dc {vb40}
VB4_RRL rrl__vb4 vss dc {vb4_rrl}
VREFCM vref_cm vss dc {vcm_ref}
XM10_MAIN out1_n main__vb3 main__casc_src_n vdd sg13_lv_pmos l=x_dut_xm10_main_l m=x_dut_xm10_main_m w=x_dut_xm10_main_w
XM10_OPAMP_RRL rrl__oa_outp rrl__vb1 rrl__oa_d1p vdd sg13_lv_pmos l=x_dut_xm10_opamp_rrl_l m=x_dut_xm10_opamp_rrl_m w=x_dut_xm10_opamp_rrl_w
XM11_MAIN out1_p main__vb3 main__casc_src_p vdd sg13_lv_pmos l=x_dut_xm11_main_l m=x_dut_xm11_main_m w=x_dut_xm11_main_w
XM11_OPAMP_RRL rrl__oa_outn rrl__vb2 rrl__oa_csrc_n vss sg13_lv_nmos l=x_dut_xm11_opamp_rrl_l m=x_dut_xm11_opamp_rrl_m w=x_dut_xm11_opamp_rrl_w
XM12_MAIN out1_p main__vb2 main__fold_p vss sg13_lv_nmos l=x_dut_xm12_main_l m=x_dut_xm12_main_m w=x_dut_xm12_main_w
XM12_OPAMP_RRL rrl__oa_outp rrl__vb2 rrl__oa_csrc_p vss sg13_lv_nmos l=x_dut_xm12_opamp_rrl_l m=x_dut_xm12_opamp_rrl_m w=x_dut_xm12_opamp_rrl_w
XM13_MAIN out1_n main__vb2 main__fold_n vss sg13_lv_nmos l=x_dut_xm13_main_l m=x_dut_xm13_main_m w=x_dut_xm13_main_w
XM13_OPAMP_RRL rrl__oa_csrc_n rrl__oa_cm_bias vss vss sg13_lv_nmos l=x_dut_xm13_opamp_rrl_l m=x_dut_xm13_opamp_rrl_m w=x_dut_xm13_opamp_rrl_w
XM14_MAIN voutp main__g2_p vss vss sg13_lv_nmos l=x_dut_xm14_main_l m=x_dut_xm14_main_m w=x_dut_xm14_main_w
XM14_OPAMP_RRL rrl__oa_csrc_p rrl__oa_cm_bias vss vss sg13_lv_nmos l=x_dut_xm14_opamp_rrl_l m=x_dut_xm14_opamp_rrl_m w=x_dut_xm14_opamp_rrl_w
XM15_MAIN voutn main__g2_n vss vss sg13_lv_nmos l=x_dut_xm15_main_l m=x_dut_xm15_main_m w=x_dut_xm15_main_w
XM15_OPAMP_RRL rrl__oa_cm_bias rrl__oa_cm_bias vss vss sg13_lv_nmos l=x_dut_xm15_opamp_rrl_l m=x_dut_xm15_opamp_rrl_m w=x_dut_xm15_opamp_rrl_w
XM16_MAIN out1_n clk_chout main__g2_n vss sg13_lv_nmos l=x_dut_xm16_main_l m=x_dut_xm16_main_m w=x_dut_xm16_main_w
XM16_OPAMP_RRL rrl__oa_cm_sense rrl__oa_cm_sense vss vss sg13_lv_nmos l=x_dut_xm16_opamp_rrl_l m=x_dut_xm16_opamp_rrl_m w=x_dut_xm16_opamp_rrl_w
XM17_MAIN main__g2_n clk_chout_not out1_n vdd sg13_lv_pmos l=x_dut_xm17_main_l m=x_dut_xm17_main_m w=x_dut_xm17_main_w
XM18_MAIN out1_p clk_chout main__g2_p vss sg13_lv_nmos l=x_dut_xm18_main_l m=x_dut_xm18_main_m w=x_dut_xm18_main_w
XM19_MAIN main__g2_p clk_chout_not out1_p vdd sg13_lv_pmos l=x_dut_xm19_main_l m=x_dut_xm19_main_m w=x_dut_xm19_main_w
XM1_CHRRL_1_RRL rrl__sum_p clk_chout rrl__sc_p vss sg13_lv_nmos l=x_dut_xm1_chrrl_1_rrl_l m=x_dut_xm1_chrrl_1_rrl_m w=x_dut_xm1_chrrl_1_rrl_w
XM1_CHRRL_2_RRL rrl__sum_n clk_chout rrl__sc_n vss sg13_lv_nmos l=x_dut_xm1_chrrl_2_rrl_l m=x_dut_xm1_chrrl_2_rrl_m w=x_dut_xm1_chrrl_2_rrl_w
XM1_CHRRL_3_RRL rrl__sum_p clk_chout_not rrl__sc_n vss sg13_lv_nmos l=x_dut_xm1_chrrl_3_rrl_l m=x_dut_xm1_chrrl_3_rrl_m w=x_dut_xm1_chrrl_3_rrl_w
XM1_CHRRL_4_RRL rrl__sum_n clk_chout_not rrl__sc_p vss sg13_lv_nmos l=x_dut_xm1_chrrl_4_rrl_l m=x_dut_xm1_chrrl_4_rrl_m w=x_dut_xm1_chrrl_4_rrl_w
XM1_MAIN main__tail vb4_ctl vdd vdd sg13_lv_pmos l=x_dut_xm1_main_l m=x_dut_xm1_main_m w=x_dut_xm1_main_w
XM1_OPAMP_RRL rrl__oa_tail rrl__vb3 vdd vdd sg13_lv_pmos l=x_dut_xm1_opamp_rrl_l m=x_dut_xm1_opamp_rrl_m w=x_dut_xm1_opamp_rrl_w
XM1_S1_RRL rrl__sc_n clk_phi_2 vss vss sg13_lv_nmos l=x_dut_xm1_s1_rrl_l m=x_dut_xm1_s1_rrl_m w=x_dut_xm1_s1_rrl_w
XM1_S2_RRL rrl__sc_p clk_phi_2 vss vss sg13_lv_nmos l=x_dut_xm1_s2_rrl_l m=x_dut_xm1_s2_rrl_m w=x_dut_xm1_s2_rrl_w
XM1_S3_RRL rrl__oa_inp clk_phi_2 rrl__oa_outn vss sg13_lv_nmos l=x_dut_xm1_s3_rrl_l m=x_dut_xm1_s3_rrl_m w=x_dut_xm1_s3_rrl_w
XM1_S4_RRL rrl__oa_inn clk_phi_2 rrl__oa_outp vss sg13_lv_nmos l=x_dut_xm1_s4_rrl_l m=x_dut_xm1_s4_rrl_m w=x_dut_xm1_s4_rrl_w
XM1_S5_RRL rrl__oa_outn clk_phi_1 rrl__int_p vss sg13_lv_nmos l=x_dut_xm1_s5_rrl_l m=x_dut_xm1_s5_rrl_m w=x_dut_xm1_s5_rrl_w
XM1_S6_RRL rrl__oa_outp clk_phi_1 rrl__int_n vss sg13_lv_nmos l=x_dut_xm1_s6_rrl_l m=x_dut_xm1_s6_rrl_m w=x_dut_xm1_s6_rrl_w
XM20_MAIN main__fbch_p clk_chfb voutp vss sg13_lv_nmos l=x_dut_xm20_main_l m=x_dut_xm20_main_m w=x_dut_xm20_main_w
XM21_MAIN voutp clk_chfb_not main__fbch_p vdd sg13_lv_pmos l=x_dut_xm21_main_l m=x_dut_xm21_main_m w=x_dut_xm21_main_w
XM22_MAIN main__fbch_n clk_chfb voutn vss sg13_lv_nmos l=x_dut_xm22_main_l m=x_dut_xm22_main_m w=x_dut_xm22_main_w
XM23_MAIN voutn clk_chfb_not main__fbch_n vdd sg13_lv_pmos l=x_dut_xm23_main_l m=x_dut_xm23_main_m w=x_dut_xm23_main_w
XM24_MAIN vinn clk_chin main__inch_n vss sg13_lv_nmos l=x_dut_xm24_main_l m=x_dut_xm24_main_m w=x_dut_xm24_main_w
XM25_MAIN main__inch_n clk_chin_not vinn vdd sg13_lv_pmos l=x_dut_xm25_main_l m=x_dut_xm25_main_m w=x_dut_xm25_main_w
XM26_MAIN vinp clk_chin main__inch_p vss sg13_lv_nmos l=x_dut_xm26_main_l m=x_dut_xm26_main_m w=x_dut_xm26_main_w
XM27_MAIN main__inch_p clk_chin_not vinp vdd sg13_lv_pmos l=x_dut_xm27_main_l m=x_dut_xm27_main_m w=x_dut_xm27_main_w
XM28_MAIN out1_n clk_chout_not main__g2_p vss sg13_lv_nmos l=x_dut_xm28_main_l m=x_dut_xm28_main_m w=x_dut_xm28_main_w
XM29_MAIN main__g2_p clk_chout out1_n vdd sg13_lv_pmos l=x_dut_xm29_main_l m=x_dut_xm29_main_m w=x_dut_xm29_main_w
XM2_CHRRL_1_RRL rrl__sc_p clk_chout_not rrl__sum_p vdd sg13_lv_pmos l=x_dut_xm2_chrrl_1_rrl_l m=x_dut_xm2_chrrl_1_rrl_m w=x_dut_xm2_chrrl_1_rrl_w
XM2_CHRRL_2_RRL rrl__sc_n clk_chout_not rrl__sum_n vdd sg13_lv_pmos l=x_dut_xm2_chrrl_2_rrl_l m=x_dut_xm2_chrrl_2_rrl_m w=x_dut_xm2_chrrl_2_rrl_w
XM2_CHRRL_3_RRL rrl__sc_n clk_chout rrl__sum_p vdd sg13_lv_pmos l=x_dut_xm2_chrrl_3_rrl_l m=x_dut_xm2_chrrl_3_rrl_m w=x_dut_xm2_chrrl_3_rrl_w
XM2_CHRRL_4_RRL rrl__sc_p clk_chout rrl__sum_n vdd sg13_lv_pmos l=x_dut_xm2_chrrl_4_rrl_l m=x_dut_xm2_chrrl_4_rrl_m w=x_dut_xm2_chrrl_4_rrl_w
XM2_MAIN main__fold_p main__vsum_p main__tail vdd sg13_lv_pmos l=x_dut_xm2_main_l m=x_dut_xm2_main_m w=x_dut_xm2_main_w
XM2_OPAMP_RRL rrl__oa_d1n rrl__oa_inp rrl__oa_tail vdd sg13_lv_pmos l=x_dut_xm2_opamp_rrl_l m=x_dut_xm2_opamp_rrl_m w=x_dut_xm2_opamp_rrl_w
XM2_S1_RRL vss clk_phi_1 rrl__sc_n vdd sg13_lv_pmos l=x_dut_xm2_s1_rrl_l m=x_dut_xm2_s1_rrl_m w=x_dut_xm2_s1_rrl_w
XM2_S2_RRL vss clk_phi_1 rrl__sc_p vdd sg13_lv_pmos l=x_dut_xm2_s2_rrl_l m=x_dut_xm2_s2_rrl_m w=x_dut_xm2_s2_rrl_w
XM2_S3_RRL rrl__oa_outn clk_phi_1 rrl__oa_inp vdd sg13_lv_pmos l=x_dut_xm2_s3_rrl_l m=x_dut_xm2_s3_rrl_m w=x_dut_xm2_s3_rrl_w
XM2_S4_RRL rrl__oa_outp clk_phi_1 rrl__oa_inn vdd sg13_lv_pmos l=x_dut_xm2_s4_rrl_l m=x_dut_xm2_s4_rrl_m w=x_dut_xm2_s4_rrl_w
XM2_S5_RRL rrl__int_p clk_phi_2 rrl__oa_outn vdd sg13_lv_pmos l=x_dut_xm2_s5_rrl_l m=x_dut_xm2_s5_rrl_m w=x_dut_xm2_s5_rrl_w
XM2_S6_RRL rrl__int_n clk_phi_2 rrl__oa_outp vdd sg13_lv_pmos l=x_dut_xm2_s6_rrl_l m=x_dut_xm2_s6_rrl_m w=x_dut_xm2_s6_rrl_w
XM30_MAIN out1_p clk_chout_not main__g2_n vss sg13_lv_nmos l=x_dut_xm30_main_l m=x_dut_xm30_main_m w=x_dut_xm30_main_w
XM31_MAIN main__g2_n clk_chout out1_p vdd sg13_lv_pmos l=x_dut_xm31_main_l m=x_dut_xm31_main_m w=x_dut_xm31_main_w
XM32_MAIN vinn clk_chin_not main__inch_p vss sg13_lv_nmos l=x_dut_xm32_main_l m=x_dut_xm32_main_m w=x_dut_xm32_main_w
XM33_MAIN main__inch_p clk_chin vinn vdd sg13_lv_pmos l=x_dut_xm33_main_l m=x_dut_xm33_main_m w=x_dut_xm33_main_w
XM34_MAIN vinp clk_chin_not main__inch_n vss sg13_lv_nmos l=x_dut_xm34_main_l m=x_dut_xm34_main_m w=x_dut_xm34_main_w
XM35_MAIN main__inch_n clk_chin vinp vdd sg13_lv_pmos l=x_dut_xm35_main_l m=x_dut_xm35_main_m w=x_dut_xm35_main_w
XM36_MAIN main__fbch_p clk_chfb_not voutn vss sg13_lv_nmos l=x_dut_xm36_main_l m=x_dut_xm36_main_m w=x_dut_xm36_main_w
XM37_MAIN voutn clk_chfb main__fbch_p vdd sg13_lv_pmos l=x_dut_xm37_main_l m=x_dut_xm37_main_m w=x_dut_xm37_main_w
XM38_MAIN main__fbch_n clk_chfb_not voutp vss sg13_lv_nmos l=x_dut_xm38_main_l m=x_dut_xm38_main_m w=x_dut_xm38_main_w
XM39_MAIN voutp clk_chfb main__fbch_n vdd sg13_lv_pmos l=x_dut_xm39_main_l m=x_dut_xm39_main_m w=x_dut_xm39_main_w
XM3_MAIN main__fold_n main__vsum_n main__tail vdd sg13_lv_pmos l=x_dut_xm3_main_l m=x_dut_xm3_main_m w=x_dut_xm3_main_w
XM3_OPAMP_RRL rrl__oa_d1p rrl__oa_inn rrl__oa_tail vdd sg13_lv_pmos l=x_dut_xm3_opamp_rrl_l m=x_dut_xm3_opamp_rrl_m w=x_dut_xm3_opamp_rrl_w
XM4_MAIN main__fold_p main__vb1 vss vss sg13_lv_nmos l=x_dut_xm4_main_l m=x_dut_xm4_main_m w=x_dut_xm4_main_w
XM4_OPAMP_RRL rrl__oa_cm_tail rrl__vb3 vdd vdd sg13_lv_pmos l=x_dut_xm4_opamp_rrl_l m=x_dut_xm4_opamp_rrl_m w=x_dut_xm4_opamp_rrl_w
XM5_MAIN main__fold_n main__vb1 vss vss sg13_lv_nmos l=x_dut_xm5_main_l m=x_dut_xm5_main_m w=x_dut_xm5_main_w
XM5_OPAMP_RRL rrl__oa_cm_sense rrl__oa_outn rrl__oa_cm_tail vdd sg13_lv_pmos l=x_dut_xm5_opamp_rrl_l m=x_dut_xm5_opamp_rrl_m w=x_dut_xm5_opamp_rrl_w
XM6_MAIN main__casc_src_n vb4_ctl vdd vdd sg13_lv_pmos l=x_dut_xm6_main_l m=x_dut_xm6_main_m w=x_dut_xm6_main_w
XM6_OPAMP_RRL rrl__oa_cm_bias rrl__vb4 rrl__oa_cm_tail vdd sg13_lv_pmos l=x_dut_xm6_opamp_rrl_l m=x_dut_xm6_opamp_rrl_m w=x_dut_xm6_opamp_rrl_w
XM7_MAIN main__casc_src_p vb4_ctl vdd vdd sg13_lv_pmos l=x_dut_xm7_main_l m=x_dut_xm7_main_m w=x_dut_xm7_main_w
XM7_OPAMP_RRL rrl__oa_cm_sense rrl__oa_outp rrl__oa_cm_tail vdd sg13_lv_pmos l=x_dut_xm7_opamp_rrl_l m=x_dut_xm7_opamp_rrl_m w=x_dut_xm7_opamp_rrl_w
XM8_MAIN voutp vb4_ctl vdd vdd sg13_lv_pmos l=x_dut_xm8_main_l m=x_dut_xm8_main_m w=x_dut_xm8_main_w
XM8_OPAMP_RRL rrl__oa_cm_bias rrl__vb4 rrl__oa_cm_tail vdd sg13_lv_pmos l=x_dut_xm8_opamp_rrl_l m=x_dut_xm8_opamp_rrl_m w=x_dut_xm8_opamp_rrl_w
XM9_MAIN voutn vb4_ctl vdd vdd sg13_lv_pmos l=x_dut_xm9_main_l m=x_dut_xm9_main_m w=x_dut_xm9_main_w
XM9_OPAMP_RRL rrl__oa_outn rrl__vb1 rrl__oa_d1n vdd sg13_lv_pmos l=x_dut_xm9_opamp_rrl_l m=x_dut_xm9_opamp_rrl_m w=x_dut_xm9_opamp_rrl_w
.end
