** GENERATED by `analog-db export-raw` — DO NOT EDIT.
** circuit=amp_032_ti_ldo_error_selfbias  class=amplifier  pdk=ihp-sg13g2  testbench=linearity  corner=tt
** Self-contained deck: testbench + bound params + lowered DUT (.subckt amp_032_ti_ldo_error_selfbias).
** PDK corner libs resolve by BARE NAME on the image's ngspice sourcepath — run in a
** PDK-enabled env (the base image / api container), NOT a bare host:
**   docker run --rm -i spicexplorer-spice-base:local \
**     bash -lc 'd=$(mktemp -d) && cat > $d/c.spice && cd $d && ngspice -b c.spice' < raw/amp_032_ti_ldo_error_selfbias/ihp-sg13g2/linearity.spice
*----------------------------------------------------------*
** params: 18 free + 0 frozen knobs (sizing.yaml) · 9 tied · 0 ratio-derived (abstract/params.yaml) · 3 testbench params
** AUTHORED TEMPLATE — amplifier/linearity_selfbias (2026-07-20): input common-mode range (ICMR)
** for SELF-BIASED DUTs (no ibias port). Identical to `linearity` except there is no external bias
** source — derived exactly as psrr_vdd_selfbias derives from psrr_vdd (drop `.param IBIAS` and the
** `Ibias` line), so a 5-port [vdd vout vinp vinn vss] DUT does not leave a current source driving
** a dangling `ibias` node (which makes the DC solve singular).
** ICMR via a buffer-connected DC sweep: the input range over which the follower tracks within
** VTRACK. The buffer-connected DC op point is the same one ac_open_loop_biaswrap already proves
** out for these DUTs, so biasing is safe.
** Bindings: DUT PORT_LINE VDD VCM CL VTRACK VSWEEP_STEP SLOPE_TOL PDK_INCLUDE.
.lib cornerMOSlv.lib mos_tt
.lib cornerRES.lib res_typ
.lib cornerCAP.lib cap_typ
.temp 27

.param VDD=1.5
.param VCM=0.75
.param CL=10p

Vdd  vdd 0 dc {VDD}
Vss  vss 0 dc 0
CLoad vout 0 {CL}

* buffer-connected: vinn shorted to vout; sweep the common-mode input
Vinp vinp 0 dc {VCM}
Vfb  vinn vout dc 0

XDUT vdd vout vinp vinn vss amp_032_ti_ldo_error_selfbias

.control
  set filetype=ascii
  dc Vinp 0 1.5 0.01
  let verr = abs(v(vout) - v(vinp))
  * ICMR = widest CONTIGUOUS run of points that both track in absolute terms
  * (|verr| <= VTRACK) and are ACTIVE (dvout/dvin ~ 1). This mirrors the platform registry's
  * `{meas: icmr_range}` (spicexplorer_core waveforms.icmr_band) exactly, so the analog-db
  * run/verify lane and the optimizer lane report the same number.
  *
  * REWRITTEN 2026-07-20. The previous form was `meas dc ... WHEN verr=VTRACK CROSS=1/LAST`,
  * which was wrong two ways. (1) CROSS=1 finds the band EXIT on a DUT that already tracks at
  * vin=0, so the pair returned the complement of the real band — it read amp_022 as 0.105 V
  * against a true 1.400 V. (2) More fundamentally, an absolute-error test ALONE cannot tell
  * "the follower is tracking" from "both ends sit near the same rail": where the input pair
  * is cut off vout is pinned at a rail, and if vin is near that rail too then verr is small
  * by coincidence. That reported a 3.23 V band on a 3.3 V supply for amp_033. The slope test
  * rejects those dead points because a railed output has dvout/dvin ~ 0.
  let vsw = v(vinp)
  let dvout = deriv(v(vout))
  let dvin  = deriv(vsw)
  let slope = dvout / dvin
  let intrack = (verr <= 0.05) & (abs(slope - 1) <= 0.1)
  let npts = length(intrack)
  let k = 0
  let best = 0
  let bstart = 0
  let bend = 0
  let cstart = 0
  let inband = 0
  while k < npts
    if intrack[k] > 0.5
      if inband < 0.5
        let cstart = vsw[k]
        let inband = 1
      end
      if (vsw[k] - cstart) > best
        let best = vsw[k] - cstart
        let bstart = cstart
        let bend = vsw[k]
      end
    else
      let inband = 0
    end
    let k = k + 1
  end
  let icmr_min = bstart
  let icmr_max = bend
  let icmr_range = best
  print icmr_min icmr_max icmr_range
  write
  quit
.endc
.param x_dut_xmbp_w=5.578670789917222e-06
.param x_dut_xmbp_l=4.652399317553778e-06
.param x_dut_xmb0_w=8.276833786204537e-05
.param x_dut_xmb0_l=3.15070605280647e-06
.param x_dut_xmbc_m=1
.param x_dut_xmbo_m=1
.param x_dut_xm1_w=6.400316047920548e-05
.param x_dut_xm1_l=5.758061070605141e-07
.param x_dut_xm3_w=2.269768753572863e-05
.param x_dut_xm3_l=4.103599384216178e-06
.param x_dut_xm4_w=4.622984258189675e-05
.param x_dut_xm4_l=7.560584329408141e-06
.param x_dut_xm6_w=1.0646593948046076e-05
.param x_dut_xm6_l=1.3958157250351549e-06
.param r_z=35759.18207181488
.param c_comp=5.3161930814325235e-12
.param x_dut_xmbf_w=3.1866222602286976e-06
.param r_nd=9882082.54892156
* ---- GENERATED parameter ties (abstract/params.yaml groups/ratios) ----
* Each tied symbol is defined exactly once, by its line below; rewrite that
* .param to untie just that symbol (untying = shadowing, plan D-3).
.param x_dut_xmbc_l = {x_dut_xmb0_l}
.param x_dut_xmbf_l = {x_dut_xmb0_l}
.param x_dut_xmbo_l = {x_dut_xmb0_l}
.param x_dut_xmbc_w = {x_dut_xmb0_w}
.param x_dut_xmbo_w = {x_dut_xmb0_w}
.param x_dut_xm2_w = {x_dut_xm1_w}
.param x_dut_xm2_l = {x_dut_xm1_l}
.param x_dut_xm5_w = {x_dut_xm3_w}
.param x_dut_xm5_l = {x_dut_xm3_l}
.subckt amp_032_ti_ldo_error_selfbias vdd vout vinp vinn vss
CC ncz vout 'c_comp'
RND na nd 'r_nd'
RZ nb ncz 'r_z'
XM1 na vinn tail vss sg13_lv_nmos l=x_dut_xm1_l w=x_dut_xm1_w
XM2 nb vinp tail vss sg13_lv_nmos l=x_dut_xm2_l w=x_dut_xm2_w
XM3 na nd vdd vdd sg13_lv_pmos l=x_dut_xm3_l w=x_dut_xm3_w
XM4 nlev na nd vdd sg13_lv_pmos l=x_dut_xm4_l w=x_dut_xm4_w
XM5 nb nd vdd vdd sg13_lv_pmos l=x_dut_xm5_l w=x_dut_xm5_w
XM6 vout nb vdd vdd sg13_lv_pmos l=x_dut_xm6_l w=x_dut_xm6_w
XMB0 ibias ibias vss vss sg13_lv_nmos l=x_dut_xmb0_l w=x_dut_xmb0_w
XMBC tail ibias vss vss sg13_lv_nmos l=x_dut_xmbc_l m=x_dut_xmbc_m w=x_dut_xmbc_w
XMBF nlev ibias vss vss sg13_lv_nmos l=x_dut_xmbf_l w=x_dut_xmbf_w
XMBO vout ibias vss vss sg13_lv_nmos l=x_dut_xmbo_l m=x_dut_xmbo_m w=x_dut_xmbo_w
XMBP ibias ibias vdd vdd sg13_lv_pmos l=x_dut_xmbp_l w=x_dut_xmbp_w
.ends
.end
