** GENERATED by `analog-db export-raw` — DO NOT EDIT.
** circuit=ldo_009_fer_5t_pass  class=ldo  pdk=ihp-sg13g2  testbench=tran_load_step  corner=tt
** Self-contained deck: testbench + bound params + lowered DUT (.subckt ldo_009_fer_5t_pass).
** PDK corner libs resolve by BARE NAME on the image's ngspice sourcepath — run in a
** PDK-enabled env (the base image / api container), NOT a bare host:
**   docker run --rm -i spicexplorer-spice-base:local \
**     bash -lc 'd=$(mktemp -d) && cat > $d/c.spice && cd $d && ngspice -b c.spice' < raw/ldo_009_fer_5t_pass/ihp-sg13g2/tran_load_step.spice
*----------------------------------------------------------*
** params: 12 free + 9 frozen knobs (sizing.yaml) · 6 tied · 0 ratio-derived (abstract/params.yaml) · 1 testbench params
** AUTHORED TEMPLATE — ldo/tran_load_step: fast lo->hi load step into Cout; undershoot + recovery.
** Bindings: DUT PORT_LINE VDD COUT ILOAD_LO ILOAD_HI TSTART TEDGE TPULSE TPER TSTEP TSTOP VTOL
**   PDK_INCLUDE.
.lib cornerMOSlv.lib mos_tt
.temp 27

.param VDD=1.8

Vdd  vdd 0 dc {VDD}
Vss  vss 0 dc 0
CLoad vout 0 1u
Iload vout 0 pulse(1m 10m 5u 10n 10n 20u 40u)

XDUT vdd vout vss ldo_009_fer_5t_pass

.control
  set filetype=ascii
  tran 50n 30u
  meas tran vout_min  MIN  v(vout) from=5u to=30u
  meas tran vout_post FIND v(vout) AT=30u
  let v_undershoot = vout_post - vout_min
  * recovery: time after the step for v(vout) to re-enter the +/-VTOL band around its final value
  let verr = abs(v(vout) - vout_post)
  meas tran tcross WHEN verr=1m FALL=LAST
  let t_transient = tcross - 5u
  print v_undershoot t_transient
  write
  quit
.endc
.param x_dut_xmnb_w=4u
.param x_dut_xmnb_l=0.4u
.param x_dut_xmip_w=8u
.param x_dut_xmip_l=0.4u
.param x_dut_xmld_w=4u
.param x_dut_xmld_l=0.4u
.param x_dut_xmp_w=8u
.param x_dut_xmp_l=0.2u
.param x_cmil=2e-12
.param x_cout=50e-12
.param x_rbleed=1e5
.param x_rref=10000
.param x_vref_val=0.9
.param x_ibias_val=20e-6
.param x_dut_xmnb_m=1
.param x_dut_xmnt_m=2
.param x_dut_xmip_m=2
.param x_dut_xmin_m=2
.param x_dut_xmld_m=1
.param x_dut_xmlm_m=1
.param x_dut_xmp_m=20
* ---- GENERATED parameter ties (abstract/params.yaml groups/ratios) ----
* Each tied symbol is defined exactly once, by its line below; rewrite that
* .param to untie just that symbol (untying = shadowing, plan D-3).
.param x_dut_xmnt_w = {x_dut_xmnb_w}
.param x_dut_xmnt_l = {x_dut_xmnb_l}
.param x_dut_xmin_w = {x_dut_xmip_w}
.param x_dut_xmin_l = {x_dut_xmip_l}
.param x_dut_xmlm_w = {x_dut_xmld_w}
.param x_dut_xmlm_l = {x_dut_xmld_l}
.subckt ldo_009_fer_5t_pass vdd vout vss
CMIL vout otao x_cmil
COUT vout vss x_cout
IBI vdd nbias dc {x_ibias_val}
RBLD vout vss x_rbleed
RREF ref0 vref x_rref
VLP lp_brk vout dc 0
VREF ref0 vss dc {x_vref_val}
XMIN otao vref tail vss sg13_lv_nmos l=x_dut_xmin_l m=x_dut_xmin_m w=x_dut_xmin_w
XMIP otax lp_brk tail vss sg13_lv_nmos l=x_dut_xmip_l m=x_dut_xmip_m w=x_dut_xmip_w
XMLD otax otax vdd vdd sg13_lv_pmos l=x_dut_xmld_l m=x_dut_xmld_m w=x_dut_xmld_w
XMLM otao otax vdd vdd sg13_lv_pmos l=x_dut_xmlm_l m=x_dut_xmlm_m w=x_dut_xmlm_w
XMNB nbias nbias vss vss sg13_lv_nmos l=x_dut_xmnb_l m=x_dut_xmnb_m w=x_dut_xmnb_w
XMNT tail nbias vss vss sg13_lv_nmos l=x_dut_xmnt_l m=x_dut_xmnt_m w=x_dut_xmnt_w
XMP vout otao vdd vdd sg13_lv_pmos l=x_dut_xmp_l m=x_dut_xmp_m w=x_dut_xmp_w
.ends
.end
