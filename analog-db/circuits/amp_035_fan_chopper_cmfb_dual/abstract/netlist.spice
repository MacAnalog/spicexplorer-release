** GENERATED by `analog-db generate` — DO NOT EDIT. Source: composition.yaml (composer, plan P4)
** Composite: amp_035_fan_chopper_cmfb_dual = cmfb_out(cmfb_002_5t_pmos_input @ cf3a412052ba) + cmfb_s1(cmfb_002_5t_pmos_input @ cf3a412052ba) + core(amp_026_fan_chopper_ota @ 43c5f13906fb)
** DUAL-loop CM closure of amp_026_fan_chopper_ota: amp_034's output loop, plus a second real 5T CMFB around the FIRST stage. Three instances share one core.
** WHY. amp_034 closes the output CM but leaves stage 1 open, and that residue is measurable: the core's hand-tuned vb1 = 0.398 balances the fold nodes only near a 0.6 V INPUT common mode, so dropping the input CM to 0.5 V rails stage 1 high and drags the output to ~0.026 V — verified on the bare core too (amp_026 dc_op at VCM 0.5 reads vocm = 0.004 V). One knob, hand-set, is the only thing holding the first stage's operating point. This entry replaces that knob with a loop.
** ACTUATOR — and why it only became available once amp_034 existed. In the bare core {vb4} gates FIVE devices: the tail XM1, the fold sources XM6/XM7 AND the output sources XM8/XM9. Driving it was a NON-inverting plant (cm_plant_delta +1.19 V) because the huge stage-1 path outran the direct output term, which is why amp_034 split XM8/XM9 out onto vb4o instead. With those two gone, {vb4} is a CLEAN STAGE-1-ONLY actuator, and re-measuring the plant with the output loop closed gives:
**   vb4 0.35 -> out1 CM 1.1115 | vb4 0.75 -> out1 CM 0.0189
**   cm_plant_delta = -1.093 V  -> INVERTING plant -> canonical servo (cmfb_002/003)
**   out1 CM at the committed vb4 = 0.55 is 0.3265 V; achievable window [0.00, 1.15] V.
** So the two loops are actuated on the two halves of what used to be one bias net, and BOTH want the canonical polarity.
** FLAVOR — cmfb_002 (PMOS-input) for BOTH loops, but for different reasons. Loop 1 (output, sensed CM 0.5 V): amp_034's measured in-loop A/B. Loop 2 (stage 1, sensed CM 0.327 V): forced. An NMOS input pair needs ntail <= 0.327 - Vth_n < 0 at the IHP LV Vth — it cannot sense a 0.33 V common mode at all, while the PMOS pair has ~0.85 V of tail headroom there.
** SENSE LOADING — the one real design change vs loop 1. out1_p/out1_n are CASCODED high-impedance nodes carrying the whole first-stage gain; the CMFB's resistive averager hangs RMP+RMN across them. The block's 1 MOhm default would be a ~2 MOhm differential load on a multi-MOhm node and would eat the gain it is supposed to protect, so loop 2 overrides x_dut_rmp_value to 50 MOhm (100 MOhm differential, in-bounds for the block). The divider is unaffected — the CMFB's own input is a MOS gate (r_sense_in ~4e11 Ohm) — and the CM loop only needs kHz-MHz bandwidth, so the slower sense pole is free.
** LOOP SIGNS. Output: vocm UP -> vcmfb_out UP -> vb4o UP -> XM8O/XM9O |Vsg| DOWN -> vocm DOWN. Stage 1: out1 CM UP -> vcmfb_s1 UP -> vb4 UP -> XM6/XM7 starve -> out1 CM DOWN. Both negative, both with the canonical block.
** COMPENSATION — {c_cm_s1}, and it is NOT optional. Uncompensated, the two CM loops make the DC solution DYNAMICALLY UNSTABLE: the op solver finds vocm = 0.5125 V and reports healthy small-signal figures about it, but a plain transient with ZERO disturbance walks away from it (0.5125 -> 0.628 -> 0.224 V), and a 1 uA CM kick never returns. That is the failure mode this repo has hit before -- "an underdamped escape from the interior basin is a servo-compensation problem, not polarity" (amplifier/dc_cmfb_plant_sign header) -- and the fix is the same shape: split the two CM loops' poles by hanging a capacitor on the INNER (stage-1) servo output. Measured, ICM = 20 uA CM kick, cm_resid_v:
**   none -258 mV (diverges) | 20p -76 mV | 30p -27.6 mV | 50p +5.0 mV |
**   70p -2.0 mV | 100p +0.41 mV
** and with 100p a zero-kick transient holds 0.5124775 V to seven digits at every sample. Default 100p (10x margin over the ~20p edge where recovery first appears); the 50p knee is where cm_resid_v first enters the +/-10 mV datasheet band. This is a real area cost and the honest headline number of this entry alongside the rejection.
**.subckt amp_035_fan_chopper_cmfb_dual vinp vinn voutp voutn vdd vss
* --- instance cmfb_out: cmfb_002_5t_pmos_input @ cf3a412052ba ---
RMP_CMFB_OUT cmfb_out__cm_sense voutp 'x_dut_rmp_cmfb_out_value'
RMN_CMFB_OUT voutn cmfb_out__cm_sense 'x_dut_rmn_cmfb_out_value'
XM1_CMFB_OUT cmfb_out__ptail cmfb_out__bias vdd vdd pmos l=x_dut_xm1_cmfb_out_l m=x_dut_xm1_cmfb_out_m w=x_dut_xm1_cmfb_out_w
XM2_CMFB_OUT vb4o cmfb_out__mirr vss vss nmos l=x_dut_xm2_cmfb_out_l m=x_dut_xm2_cmfb_out_m w=x_dut_xm2_cmfb_out_w
XM3_CMFB_OUT cmfb_out__bias cmfb_out__bias vdd vdd pmos l=x_dut_xm3_cmfb_out_l m=x_dut_xm3_cmfb_out_m w=x_dut_xm3_cmfb_out_w
XM4_CMFB_OUT cmfb_out__mirr cmfb_out__cm_sense cmfb_out__ptail vdd pmos l=x_dut_xm4_cmfb_out_l m=x_dut_xm4_cmfb_out_m w=x_dut_xm4_cmfb_out_w
XM5_CMFB_OUT vb4o vref_out cmfb_out__ptail vdd pmos l=x_dut_xm5_cmfb_out_l m=x_dut_xm5_cmfb_out_m w=x_dut_xm5_cmfb_out_w
XM6_CMFB_OUT cmfb_out__mirr cmfb_out__mirr vss vss nmos l=x_dut_xm6_cmfb_out_l m=x_dut_xm6_cmfb_out_m w=x_dut_xm6_cmfb_out_w
XM7_CMFB_OUT cmfb_out__bias cmfb_out__bias vss vss nmos l=x_dut_xm7_cmfb_out_l m=x_dut_xm7_cmfb_out_m w=x_dut_xm7_cmfb_out_w
* --- instance cmfb_s1: cmfb_002_5t_pmos_input @ cf3a412052ba ---
RMP_CMFB_S1 cmfb_s1__cm_sense stg1_p 'x_dut_rmp_cmfb_s1_value'
RMN_CMFB_S1 stg1_n cmfb_s1__cm_sense 'x_dut_rmn_cmfb_s1_value'
XM1_CMFB_S1 cmfb_s1__ptail cmfb_s1__bias vdd vdd pmos l=x_dut_xm1_cmfb_s1_l m=x_dut_xm1_cmfb_s1_m w=x_dut_xm1_cmfb_s1_w
XM2_CMFB_S1 vb4_ctl cmfb_s1__mirr vss vss nmos l=x_dut_xm2_cmfb_s1_l m=x_dut_xm2_cmfb_s1_m w=x_dut_xm2_cmfb_s1_w
XM3_CMFB_S1 cmfb_s1__bias cmfb_s1__bias vdd vdd pmos l=x_dut_xm3_cmfb_s1_l m=x_dut_xm3_cmfb_s1_m w=x_dut_xm3_cmfb_s1_w
XM4_CMFB_S1 cmfb_s1__mirr cmfb_s1__cm_sense cmfb_s1__ptail vdd pmos l=x_dut_xm4_cmfb_s1_l m=x_dut_xm4_cmfb_s1_m w=x_dut_xm4_cmfb_s1_w
XM5_CMFB_S1 vb4_ctl vref_s1 cmfb_s1__ptail vdd pmos l=x_dut_xm5_cmfb_s1_l m=x_dut_xm5_cmfb_s1_m w=x_dut_xm5_cmfb_s1_w
XM6_CMFB_S1 cmfb_s1__mirr cmfb_s1__mirr vss vss nmos l=x_dut_xm6_cmfb_s1_l m=x_dut_xm6_cmfb_s1_m w=x_dut_xm6_cmfb_s1_w
XM7_CMFB_S1 cmfb_s1__bias cmfb_s1__bias vss vss nmos l=x_dut_xm7_cmfb_s1_l m=x_dut_xm7_cmfb_s1_m w=x_dut_xm7_cmfb_s1_w
* --- instance core: amp_026_fan_chopper_ota @ 43c5f13906fb (omit: XM8, XM9, Vb4) ---
XM1_CORE core__tail vb4_ctl vdd vdd pmos w=x_dut_xm1_core_w l=x_dut_xm1_core_l m=x_dut_xm1_core_m
XM2_CORE core__fold_p vinp core__tail vdd pmos w=x_dut_xm2_core_w l=x_dut_xm2_core_l m=x_dut_xm2_core_m
XM3_CORE core__fold_n vinn core__tail vdd pmos w=x_dut_xm3_core_w l=x_dut_xm3_core_l m=x_dut_xm3_core_m
XM4_CORE core__fold_p core__vb1 vss vss nmos w=x_dut_xm4_core_w l=x_dut_xm4_core_l m=x_dut_xm4_core_m
XM5_CORE core__fold_n core__vb1 vss vss nmos w=x_dut_xm5_core_w l=x_dut_xm5_core_l m=x_dut_xm5_core_m
XM12_CORE stg1_p core__vb2 core__fold_p vss nmos w=x_dut_xm12_core_w l=x_dut_xm12_core_l m=x_dut_xm12_core_m
XM13_CORE stg1_n core__vb2 core__fold_n vss nmos w=x_dut_xm13_core_w l=x_dut_xm13_core_l m=x_dut_xm13_core_m
XM6_CORE core__casc_src_n vb4_ctl vdd vdd pmos w=x_dut_xm6_core_w l=x_dut_xm6_core_l m=x_dut_xm6_core_m
XM7_CORE core__casc_src_p vb4_ctl vdd vdd pmos w=x_dut_xm7_core_w l=x_dut_xm7_core_l m=x_dut_xm7_core_m
XM10_CORE stg1_n core__vb3 core__casc_src_n vdd pmos w=x_dut_xm10_core_w l=x_dut_xm10_core_l m=x_dut_xm10_core_m
XM11_CORE stg1_p core__vb3 core__casc_src_p vdd pmos w=x_dut_xm11_core_w l=x_dut_xm11_core_l m=x_dut_xm11_core_m
XM16_CORE stg1_n vdd core__g2_n vss nmos w=x_dut_xm16_core_w l=x_dut_xm16_core_l m=x_dut_xm16_core_m
XM17_CORE core__g2_n vss stg1_n vdd pmos w=x_dut_xm17_core_w l=x_dut_xm17_core_l m=x_dut_xm17_core_m
XM18_CORE stg1_p vdd core__g2_p vss nmos w=x_dut_xm18_core_w l=x_dut_xm18_core_l m=x_dut_xm18_core_m
XM19_CORE core__g2_p vss stg1_p vdd pmos w=x_dut_xm19_core_w l=x_dut_xm19_core_l m=x_dut_xm19_core_m
XM20_CORE stg1_p vss core__g2_n vss nmos w=x_dut_xm20_core_w l=x_dut_xm20_core_l m=x_dut_xm20_core_m
XM21_CORE core__g2_n vdd stg1_p vdd pmos w=x_dut_xm21_core_w l=x_dut_xm21_core_l m=x_dut_xm21_core_m
XM22_CORE stg1_n vss core__g2_p vss nmos w=x_dut_xm22_core_w l=x_dut_xm22_core_l m=x_dut_xm22_core_m
XM23_CORE core__g2_p vdd stg1_n vdd pmos w=x_dut_xm23_core_w l=x_dut_xm23_core_l m=x_dut_xm23_core_m
XM14_CORE voutp core__g2_p vss vss nmos w=x_dut_xm14_core_w l=x_dut_xm14_core_l m=x_dut_xm14_core_m
XM15_CORE voutn core__g2_n vss vss nmos w=x_dut_xm15_core_w l=x_dut_xm15_core_l m=x_dut_xm15_core_m
Cm1_CORE core__g2_p voutp 'x_dut_cm1_core_value'
Cm2_CORE core__g2_n voutn 'x_dut_cm2_core_value'
Vb1_CORE core__vb1 vss dc {vb1_core}
Vb2_CORE core__vb2 vss dc {vb2_core}
Vb3_CORE core__vb3 vss dc {vb3_core}
* --- composite-owned nets ---
Vrefout vref_out vss dc {vcm_ref}
Ccm_s1 vb4_ctl vss 'c_cm_s1'
Vrefs1 vref_s1 vss dc {vcm_ref_stg1}
XM8O voutp vb4o vdd vdd pmos w=x_dut_xm8o_w l=x_dut_xm8o_l m=x_dut_xm8o_m
XM9O voutn vb4o vdd vdd pmos w=x_dut_xm9o_w l=x_dut_xm9o_l m=x_dut_xm9o_m
**.ends
.end
