** GENERATED by `analog-db generate` — DO NOT EDIT. Source: abstract/netlist.spice → gf180mcu
* amp_017_tan_clia (emitted by spicexplorer-circuitgraph)
C0 net2 vss 'CAPACITOR_0'
C1 net8 VOUT 'CAPACITOR_1'
I0 net1 vss 'CURRENT_0_BIAS'
R0 net5 net2 'RESISTOR_0'
XM0 net1 net1 vdd vdd pfet_03v3 l=x_dut_xm0_l m=x_dut_xm0_m w=x_dut_xm0_w
XM1 VB4 net1 vdd vdd pfet_03v3 l=x_dut_xm1_l m=x_dut_xm1_m w=x_dut_xm1_w
XM12 VB4 VB3 net6 vss nfet_03v3 l=x_dut_xm12_l m=x_dut_xm12_m w=x_dut_xm12_w
XM13 DM_1 VB3 net7 vss nfet_03v3 l=x_dut_xm13_l m=x_dut_xm13_m w=x_dut_xm13_w
XM14 VB3 VB3 vss vss nfet_03v3 l=x_dut_xm14_l m=x_dut_xm14_m w=x_dut_xm14_w
XM15 VOUTN VB3 DM_2 vss nfet_03v3 l=x_dut_xm15_l m=x_dut_xm15_m w=x_dut_xm15_w
XM16 net050 VB3 net8 vss nfet_03v3 l=x_dut_xm16_l m=x_dut_xm16_m w=x_dut_xm16_w
XM17 net6 VB4 vss vss nfet_03v3 l=x_dut_xm17_l m=x_dut_xm17_m w=x_dut_xm17_w
XM18 net7 VB4 vss vss nfet_03v3 l=x_dut_xm18_l m=x_dut_xm18_m w=x_dut_xm18_w
XM19 DM_2 VB4 vss vss nfet_03v3 l=x_dut_xm19_l m=x_dut_xm19_m w=x_dut_xm19_w
XM2 DM_1 DM_1 vdd vdd pfet_03v3 l=x_dut_xm2_l m=x_dut_xm2_m w=x_dut_xm2_w
XM20 net8 VB4 vss vss nfet_03v3 l=x_dut_xm20_l m=x_dut_xm20_m w=x_dut_xm20_w
XM3 VB3 net1 vdd vdd pfet_03v3 l=x_dut_xm3_l m=x_dut_xm3_m w=x_dut_xm3_w
XM4 net31 net1 vdd vdd pfet_03v3 l=x_dut_xm4_l m=x_dut_xm4_m w=x_dut_xm4_w
XM5 VOUTN VOUTN vdd vdd pfet_03v3 l=x_dut_xm5_l m=x_dut_xm5_m w=x_dut_xm5_w
XM6 net050 VOUTN vdd vdd pfet_03v3 l=x_dut_xm6_l m=x_dut_xm6_m w=x_dut_xm6_w
XM61 net3 VB4 vss vss nfet_03v3 l=x_dut_xm61_l m=x_dut_xm61_m w=x_dut_xm61_w
XM68 VOUT net050 vdd vdd pfet_03v3 l=x_dut_xm68_l m=x_dut_xm68_m w=x_dut_xm68_w
XM69 VOUT net5 vss vss nfet_03v3 l=x_dut_xm69_l m=x_dut_xm69_m w=x_dut_xm69_w
XM70 net3 net050 vdd vdd pfet_03v3 l=x_dut_xm70_l m=x_dut_xm70_m w=x_dut_xm70_w
XM71 net3 net3 vss vss nfet_03v3 l=x_dut_xm71_l m=x_dut_xm71_m w=x_dut_xm71_w
XM72 net5 net3 vss vss nfet_03v3 l=x_dut_xm72_l m=x_dut_xm72_m w=x_dut_xm72_w
XM73 net5 DM_1 vdd vdd pfet_03v3 l=x_dut_xm73_l m=x_dut_xm73_m w=x_dut_xm73_w
XM8 DM_2 VINN net31 net31 pfet_03v3 l=x_dut_xm8_l m=x_dut_xm8_m w=x_dut_xm8_w
XM9 net8 VINP net31 net31 pfet_03v3 l=x_dut_xm9_l m=x_dut_xm9_m w=x_dut_xm9_w
.end
