** GENERATED by `analog-db export-raw` — DO NOT EDIT.
** circuit=ldo_005_buffered_ref  class=ldo  pdk=sky130  testbench=line_regulation  corner=tt
** Self-contained deck: testbench + bound params + lowered DUT (.subckt ldo_005_buffered_ref).
** PDK corner libs resolve by BARE NAME on the image's ngspice sourcepath — run in a
** PDK-enabled env (the base image / api container), NOT a bare host:
**   docker run --rm -i spicexplorer-spice-base:local \
**     bash -lc 'd=$(mktemp -d) && cat > $d/c.spice && cd $d && ngspice -b c.spice' < raw/ldo_005_buffered_ref/sky130/line_regulation.spice
*----------------------------------------------------------*
** params: 25 free + 0 frozen knobs (sizing.yaml) · 12 tied · 0 ratio-derived (abstract/params.yaml) · 0 testbench params
** AUTHORED TEMPLATE — ldo/line_regulation: DC Vin sweep at fixed load; delta-Vout (volts).
** Sweep the supply above the dropout knee so line_reg reflects the in-regulation range.
** Bindings: DUT PORT_LINE ILOAD VDD_START VDD_STOP VDD_STEP PDK_INCLUDE.
.lib sky130.lib.spice tt
.temp 27

Vdd  vdd 0 dc 1.4
Vss  vss 0 dc 0
Iload vout 0 dc 1m

XDUT vdd vout vss ldo_005_buffered_ref

.control
  set filetype=ascii
  dc Vdd 1.4 2.0 0.05
  meas dc vout_max MAX v(vout)
  meas dc vout_min MIN v(vout)
  let line_reg = vout_max - vout_min
  print line_reg
  write
  quit
.endc
.param x_dut_xmp_w=20
.param x_dut_xmp_m=20
.param x_dut_xmp_l=0.5
.param r_bleed=10k
.param r_z=1
.param c_comp=0.05p
.param x_dut_xm7_w=4
.param x_dut_xm7_l=0.5
.param x_dut_xm9_w=4
.param x_dut_xm9_l=0.5
.param x_dut_xm12_w=4
.param x_dut_xm12_l=1
.param i_tail_err=200u
.param x_dut_xm1_w=4
.param x_dut_xm1_l=0.5
.param x_dut_xm3_w=4
.param x_dut_xm3_l=0.5
.param x_dut_xm6_w=4
.param x_dut_xm6_l=1
.param i_tail_ref=100u
.param r_ref_top=100k
.param r_ref_bot=100k
.param r_lpf=10k
.param c_lpf=10p
.param vref_val=0.7
* ---- GENERATED parameter ties (abstract/params.yaml groups/ratios) ----
* Each tied symbol is defined exactly once, by its line below; rewrite that
* .param to untie just that symbol (untying = shadowing, plan D-3).
.param x_dut_xm2_w = {x_dut_xm1_w}
.param x_dut_xm2_l = {x_dut_xm1_l}
.param x_dut_xm4_w = {x_dut_xm3_w}
.param x_dut_xm4_l = {x_dut_xm3_l}
.param x_dut_xm5_w = {x_dut_xm6_w}
.param x_dut_xm5_l = {x_dut_xm6_l}
.param x_dut_xm8_w = {x_dut_xm7_w}
.param x_dut_xm8_l = {x_dut_xm7_l}
.param x_dut_xm10_w = {x_dut_xm9_w}
.param x_dut_xm10_l = {x_dut_xm9_l}
.param x_dut_xm11_w = {x_dut_xm12_w}
.param x_dut_xm11_l = {x_dut_xm12_l}
.subckt ldo_005_buffered_ref vdd vout vss
CC ncz vout 'c_comp'
C_LPF v_lpf_out vss 'c_lpf'
IBIAS_ERR vdd ebias_err dc {i_tail_err}
IBIAS_REF vdd ebias_ref dc {i_tail_ref}
R1 v_ref_out v_ref_fb 'r_ref_top'
R2 v_ref_fb vss 'r_ref_bot'
R3 vout vss 'r_bleed'
RZ egate ncz 'r_z'
R_LPF v_ref_out v_lpf_out 'r_lpf'
VREF vref vss dc {vref_val}
XM1 rd1 vref retail vss sky130_fd_pr__nfet_01v8 l=x_dut_xm1_l w=x_dut_xm1_w
XM10 egate noutm vdd vdd sky130_fd_pr__pfet_01v8 l=x_dut_xm10_l w=x_dut_xm10_w
XM11 etail ebias_err vss vss sky130_fd_pr__nfet_01v8 l=x_dut_xm11_l w=x_dut_xm11_w
XM12 ebias_err ebias_err vss vss sky130_fd_pr__nfet_01v8 l=x_dut_xm12_l w=x_dut_xm12_w
XM2 v_ref_out v_ref_fb retail vss sky130_fd_pr__nfet_01v8 l=x_dut_xm2_l w=x_dut_xm2_w
XM3 rd1 rd1 vdd vdd sky130_fd_pr__pfet_01v8 l=x_dut_xm3_l w=x_dut_xm3_w
XM4 v_ref_out rd1 vdd vdd sky130_fd_pr__pfet_01v8 l=x_dut_xm4_l w=x_dut_xm4_w
XM5 retail ebias_ref vss vss sky130_fd_pr__nfet_01v8 l=x_dut_xm5_l w=x_dut_xm5_w
XM6 ebias_ref ebias_ref vss vss sky130_fd_pr__nfet_01v8 l=x_dut_xm6_l w=x_dut_xm6_w
XM7 noutm vout etail vss sky130_fd_pr__nfet_01v8 l=x_dut_xm7_l w=x_dut_xm7_w
XM8 egate v_lpf_out etail vss sky130_fd_pr__nfet_01v8 l=x_dut_xm8_l w=x_dut_xm8_w
XM9 noutm noutm vdd vdd sky130_fd_pr__pfet_01v8 l=x_dut_xm9_l w=x_dut_xm9_w
XMP vout egate vdd vdd sky130_fd_pr__pfet_01v8 l=x_dut_xmp_l m=x_dut_xmp_m w=x_dut_xmp_w
.ends
.end
