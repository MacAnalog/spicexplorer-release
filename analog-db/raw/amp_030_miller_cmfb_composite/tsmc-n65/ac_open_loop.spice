** GENERATED by `analog-db export-raw` — DO NOT EDIT.
** circuit=amp_030_miller_cmfb_composite  class=amplifier  pdk=tsmc-n65  testbench=ac_open_loop  corner=tt
** Self-contained deck: testbench + bound params + lowered DUT (.subckt amp_030_miller_cmfb_composite).
** PDK corner libs resolve by BARE NAME on the image's ngspice sourcepath — run in a
** PDK-enabled env (the base image / api container), NOT a bare host:
**   docker run --rm -i spicexplorer-spice-base:local \
**     bash -lc 'd=$(mktemp -d) && cat > $d/c.spice && cd $d && ngspice -b c.spice' < raw/amp_030_miller_cmfb_composite/tsmc-n65/ac_open_loop.spice
*----------------------------------------------------------*
** params: 21 free + 6 frozen knobs (sizing.yaml) · 17 tied · 0 ratio-derived (abstract/params.yaml) · 3 testbench params
** AUTHORED TEMPLATE — amplifier/ac_open_loop_diff (fully-differential open-loop AC).
** Open-loop DIFFERENTIAL gain/phase of a self-biased FD OTA (internal current reference,
** no external ibias port; e.g. amp_020_two_stage_miller_cmfb). Differential input driven directly
** — no AnalogGym-style bias-wrap needed: unlike a single-ended amp with no output
** feedback of any kind, a genuinely SYMMETRIC differential topology driven by MATCHED
** (vinp=vinn=VCM) inputs gives a well-defined output OFFSET regardless of open-loop gain
** — both branches move together, not apart, so there is nothing for the gain to amplify
** into a rail. (The output COMMON MODE still has to be centered by sizing — see
** pdk/<pdk>/sizing.yaml — but that's a device-sizing concern, not a testbench one.)
**
** Required bindings: DUT (subckt name), PORT_LINE (instance port order = circuit.yaml
**   ports: vinp vinn voutp voutn vdd vss), VDD VCM CL, FSTART FSTOP PPD,
**   PDK_INCLUDE (.lib/.include lines for the bound PDK+corner).
*----------------------------------------------------------*
.lib tsmc_n65_models.scs tt
.temp 27

.param VDD=1.2
.param VCM=0.6
.param CL=10p

Vdd  vdd 0 dc {VDD}
Vss  vss 0 dc 0
CLoadp voutp 0 {CL}
CLoadn voutn 0 {CL}

* DUT instance (port order = circuit.yaml ports)
XDUT vinp vinn voutp voutn vdd vss amp_030_miller_cmfb_composite

* --- input drive (AC open loop, differential) ---
Vcm  vcm 0 dc {VCM}
Vinp vinp vcm dc 0 ac 0.5
Vinn vinn vcm dc 0 ac -0.5

.control
  set filetype=ascii
  ac dec 101 10 1G
  let vodm = v(voutp) - v(voutn)
  * db()/cph() must be precomputed as their own vectors before use in .meas FIND/WHEN —
  * ngspice's vdb()/cph() shorthand only resolves against real circuit nodes, not a
  * `let`-derived vector like vodm, so a bare `FIND db(vodm)` fails to resolve.
  let dbvodm = db(vodm)
  meas ac dcgain  FIND dbvodm  AT=10
  meas ac ugf     WHEN dbvodm=0 FALL=1
  * cph() = continuous (unwrapped) phase — vp() wraps at +/-180 and corrupts PM for
  * multi-pole phase trajectories; normalize to the DC phase so PM = 180 - total phase lag.
  let phc = cph(vodm)*180/3.14159265
  let ph = 180 + phc - phc[0]
  meas ac pm      FIND ph WHEN dbvodm=0 FALL=1
  write
  quit
.endc
.param x_dut_xm1_core_w=5e-06
.param x_dut_xm1_core_l=5e-07
.param x_dut_xm3_core_w=5e-06
.param x_dut_xm3_core_l=2e-06
.param x_dut_xm5_core_w=4e-05
.param x_dut_xm5_core_l=2e-06
.param x_dut_xm6_core_w=3.5e-06
.param x_dut_xm6_core_l=2e-06
.param x_dut_xm7_core_w=1.05e-05
.param x_dut_xm8_core_w=3.5e-06
.param x_dut_r1_core_value=8000.0
.param x_dut_c1_core_value=1p
.param i_bias_core=2e-05
.param x_dut_xm1_core_m=1
.param x_dut_xm3_core_m=1
.param x_dut_xm5_core_m=1
.param x_dut_xm6_core_m=1
.param x_dut_xm7_core_m=1
.param x_dut_xm8_core_m=1
.param gm_val_servo=100u
.param rout_val_servo=10k
.param cout_val_servo=100f
.param rin_val_servo=1e12
.param cin_val_servo=10f
.param x_dut_rmp_servo_value=1Meg
.param vcm_ref=0.6
.param vbl0=0.71
* ---- GENERATED parameter ties (abstract/params.yaml groups/ratios) ----
* Each tied symbol is defined exactly once, by its line below; rewrite that
* .param to untie just that symbol (untying = shadowing, plan D-3).
.param x_dut_xm10_core_l = {x_dut_xm6_core_l}
.param x_dut_xm7_core_l = {x_dut_xm6_core_l}
.param x_dut_xm8_core_l = {x_dut_xm6_core_l}
.param x_dut_xm2_core_w = {x_dut_xm1_core_w}
.param x_dut_xm2_core_l = {x_dut_xm1_core_l}
.param x_dut_xm2_core_m = {x_dut_xm1_core_m}
.param x_dut_xm4_core_w = {x_dut_xm3_core_w}
.param x_dut_xm4_core_l = {x_dut_xm3_core_l}
.param x_dut_xm4_core_m = {x_dut_xm3_core_m}
.param x_dut_xm9_core_w = {x_dut_xm5_core_w}
.param x_dut_xm9_core_l = {x_dut_xm5_core_l}
.param x_dut_xm9_core_m = {x_dut_xm5_core_m}
.param x_dut_xm10_core_w = {x_dut_xm7_core_w}
.param x_dut_xm10_core_m = {x_dut_xm7_core_m}
.param x_dut_r2_core_value = {x_dut_r1_core_value}
.param x_dut_c2_core_value = {x_dut_c1_core_value}
.param x_dut_rmn_servo_value = {x_dut_rmp_servo_value}
.subckt amp_030_miller_cmfb_composite vinp vinn voutp voutn vdd vss
C1_CORE core__mill_p voutp 'x_dut_c1_core_value'
C2_CORE core__mill_n voutn 'x_dut_c2_core_value'
CIN_SERVO_SERVO servo__cm_sense vref_cm 'cin_val_servo'
COUT_SERVO_SERVO vss vcmfb_raw 'cout_val_servo'
GM_SERVO_SERVO vss vcmfb_raw vref_cm servo__cm_sense {gm_val_servo}
IBIAS_CORE vdd core__ref dc {i_bias_core}
R1_CORE core__stg1p core__mill_p 'x_dut_r1_core_value'
R2_CORE core__stg1n core__mill_n 'x_dut_r2_core_value'
RIN_SERVO_SERVO servo__cm_sense vref_cm 'rin_val_servo'
RMN_SERVO voutn servo__cm_sense 'x_dut_rmn_servo_value'
RMP_SERVO servo__cm_sense voutp 'x_dut_rmp_servo_value'
ROUT_SERVO_SERVO vss vcmfb_raw 'rout_val_servo'
VBL0 vbl_ctl vcmfb_raw dc {vbl0}
VREFCM vref_cm vss dc {vcm_ref}
XM10_CORE voutn core__ref vss vss nch_lvt l=x_dut_xm10_core_l m=x_dut_xm10_core_m w=x_dut_xm10_core_w
XM1_CORE core__stg1p vinp core__tail vss nch_lvt l=x_dut_xm1_core_l m=x_dut_xm1_core_m w=x_dut_xm1_core_w
XM2_CORE core__stg1n vinn core__tail vss nch_lvt l=x_dut_xm2_core_l m=x_dut_xm2_core_m w=x_dut_xm2_core_w
XM3_CORE core__stg1p vbl_ctl vdd vdd pch_lvt l=x_dut_xm3_core_l m=x_dut_xm3_core_m w=x_dut_xm3_core_w
XM4_CORE core__stg1n vbl_ctl vdd vdd pch_lvt l=x_dut_xm4_core_l m=x_dut_xm4_core_m w=x_dut_xm4_core_w
XM5_CORE voutp core__stg1p vdd vdd pch_lvt l=x_dut_xm5_core_l m=x_dut_xm5_core_m w=x_dut_xm5_core_w
XM6_CORE core__ref core__ref vss vss nch_lvt l=x_dut_xm6_core_l m=x_dut_xm6_core_m w=x_dut_xm6_core_w
XM7_CORE voutp core__ref vss vss nch_lvt l=x_dut_xm7_core_l m=x_dut_xm7_core_m w=x_dut_xm7_core_w
XM8_CORE core__tail core__ref vss vss nch_lvt l=x_dut_xm8_core_l m=x_dut_xm8_core_m w=x_dut_xm8_core_w
XM9_CORE voutn core__stg1n vdd vdd pch_lvt l=x_dut_xm9_core_l m=x_dut_xm9_core_m w=x_dut_xm9_core_w
.ends
.end
