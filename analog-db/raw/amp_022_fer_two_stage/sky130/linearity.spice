** GENERATED by `analog-db export-raw` — DO NOT EDIT.
** circuit=amp_022_fer_two_stage  class=amplifier  pdk=sky130  testbench=linearity  corner=tt
** Self-contained deck: testbench + bound params + lowered DUT (.subckt amp_022_fer_two_stage).
** PDK corner libs resolve by BARE NAME on the image's ngspice sourcepath — run in a
** PDK-enabled env (the base image / api container), NOT a bare host:
**   docker run --rm -i spicexplorer-spice-base:local \
**     bash -lc 'd=$(mktemp -d) && cat > $d/c.spice && cd $d && ngspice -b c.spice' < raw/amp_022_fer_two_stage/sky130/linearity.spice
*----------------------------------------------------------*
** params: 10 free + 5 frozen knobs (sizing.yaml) · 12 tied · 4 ratio-derived (abstract/params.yaml) · 4 testbench params
** AUTHORED TEMPLATE — amplifier/linearity (plan D-4; the cascode 5th analysis, distilled).
** SCAFFOLD: input common-mode range (ICMR) via a buffer-connected DC sweep — the input
** range over which the follower tracks within VTRACK. The legacy cascode TB additionally
** gated on the tail-current plateau via an internal ammeter (v.xota.vmeas1#branch), which
** depends on legacy-DUT internals; this distilled form is DUT-agnostic. Bind with
** `enabled: false` until per-circuit thresholds are reviewed.
** Bindings: DUT PORT_LINE VDD VCM IBIAS CL VTRACK VSWEEP_STEP SLOPE_TOL PDK_INCLUDE.
.lib sky130.lib.spice tt
.temp 27

.param VDD=1.5
.param VCM=0.6
.param IBIAS=20u
.param CL=500f

Vdd  vdd 0 dc {VDD}
Vss  vss 0 dc 0
Ibias vdd ibias dc {IBIAS}
CLoad vout 0 {CL}

* buffer-connected: vinn shorted to vout; sweep the common-mode input
Vinp vinp 0 dc {VCM}
Vfb  vinn vout dc 0

XDUT vdd vout vinp vinn ibias vss amp_022_fer_two_stage

.control
  set filetype=ascii
  dc Vinp 0 1.5 0.005
  let verr = abs(v(vout) - v(vinp))
  * ICMR = widest CONTIGUOUS run of points that both track in absolute terms
  * (|verr| <= VTRACK) and are ACTIVE (dvout/dvin ~ 1). This mirrors the platform registry's
  * `{meas: icmr_range}` (spicexplorer_core waveforms.icmr_band) exactly, so the analog-db
  * run/verify lane and the optimizer lane report the same number.
  *
  * REWRITTEN 2026-07-20. The previous form was `meas dc ... WHEN verr=VTRACK CROSS=1/LAST`,
  * which was wrong two ways. (1) CROSS=1 finds the band EXIT on a DUT that already tracks at
  * vin=0, so the pair returned the complement of the real band — it read amp_022 as 0.105 V
  * against a true 1.400 V. (2) More fundamentally, an absolute-error test ALONE cannot tell
  * "the follower is tracking" from "both ends sit near the same rail": where the input pair
  * is cut off vout is pinned at a rail, and if vin is near that rail too then verr is small
  * by coincidence. That reported a 3.23 V band on a 3.3 V supply for amp_033. The slope test
  * rejects those dead points because a railed output has dvout/dvin ~ 0.
  let vsw = v(vinp)
  let dvout = deriv(v(vout))
  let dvin  = deriv(vsw)
  let slope = dvout / dvin
  let intrack = (verr <= 20m) & (abs(slope - 1) <= 0.1)
  let npts = length(intrack)
  let k = 0
  let best = 0
  let bstart = 0
  let bend = 0
  let cstart = 0
  let inband = 0
  while k < npts
    if intrack[k] > 0.5
      if inband < 0.5
        let cstart = vsw[k]
        let inband = 1
      end
      if (vsw[k] - cstart) > best
        let best = vsw[k] - cstart
        let bstart = cstart
        let bend = vsw[k]
      end
    else
      let inband = 0
    end
    let k = k + 1
  end
  let icmr_min = bstart
  let icmr_max = bend
  let icmr_range = best
  print icmr_min icmr_max icmr_range
  write
  quit
.endc
.param x_dut_xmbd_w=4
.param x_dut_xm7_w=8
.param x_dut_xm0_w=8
.param x_dut_xm3_w=6
.param x_dut_xm7_l=0.4
.param x_dut_xm0_l=0.4
.param x_dut_xm3_l=0.4
.param x_dut_xm2_l=0.4
.param x_dut_xmbd_l=0.4
.param x_dut_cc_value=2e-12
.param x_dut_xm0_m=5
.param x_dut_xm3_m=2
.param x_dut_xm2_m=24
.param x_dut_xm7_m=3
.param x_dut_xmbd_m=1
* ---- GENERATED parameter ties (abstract/params.yaml groups/ratios) ----
* Each tied symbol is defined exactly once, by its line below; rewrite that
* .param to untie just that symbol (untying = shadowing, plan D-3).
.param x_dut_xm1_w = {x_dut_xm0_w}
.param x_dut_xm1_l = {x_dut_xm0_l}
.param x_dut_xm1_m = {x_dut_xm0_m}
.param x_dut_xm4_w = {x_dut_xm3_w}
.param x_dut_xm4_l = {x_dut_xm3_l}
.param x_dut_xm2_w = {x_dut_xm3_w}
.param x_dut_xm5_w = {x_dut_xm7_w}
.param x_dut_xm6_w = {x_dut_xm7_w}
.param x_dut_xm5_l = {x_dut_xm7_l}
.param x_dut_xm6_l = {x_dut_xm7_l}
.param x_dut_xmbs_w = {x_dut_xmbd_w}
.param x_dut_xmbs_l = {x_dut_xmbd_l}
.param x_dut_xm4_m = {x_dut_xm3_m*1}
.param x_dut_xm5_m = {x_dut_xm7_m*1}
.param x_dut_xm6_m = {x_dut_xm7_m*17/3}
.param x_dut_xmbs_m = {x_dut_xmbd_m*1}
.subckt amp_022_fer_two_stage vdd vout vinp vinn ibias vss
CC b vout x_dut_cc_value
XM0 a vinn c vdd sky130_fd_pr__pfet_01v8 l=x_dut_xm0_l m=x_dut_xm0_m w=x_dut_xm0_w
XM1 b vinp c vdd sky130_fd_pr__pfet_01v8 l=x_dut_xm1_l m=x_dut_xm1_m w=x_dut_xm1_w
XM2 vout b vss vss sky130_fd_pr__nfet_01v8 l=x_dut_xm2_l m=x_dut_xm2_m w=x_dut_xm2_w
XM3 a a vss vss sky130_fd_pr__nfet_01v8 l=x_dut_xm3_l m=x_dut_xm3_m w=x_dut_xm3_w
XM4 b a vss vss sky130_fd_pr__nfet_01v8 l=x_dut_xm4_l m=x_dut_xm4_m w=x_dut_xm4_w
XM5 c pbias vdd vdd sky130_fd_pr__pfet_01v8 l=x_dut_xm5_l m=x_dut_xm5_m w=x_dut_xm5_w
XM6 vout pbias vdd vdd sky130_fd_pr__pfet_01v8 l=x_dut_xm6_l m=x_dut_xm6_m w=x_dut_xm6_w
XM7 pbias pbias vdd vdd sky130_fd_pr__pfet_01v8 l=x_dut_xm7_l m=x_dut_xm7_m w=x_dut_xm7_w
XMBD ibias ibias vss vss sky130_fd_pr__nfet_01v8 l=x_dut_xmbd_l m=x_dut_xmbd_m w=x_dut_xmbd_w
XMBS pbias ibias vss vss sky130_fd_pr__nfet_01v8 l=x_dut_xmbs_l m=x_dut_xmbs_m w=x_dut_xmbs_w
.ends
.end
