** GENERATED by `analog-db export-raw` — DO NOT EDIT.
** circuit=ldo_008_fer_mirror_ota  class=ldo  pdk=ihp-sg13g2  testbench=ac_loopgain  corner=tt
** Self-contained deck: testbench + bound params + lowered DUT (.subckt ldo_008_fer_mirror_ota).
** PDK corner libs resolve by BARE NAME on the image's ngspice sourcepath — run in a
** PDK-enabled env (the base image / api container), NOT a bare host:
**   docker run --rm -i spicexplorer-spice-base:local \
**     bash -lc 'd=$(mktemp -d) && cat > $d/c.spice && cd $d && ngspice -b c.spice' < raw/ldo_008_fer_mirror_ota/ihp-sg13g2/ac_loopgain.spice
*----------------------------------------------------------*
** params: 11 free + 9 frozen knobs (sizing.yaml) · 7 tied · 0 ratio-derived (abstract/params.yaml) · 1 testbench params
** AUTHORED TEMPLATE — ldo/ac_loopgain: TRUE regulation-loop gain, phase margin and gain margin
** by Middlebrook voltage injection at an in-DUT loop-break marker.
**
** Why this exists: an LDO's regulation loop is entirely INSIDE the subckt (vout -> error amp ->
** pass gate -> vout), so it cannot be broken from the [vdd, vout, vss] ports. The class's
** `loop_stability` bench measures closed-loop output-impedance peaking (zout_peak_db) as an
** honest proxy, but peaking is a symptom, not a margin — it cannot tell you HOW MUCH phase you
** have, and a critically-damped loop and a 30-degree loop can show similar peaks under different
** loads. This bench gives the real number.
**
** CONTRACT — the DUT must carry a loop-break marker. Put a 0 V source in the feedback path of the
** abstract netlist, between the driving node and the sensing input:
**     Vlp lp_brk vout dc 0        ; and feed the error amp's sense input from lp_brk, not vout
** A 0 V source with no AC spec is an ideal short, so it is INVISIBLE to every other analysis —
** dc_op / load_regulation / psrr / the transients all see the loop closed exactly as before. Only
** this bench turns it into a generator, via `alter`. This mirrors the amplifier class's `stb`
** bench, which uses the same 0 V VIPRB marker convention (there it becomes a Spectre iprobe).
**
** INJECTION POINT: it must sit where the source-side impedance is LOW and the load-side impedance
** is HIGH — vout (driven hard by the pass device and the output cap) into a MOSFET gate satisfies
** that by a wide margin, which is what makes the Middlebrook approximation valid here.
**
** MATH: the marker forces V(lp_brk) - V(vout) = 1 V AC. With G the transfer once around the rest
** of the loop (lp_brk -> error amp -> pass device -> vout):
**     V(vout) = G * V(lp_brk)  and  V(lp_brk) = V(vout) + 1
**  => V(lp_brk) = 1/(1-G),  V(vout) = G/(1-G),  so  T = v(vout)/v(lp_brk) = G  exactly.
** No small-signal approximation is involved in that algebra; the only assumption is the impedance
** condition above.
**
** VALIDATED 2026-07-20 against a known answer: applied to amp_033_ti_ldo_ref_selfbias closed as a
** unity buffer, this method returns 74.9178 dB / 12.083 MHz / 21.05 deg where the independent
** amplifier `ac_open_loop_biaswrap` bench returns 74.9177 dB / 12.112 MHz / 20.997 deg — agreement
** to the frequency-grid resolution. The phase normalisation (180 + phc - phc[0]) is the same
** sign-convention-agnostic form the amplifier open-loop templates use, so an inverting loop
** (phc[0] ~ 180 deg) and a non-inverting one both report the same physical margin.
**
** Bindings: DUT PORT_LINE VDD ILOAD COUT PPD FSTART FSTOP LP_PROBE PDK_INCLUDE.
** LP_PROBE is the marker's instance name inside the DUT (default `vlp`, see assemble.py).
.lib cornerMOSlv.lib mos_tt
.temp 27

.param VDD=1.8

Vdd  vdd 0 dc {VDD}
Vss  vss 0 dc 0
Iload vout 0 dc 1m
CLoad vout 0 1u

XDUT vdd vout vss ldo_008_fer_mirror_ota

.control
  set filetype=ascii
  * turn the in-loop 0 V marker into a 1 V AC generator (it stays a plain short at DC, so the
  * operating point this measurement rides on is the regulated one)
  alter @v.xdut.vlp[acmag] = 1
  ac dec 51 1 1G
  let tloop = v(vout) / v(xdut.lp_brk)
  let tdb  = db(tloop)
  let tphc = cph(tloop)*180/3.14159265
  let tph  = 180 + tphc - tphc[0]
  meas ac loopgain_db FIND tdb AT=1
  meas ac ugf_loop    WHEN tdb=0 FALL=1
  meas ac pm_loop     FIND tph WHEN tdb=0 FALL=1
  * gain margin: attenuation still in hand where the loop phase reaches 0 (i.e. 180 deg of shift
  * from the DC value). NaN when the phase never gets there — an honest "unconditionally stable"
  * rather than a fabricated number.
  meas ac gm_at_180 FIND tdb WHEN tph=0 FALL=1
  let gm_loop_db = 0 - gm_at_180
  * SENSITIVITY-FUNCTION PEAK. For a regulator, Zout_cl = Zout_ol/(1+T_rr), so
  * |Zout_cl|/|Zout_ol| = |1/(1+T_rr)| = |S| exactly, and its peak Ms is the damping
  * figure the zout_peak_db proxy was standing in for. Ms comes free from THIS sweep:
  * no open-loop Zout run is needed.
  * SIGN: tloop is the raw around-the-loop transfer measured at the marker, and it is
  * NEGATIVE at DC for a negative-feedback loop (vout up -> pass current down -> vout
  * down), i.e. tphc[0] ~ +/-180 deg. The return ratio is therefore T_rr = -tloop, and
  * S = 1/(1 - tloop). This was ADJUDICATED by measurement, not assumed: on
  * ldo_005/ihp-sg13g2 the two candidate conventions give 4.3447 dB and 4.2e-06 dB,
  * and only the first is admissible, because Ms >= 1/(2 sin(PM/2)) forces Ms >= 1.270
  * (2.07 dB) at that run's 46.39 deg phase margin. The 1/(1+tloop) form collapses to
  * 0 dB exactly as expected for the wrong sign: |1+T| is huge in band, so its peak is
  * just the high-frequency limit where the loop gain dies and |S| -> 1.
  * tloop_ph_dc is recorded on every run as the standing guard: a circuit whose DC loop
  * phase is NOT near +/-180 does not satisfy this convention and its ms_peak must not
  * be trusted.
  let s_db = db(1/(1-tloop))
  meas ac ms_peak     MAX s_db
  meas ac tloop_ph_dc FIND tphc AT=1
  print loopgain_db ugf_loop pm_loop gm_loop_db ms_peak tloop_ph_dc
  write
  quit
.endc
.param x_dut_xmnb_w=8u
.param x_dut_xmnb_l=0.5u
.param x_dut_xmdr_w=6u
.param x_dut_xmdr_l=0.3u
.param x_dut_xmld_w=8u
.param x_dut_xmld_l=0.5u
.param x_dut_xmp_w=8u
.param x_dut_xmp_l=0.2u
.param x_rcomp=2000
.param x_ccomp=160e-12
.param x_dut_rt_value=9000
.param x_vref_val=0.6
.param x_ibias_val=20e-6
.param x_dut_xmnb_m=1
.param x_dut_xmnt_m=4
.param x_dut_xmdr_m=4
.param x_dut_xmdf_m=4
.param x_dut_xmld_m=4
.param x_dut_xmlm_m=4
.param x_dut_xmp_m=60
* ---- GENERATED parameter ties (abstract/params.yaml groups/ratios) ----
* Each tied symbol is defined exactly once, by its line below; rewrite that
* .param to untie just that symbol (untying = shadowing, plan D-3).
.param x_dut_xmnt_w = {x_dut_xmnb_w}
.param x_dut_xmnt_l = {x_dut_xmnb_l}
.param x_dut_xmdf_w = {x_dut_xmdr_w}
.param x_dut_xmdf_l = {x_dut_xmdr_l}
.param x_dut_xmlm_w = {x_dut_xmld_w}
.param x_dut_xmlm_l = {x_dut_xmld_l}
.param x_dut_rb_value = {x_dut_rt_value}
.subckt ldo_008_fer_mirror_ota vdd vout vss
CC czero vout x_ccomp
IBI vdd nbias dc {x_ibias_val}
RB fb vss x_dut_rb_value
RC egate czero x_rcomp
RT lp_brk fb x_dut_rt_value
VLP lp_brk vout dc 0
VREF vref vss dc {x_vref_val}
XMDF ldiode fb tail vss sg13_lv_nmos l=x_dut_xmdf_l m=x_dut_xmdf_m w=x_dut_xmdf_w
XMDR egate vref tail vss sg13_lv_nmos l=x_dut_xmdr_l m=x_dut_xmdr_m w=x_dut_xmdr_w
XMLD ldiode ldiode vdd vdd sg13_lv_pmos l=x_dut_xmld_l m=x_dut_xmld_m w=x_dut_xmld_w
XMLM egate ldiode vdd vdd sg13_lv_pmos l=x_dut_xmlm_l m=x_dut_xmlm_m w=x_dut_xmlm_w
XMNB nbias nbias vss vss sg13_lv_nmos l=x_dut_xmnb_l m=x_dut_xmnb_m w=x_dut_xmnb_w
XMNT tail nbias vss vss sg13_lv_nmos l=x_dut_xmnt_l m=x_dut_xmnt_m w=x_dut_xmnt_w
XMP vout egate vdd vdd sg13_lv_pmos l=x_dut_xmp_l m=x_dut_xmp_m w=x_dut_xmp_w
.ends
.end
