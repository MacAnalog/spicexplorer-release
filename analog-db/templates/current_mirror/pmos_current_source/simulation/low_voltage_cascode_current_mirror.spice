** sch_path: low_voltage_cascode_current_mirror.sch
**.subckt low_voltage_cascode_current_mirror VDD iin VBIAS iout
*.iopin VDD
*.iopin iin
*.iopin VBIAS
*.iopin iout
XM1 net2 iin VDD VDD sg13_lv_pmos w=0.15u l=0.13u ng=1 m=1
XM2 net1 iin VDD VDD sg13_lv_pmos w=0.15u l=0.13u ng=1 m=1
XM3 iout VBIAS net1 VDD sg13_lv_pmos w=0.15u l=0.13u ng=1 m=1
XM4 iin VBIAS net2 VDD sg13_lv_pmos w=0.15u l=0.13u ng=1 m=1
**.ends
.end
