** GENERATED by `analog-db export-raw` — DO NOT EDIT.
** Standalone lowered DUT subckt for cmp_001_hyst_diffpair on sky130 (sizing .param defaults + .subckt).
** Not a runnable deck on its own — include it under your own testbench:
**   .include _dut.spice
**   XDUT vdd vout vinp vinn vss cmp_001_hyst_diffpair
** Source: pdk/sky130/netlist.spice (run `analog-db generate` to refresh).
*----------------------------------------------------------*
** params: 10 free + 12 frozen knobs (sizing.yaml) · 17 tied · 0 ratio-derived (abstract/params.yaml)
.param x_dut_xmip_w=10
.param x_dut_xmip_l=0.3
.param x_dut_xmpld_w=10
.param x_dut_xmpld_l=0.3
.param x_dut_xmhn_w=1
.param x_dut_xmb1p_w=5
.param x_dut_xmb1n_w=2
.param x_dut_xmb1p_l=0.15
.param x_rtail=6000
.param x_dut_rhn_value=3e5
.param x_dut_xmip_m=2
.param x_dut_xmin_m=2
.param x_dut_xmpld_m=4
.param x_dut_xmplm_m=4
.param x_dut_xmhn_m=1
.param x_dut_xmhp_m=1
.param x_dut_xmb1p_m=1
.param x_dut_xmb1n_m=1
.param x_dut_xmb2p_m=2
.param x_dut_xmb2n_m=2
.param x_dut_xmb3p_m=4
.param x_dut_xmb3n_m=4
* ---- GENERATED parameter ties (abstract/params.yaml groups/ratios) ----
* Each tied symbol is defined exactly once, by its line below; rewrite that
* .param to untie just that symbol (untying = shadowing, plan D-3).
.param x_dut_xmin_l = {x_dut_xmip_l}
.param x_dut_xmhn_l = {x_dut_xmip_l}
.param x_dut_xmhp_l = {x_dut_xmip_l}
.param x_dut_xmin_w = {x_dut_xmip_w}
.param x_dut_xmplm_w = {x_dut_xmpld_w}
.param x_dut_xmplm_l = {x_dut_xmpld_l}
.param x_dut_xmhp_w = {x_dut_xmhn_w}
.param x_dut_xmb1n_l = {x_dut_xmb1p_l}
.param x_dut_xmb2p_l = {x_dut_xmb1p_l}
.param x_dut_xmb2n_l = {x_dut_xmb1p_l}
.param x_dut_xmb3p_l = {x_dut_xmb1p_l}
.param x_dut_xmb3n_l = {x_dut_xmb1p_l}
.param x_dut_xmb2p_w = {x_dut_xmb1p_w}
.param x_dut_xmb3p_w = {x_dut_xmb1p_w}
.param x_dut_xmb2n_w = {x_dut_xmb1n_w}
.param x_dut_xmb3n_w = {x_dut_xmb1n_w}
.param x_dut_rhp_value = {x_dut_rhn_value}
.subckt cmp_001_hyst_diffpair vdd vout vinp vinn vss
RHN n1 hn x_dut_rhn_value
RHP n1 hp x_dut_rhp_value
RT tail vss x_rtail
XMB1N b1 n1 vss vss sky130_fd_pr__nfet_01v8 l=x_dut_xmb1n_l m=x_dut_xmb1n_m w=x_dut_xmb1n_w
XMB1P b1 n1 vdd vdd sky130_fd_pr__pfet_01v8 l=x_dut_xmb1p_l m=x_dut_xmb1p_m w=x_dut_xmb1p_w
XMB2N b2 b1 vss vss sky130_fd_pr__nfet_01v8 l=x_dut_xmb2n_l m=x_dut_xmb2n_m w=x_dut_xmb2n_w
XMB2P b2 b1 vdd vdd sky130_fd_pr__pfet_01v8 l=x_dut_xmb2p_l m=x_dut_xmb2p_m w=x_dut_xmb2p_w
XMB3N vout b2 vss vss sky130_fd_pr__nfet_01v8 l=x_dut_xmb3n_l m=x_dut_xmb3n_m w=x_dut_xmb3n_w
XMB3P vout b2 vdd vdd sky130_fd_pr__pfet_01v8 l=x_dut_xmb3p_l m=x_dut_xmb3p_m w=x_dut_xmb3p_w
XMHN hn vout vss vss sky130_fd_pr__nfet_01v8 l=x_dut_xmhn_l m=x_dut_xmhn_m w=x_dut_xmhn_w
XMHP hp vout vdd vdd sky130_fd_pr__pfet_01v8 l=x_dut_xmhp_l m=x_dut_xmhp_m w=x_dut_xmhp_w
XMIN n2 vinn tail vss sky130_fd_pr__nfet_01v8 l=x_dut_xmin_l m=x_dut_xmin_m w=x_dut_xmin_w
XMIP n1 vinp tail vss sky130_fd_pr__nfet_01v8 l=x_dut_xmip_l m=x_dut_xmip_m w=x_dut_xmip_w
XMPLD n2 n2 vdd vdd sky130_fd_pr__pfet_01v8 l=x_dut_xmpld_l m=x_dut_xmpld_m w=x_dut_xmpld_w
XMPLM n1 n2 vdd vdd sky130_fd_pr__pfet_01v8 l=x_dut_xmplm_l m=x_dut_xmplm_m w=x_dut_xmplm_w
.ends
