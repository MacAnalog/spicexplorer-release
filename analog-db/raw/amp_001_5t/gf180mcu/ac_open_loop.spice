** GENERATED by `analog-db export-raw` — DO NOT EDIT.
** circuit=amp_001_5t  class=amplifier  pdk=gf180mcu  testbench=ac_open_loop  corner=tt
** Self-contained deck: testbench + bound params + lowered DUT (.subckt amp_001_5t).
** PDK corner libs resolve by BARE NAME on the image's ngspice sourcepath — run in a
** PDK-enabled env (the base image / api container), NOT a bare host:
**   docker run --rm -i spicexplorer-spice-base:local \
**     bash -lc 'd=$(mktemp -d) && cat > $d/c.spice && cd $d && ngspice -b c.spice' < raw/amp_001_5t/gf180mcu/ac_open_loop.spice
*----------------------------------------------------------*
** params: 8 free + 4 frozen knobs (sizing.yaml) · 6 tied · 0 ratio-derived (abstract/params.yaml) · 4 testbench params
** AUTHORED TEMPLATE — amplifier/ac_open_loop (plan D-4).
** Open-loop AC gain/phase of an OTA. Placeholders are bound by the analysis resolver
** (assemble.py) from analyses/<id>.yaml params + datasheet default_conditions.
** Flag `bias_wrap` (AnalogGym trick): close the DC loop with a huge Lfb/Cin so the DUT
** self-biases, while the AC path stays open. Without the flag the inputs are driven directly.
**
** Required bindings: DUT (subckt name), PORT_LINE (instance port order),
**   VDD VCM IBIAS CL, FSTART FSTOP PPD (points/decade),
**   PDK_INCLUDE (.lib/.include lines for the bound PDK+corner).
*----------------------------------------------------------*
.include design.ngspice
.lib sm141064.ngspice noise_corner
.lib sm141064.ngspice nfet_03v3_t
.lib sm141064.ngspice pfet_03v3_t
.lib sm141064.ngspice fets_mm
.temp 27

.param VDD=1.5
.param VCM=0.8
.param IBIAS=20u
.param CL=10p

Vdd  vdd 0 dc {VDD}
Vss  vss 0 dc 0
Ibias vdd ibias dc {IBIAS}
CLoad vout 0 {CL}

* DUT instance (port order = circuit.yaml ports)
XDUT vdd vout vinp vinn ibias vss amp_001_5t

* --- input drive (AC open loop) ---
Vcm  vcm 0 dc {VCM}
Vinp vinp vcm dc 0 ac 0.5
Vinn vinn vcm dc 0 ac -0.5

.control
  set filetype=ascii
  ac dec 101 1k 100MEG
  meas ac dcgain  FIND vdb(vout) AT=1k
  meas ac ugf     WHEN vdb(vout)=0 FALL=1
  * cph() = continuous (unwrapped) phase — vp() wraps at +/-180 and corrupts PM for
  * multi-pole phase trajectories; normalize to the DC phase so PM = 180 - total phase lag.
  * NOTE: this DIRECT open-loop PM is reliable for dominant-pole single-stage OTAs (5t,
  * folded-cascode). For a telescopic cascode the differential→single-ended mirror path adds
  * excess phase that makes direct-drive PM ill-defined — accurate PM/stability there needs a
  * dedicated loop-gain probe (the legacy tb-loopgain testbench / a future ac_loopgain template).
  let phc = cph(vout)*180/3.14159265
  let ph = 180 + phc - phc[0]
  meas ac pm      FIND ph WHEN vdb(vout)=0 FALL=1
  * STABILITY GUARDS (2026-08-18, tcas-2026 E-041). `pm` above is a Bode margin and a Bode margin
  * assumes the open loop has no right-half-plane poles. Multistage amps with internal
  * compensation loops (Peng IAC / TCFC and kin) can lose that at a random sizing: the small-
  * signal response then shows phase LEAD instead of lag, `pm` reads 140-585 deg, and the sizing
  * oscillates rail-to-rail in the closed-loop step bench (301/301 such "feasible" sizings did).
  * Finer PPD does not change it (checked at 50/200/1000): the unwrap is right, the premise is
  * wrong. Two additive readings so a reader (or an optimizer spec) can see it without a tran:
  *   pm_min  worst phase distance to -180 deg anywhere |A| > 0 dB (equals pm when the phase is
  *           monotone; <= 0 when the phase touches -180 while the gain is still above unity)
  *   gm      gain margin at the first -180 deg crossing, -999 when the phase never gets there
  * `pm` itself is unchanged. Neither guard replaces the closed-loop step: a sizing with RHP
  * poles can pass both (pm 178, pm_min 22, gm +72 measured on one) and still oscillate. The
  * settling bench (tran_step) is the stability verdict; keep it scored.
  * (masks use `<=` and `1 - mask` only -- see the `>` parser gotcha in stb.spice.)
  let gdb    = vdb(vout)
  let mb     = (gdb <= 0)
  let ma     = 1 - mb
  let pm_min = minimum(ph*ma + 999*mb)
  * |A| never above 0 dB -> no band to take a minimum over -> the NEGATIVE sentinel, so a
  * min-bound spec fails instead of sailing past (stb.spice, 'THE SEED MUST NOT BE A MEASUREMENT')
  let mok    = (pm_min <= 998)
  let pm_min = pm_min*mok + (-999)*(1 - mok)
  let ngdb   = 0 - gdb
  let gm     = -999
  meas ac gm FIND ngdb WHEN ph=0 CROSS=1
  print pm_min gm
  write
  quit
.endc
.param x_dut_xm1_w=0.5u
.param x_dut_xm1_l=5u
.param x_dut_xm3_w=1.5u
.param x_dut_xm3_l=5u
.param x_dut_xm5_w=2u
.param x_dut_xm5_l=5u
.param x_dut_xm6_w=2u
.param x_dut_xm6_l=5u
.param x_dut_xm1_m=1
.param x_dut_xm3_m=1
.param x_dut_xm5_m=1
.param x_dut_xm6_m=1
* ---- GENERATED parameter ties (abstract/params.yaml groups/ratios) ----
* Each tied symbol is defined exactly once, by its line below; rewrite that
* .param to untie just that symbol (untying = shadowing, plan D-3).
.param x_dut_xm2_w = {x_dut_xm1_w}
.param x_dut_xm2_l = {x_dut_xm1_l}
.param x_dut_xm2_m = {x_dut_xm1_m}
.param x_dut_xm4_w = {x_dut_xm3_w}
.param x_dut_xm4_l = {x_dut_xm3_l}
.param x_dut_xm4_m = {x_dut_xm3_m}
.subckt amp_001_5t vdd vout vinp vinn ibias vss
XM1 outm vinp tail vss nfet_03v3 l=x_dut_xm1_l m=x_dut_xm1_m w=x_dut_xm1_w
XM2 vout vinn tail vss nfet_03v3 l=x_dut_xm2_l m=x_dut_xm2_m w=x_dut_xm2_w
XM3 outm outm vdd vdd pfet_03v3 l=x_dut_xm3_l m=x_dut_xm3_m w=x_dut_xm3_w
XM4 vout outm vdd vdd pfet_03v3 l=x_dut_xm4_l m=x_dut_xm4_m w=x_dut_xm4_w
XM5 tail ibias vss vss nfet_03v3 l=x_dut_xm5_l m=x_dut_xm5_m w=x_dut_xm5_w
XM6 ibias ibias vss vss nfet_03v3 l=x_dut_xm6_l m=x_dut_xm6_m w=x_dut_xm6_w
.ends
.end
