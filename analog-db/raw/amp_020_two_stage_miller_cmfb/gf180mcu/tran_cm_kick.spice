** GENERATED by `analog-db export-raw` — DO NOT EDIT.
** circuit=amp_020_two_stage_miller_cmfb  class=amplifier  pdk=gf180mcu  testbench=tran_cm_kick  corner=tt
** Self-contained deck: testbench + bound params + lowered DUT (.subckt amp_020_two_stage_miller_cmfb).
** PDK corner libs resolve by BARE NAME on the image's ngspice sourcepath — run in a
** PDK-enabled env (the base image / api container), NOT a bare host:
**   docker run --rm -i spicexplorer-spice-base:local \
**     bash -lc 'd=$(mktemp -d) && cat > $d/c.spice && cd $d && ngspice -b c.spice' < raw/amp_020_two_stage_miller_cmfb/gf180mcu/tran_cm_kick.spice
*----------------------------------------------------------*
** params: 18 free + 10 frozen knobs (sizing.yaml) · 13 tied · 0 ratio-derived (abstract/params.yaml) · 4 testbench params
** AUTHORED TEMPLATE — amplifier/tran_cm_kick (CM-loop health, time domain).
** Common-mode disturbance recovery: a CM current step ICM (0.5*ICM per side) kicks both
** outputs from TKICK to TREL; the CM feedback loop must absorb it and re-settle vocm.
**   cm_kick_v    settled vocm displacement while the kick is applied (at TMID) —
**                = ICM * Zcm(0); small = stiff servo
**   cm_resid_v   vocm at TEND minus the pre-kick level — residual after release (~0
**                for a healthy loop; nonzero flags CM bistability/latch-up: the kick
**                pushed the amp to another operating point)
**   t_cm_settle  recovery time from the release edge to |vocm - vocm(TEND)| < VTOL
** Ringing shows up as a long t_cm_settle relative to the loop bandwidth. See
** ac_cm_reg.spice's honesty note: internal T_cm/PM_cm need a composed loop probe.
**
** Assumes a self-biased, differential-output DUT with a CM control loop:
**   .subckt <id> vinp vinn voutp voutn vdd vss
** Required bindings: DUT PORT_LINE VDD VCM CL ICM TKICK TMID TREL TEND VTOL TSTEP
**                    TSTOP PDK_INCLUDE.  (TB0 sample of the pre-kick level is taken at
**                    TKICK/2; choose TKICK late enough for startup to settle.)
.include design.ngspice
.lib sm141064.ngspice noise_corner
.lib sm141064.ngspice nfet_03v3_t
.lib sm141064.ngspice pfet_03v3_t
.lib sm141064.ngspice fets_mm
.lib sm141064.ngspice res_typical
.lib sm141064.ngspice mimcap_typical
.lib sm141064.ngspice cap_mim
.temp 27

.param VDD=1.5
.param VCM=0.8
.param CL=50f
.param ICM=5u

Vdd  vdd 0 dc {VDD}
Vss  vss 0 dc 0
CLoadp voutp 0 {CL}
CLoadn voutn 0 {CL}
Vcm  vcm 0 dc {VCM}
Vinp vinp vcm dc 0
Vinn vinn vcm dc 0
* common-mode current kick, applied TKICK..TREL (one-shot: width TREL-TKICK, per >> pw)
Icmp 0 voutp pulse(0 {ICM/2} 2u 10n 10n {6u-2u} 1)
Icmn 0 voutn pulse(0 {ICM/2} 2u 10n 10n {6u-2u} 1)

XDUT vinp vinn voutp voutn vdd vss amp_020_two_stage_miller_cmfb

.control
  set filetype=ascii
  tran 2n 20u
  let vocm = (v(voutp)+v(voutn))/2
  meas tran vocm0 FIND vocm AT={2u/2}
  meas tran vocm_mid FIND vocm AT=5u
  meas tran vocm_end FIND vocm AT=19u
  let cm_kick_v = vocm_mid - vocm0
  let cm_resid_v = vocm_end - vocm0
  let verr = abs(vocm - vocm_end)
  meas tran tcross WHEN verr=2m FALL=LAST
  let t_cm_settle = tcross - 6u
  print cm_kick_v cm_resid_v t_cm_settle
  write
  quit
.endc
.param x_dut_xm1_w=2u
.param x_dut_xm1_l=0.5u
.param x_dut_xm3_w=2u
.param x_dut_xm3_l=0.5u
.param x_dut_xm5_w=66.8u
.param x_dut_xm5_l=0.5u
.param x_dut_xm7_w=4u
.param x_dut_xm7_l=0.5u
.param x_dut_xm6_w=2u
.param x_dut_xm6_l=0.5u
.param x_dut_xm8_w=2u
.param x_dut_xm8_l=0.5u
.param i_bias=50u
.param x_dut_r1_value=2k
.param x_dut_c1_value=1p
.param x_dut_r3_value=5k
.param x_dut_r5_value=5k
.param x_dut_c3_value=0.5p
.param x_dut_xm1_m=1
.param x_dut_xm2_m=1
.param x_dut_xm3_m=1
.param x_dut_xm4_m=1
.param x_dut_xm5_m=1
.param x_dut_xm9_m=1
.param x_dut_xm7_m=1
.param x_dut_xm10_m=1
.param x_dut_xm6_m=1
.param x_dut_xm8_m=1
* ---- GENERATED parameter ties (abstract/params.yaml groups/ratios) ----
* Each tied symbol is defined exactly once, by its line below; rewrite that
* .param to untie just that symbol (untying = shadowing, plan D-3).
.param x_dut_xm2_w = {x_dut_xm1_w}
.param x_dut_xm2_l = {x_dut_xm1_l}
.param x_dut_xm4_w = {x_dut_xm3_w}
.param x_dut_xm4_l = {x_dut_xm3_l}
.param x_dut_xm9_w = {x_dut_xm5_w}
.param x_dut_xm9_l = {x_dut_xm5_l}
.param x_dut_xm10_w = {x_dut_xm7_w}
.param x_dut_xm10_l = {x_dut_xm7_l}
.param x_dut_r2_value = {x_dut_r1_value}
.param x_dut_c2_value = {x_dut_c1_value}
.param x_dut_r4_value = {x_dut_r3_value}
.param x_dut_c4_value = {x_dut_c3_value}
.param x_dut_r6_value = {x_dut_r5_value}
.subckt amp_020_two_stage_miller_cmfb vinp vinn voutp voutn vdd vss
C1 mill_p voutp 'x_dut_c1_value'
C2 mill_n voutn 'x_dut_c2_value'
C3 cmz_p stg1p 'x_dut_c3_value'
C4 stg1n cmz_n 'x_dut_c4_value'
IBIAS vdd ref dc {i_bias}
R1 stg1p mill_p 'x_dut_r1_value'
R2 stg1n mill_n 'x_dut_r2_value'
R3 cmfb stg1p 'x_dut_r3_value'
R4 stg1n cmfb 'x_dut_r4_value'
R5 cmfb cmz_p 'x_dut_r5_value'
R6 cmz_n cmfb 'x_dut_r6_value'
XM1 stg1p vinp tail vss nfet_03v3 l=x_dut_xm1_l m=x_dut_xm1_m w=x_dut_xm1_w
XM10 voutn ref vss vss nfet_03v3 l=x_dut_xm10_l m=x_dut_xm10_m w=x_dut_xm10_w
XM2 stg1n vinn tail vss nfet_03v3 l=x_dut_xm2_l m=x_dut_xm2_m w=x_dut_xm2_w
XM3 stg1p cmfb vdd vdd pfet_03v3 l=x_dut_xm3_l m=x_dut_xm3_m w=x_dut_xm3_w
XM4 stg1n cmfb vdd vdd pfet_03v3 l=x_dut_xm4_l m=x_dut_xm4_m w=x_dut_xm4_w
XM5 voutp stg1p vdd vdd pfet_03v3 l=x_dut_xm5_l m=x_dut_xm5_m w=x_dut_xm5_w
XM6 ref ref vss vss nfet_03v3 l=x_dut_xm6_l m=x_dut_xm6_m w=x_dut_xm6_w
XM7 voutp ref vss vss nfet_03v3 l=x_dut_xm7_l m=x_dut_xm7_m w=x_dut_xm7_w
XM8 tail ref vss vss nfet_03v3 l=x_dut_xm8_l m=x_dut_xm8_m w=x_dut_xm8_w
XM9 voutn stg1n vdd vdd pfet_03v3 l=x_dut_xm9_l m=x_dut_xm9_m w=x_dut_xm9_w
.ends
.end
