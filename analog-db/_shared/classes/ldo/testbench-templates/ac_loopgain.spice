** AUTHORED TEMPLATE — ldo/ac_loopgain: TRUE regulation-loop gain, phase margin and gain margin
** by Middlebrook voltage injection at an in-DUT loop-break marker.
**
** Why this exists: an LDO's regulation loop is entirely INSIDE the subckt (vout -> error amp ->
** pass gate -> vout), so it cannot be broken from the [vdd, vout, vss] ports. The class's
** `loop_stability` bench measures closed-loop output-impedance peaking (zout_peak_db) as an
** honest proxy, but peaking is a symptom, not a margin — it cannot tell you HOW MUCH phase you
** have, and a critically-damped loop and a 30-degree loop can show similar peaks under different
** loads. This bench gives the real number.
**
** CONTRACT — the DUT must carry a loop-break marker. Put a 0 V source in the feedback path of the
** abstract netlist, between the driving node and the sensing input:
**     Vlp lp_brk vout dc 0        ; and feed the error amp's sense input from lp_brk, not vout
** A 0 V source with no AC spec is an ideal short, so it is INVISIBLE to every other analysis —
** dc_op / load_regulation / psrr / the transients all see the loop closed exactly as before. Only
** this bench turns it into a generator, via `alter`. This mirrors the amplifier class's `stb`
** bench, which uses the same 0 V VIPRB marker convention (there it becomes a Spectre iprobe).
**
** INJECTION POINT: it must sit where the source-side impedance is LOW and the load-side impedance
** is HIGH — vout (driven hard by the pass device and the output cap) into a MOSFET gate satisfies
** that by a wide margin, which is what makes the Middlebrook approximation valid here.
**
** MATH: the marker forces V(lp_brk) - V(vout) = 1 V AC. With G the transfer once around the rest
** of the loop (lp_brk -> error amp -> pass device -> vout):
**     V(vout) = G * V(lp_brk)  and  V(lp_brk) = V(vout) + 1
**  => V(lp_brk) = 1/(1-G),  V(vout) = G/(1-G),  so  T = v(vout)/v(lp_brk) = G  exactly.
** No small-signal approximation is involved in that algebra; the only assumption is the impedance
** condition above.
**
** VALIDATED 2026-07-20 against a known answer: applied to amp_033_ti_ldo_ref_selfbias closed as a
** unity buffer, this method returns 74.9178 dB / 12.083 MHz / 21.05 deg where the independent
** amplifier `ac_open_loop_biaswrap` bench returns 74.9177 dB / 12.112 MHz / 20.997 deg — agreement
** to the frequency-grid resolution. The phase normalisation (180 + phc - phc[0]) is the same
** sign-convention-agnostic form the amplifier open-loop templates use, so an inverting loop
** (phc[0] ~ 180 deg) and a non-inverting one both report the same physical margin.
**
** Bindings: DUT PORT_LINE VDD ILOAD COUT PPD FSTART FSTOP LP_PROBE PDK_INCLUDE.
** LP_PROBE is the marker's instance name inside the DUT (default `vlp`, see assemble.py).
${PDK_INCLUDE}

.param VDD=${VDD}

Vdd  vdd 0 dc {VDD}
Vss  vss 0 dc 0
Iload vout 0 dc ${ILOAD}
CLoad vout 0 ${COUT}

${PORT_LINE} ${DUT}

.control
  set filetype=ascii
  * turn the in-loop 0 V marker into a 1 V AC generator (it stays a plain short at DC, so the
  * operating point this measurement rides on is the regulated one)
  alter @v.xdut.${LP_PROBE}[acmag] = 1
  ac dec ${PPD} ${FSTART} ${FSTOP}
  let tloop = v(vout) / v(xdut.lp_brk)
  let tdb  = db(tloop)
  let tphc = cph(tloop)*180/3.14159265
  let tph  = 180 + tphc - tphc[0]
  meas ac loopgain_db FIND tdb AT=${FSTART}
  meas ac ugf_loop    WHEN tdb=0 FALL=1
  meas ac pm_loop     FIND tph WHEN tdb=0 FALL=1
  * gain margin: attenuation still in hand where the loop phase reaches 0 (i.e. 180 deg of shift
  * from the DC value). NaN when the phase never gets there — an honest "unconditionally stable"
  * rather than a fabricated number.
  meas ac gm_at_180 FIND tdb WHEN tph=0 FALL=1
  let gm_loop_db = 0 - gm_at_180
  print loopgain_db ugf_loop pm_loop gm_loop_db
  write
  quit
.endc
.end
