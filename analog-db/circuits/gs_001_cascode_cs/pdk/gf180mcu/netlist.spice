** GENERATED by `analog-db generate` — DO NOT EDIT. Source: abstract/netlist.spice → gf180mcu
* gs_001_cascode_cs (emitted by spicexplorer-circuitgraph)
XMNB1 nbias1 nbias1 vss vss nfet_03v3 l=x_dut_xmnb1_l m=x_dut_xmnb1_m w=x_dut_xmnb1_w
XMNB2 nbias2 nbias2 nbias1 vss nfet_03v3 l=x_dut_xmnb2_l m=x_dut_xmnb2_m w=x_dut_xmnb2_w
XMNCA vout nbias2 nint vss nfet_03v3 l=x_dut_xmnca_l m=x_dut_xmnca_m w=x_dut_xmnca_w
XMNIN nint vin vss vss nfet_03v3 l=x_dut_xmnin_l m=x_dut_xmnin_m w=x_dut_xmnin_w
XMPB1 pbias1 pbias1 vdd vdd pfet_03v3 l=x_dut_xmpb1_l m=x_dut_xmpb1_m w=x_dut_xmpb1_w
XMPB2 ibias ibias pbias1 vdd pfet_03v3 l=x_dut_xmpb2_l m=x_dut_xmpb2_m w=x_dut_xmpb2_w
XMPCA vout ibias pint vdd pfet_03v3 l=x_dut_xmpca_l m=x_dut_xmpca_m w=x_dut_xmpca_w
XMPLD pint pbias1 vdd vdd pfet_03v3 l=x_dut_xmpld_l m=x_dut_xmpld_m w=x_dut_xmpld_w
XMPNR nbias2 ibias vdd vdd pfet_03v3 l=x_dut_xmpnr_l m=x_dut_xmpnr_m w=x_dut_xmpnr_w
.end
