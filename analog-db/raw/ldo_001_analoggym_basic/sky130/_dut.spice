** GENERATED by `analog-db export-raw` — DO NOT EDIT.
** Standalone lowered DUT subckt for ldo_001_analoggym_basic on sky130 (sizing .param defaults + .subckt).
** Not a runnable deck on its own — include it under your own testbench:
**   .include _dut.spice
**   XDUT vdd vout vss ldo_001_analoggym_basic
** Source: pdk/sky130/netlist.spice (run `analog-db generate` to refresh).
*----------------------------------------------------------*
** params: 23 free + 0 frozen knobs (sizing.yaml) · 38 tied · 16 ratio-derived (abstract/params.yaml)
.param x_dut_xm0_w=5
.param x_dut_xm0_l=1
.param x_dut_xm0_m=3
.param x_dut_xm8_w=5.5
.param x_dut_xm8_l=4
.param x_dut_xm8_m=8
.param x_dut_xm10_w=8
.param x_dut_xm10_l=1
.param x_dut_xm10_m=7
.param x_dut_xm11_w=9
.param x_dut_xm11_l=0.15
.param x_dut_xm11_m=928
.param x_dut_xm14_w=1.5
.param x_dut_xm14_l=4
.param x_dut_xm14_m=10
.param x_dut_xm22_w=6
.param x_dut_xm22_l=2
.param x_dut_xm22_m=8
.param r_top=300k
.param r_bot=100k
.param c_comp=6.8p
.param vref_val=0.4
.param i_bias=1.5u
* ---- GENERATED parameter ties (abstract/params.yaml groups/ratios) ----
* Each tied symbol is defined exactly once, by its line below; rewrite that
* .param to untie just that symbol (untying = shadowing, plan D-3).
.param x_dut_xm1_w = {x_dut_xm0_w}
.param x_dut_xm2_w = {x_dut_xm0_w}
.param x_dut_xm3_w = {x_dut_xm0_w}
.param x_dut_xm4_w = {x_dut_xm0_w}
.param x_dut_xm7_w = {x_dut_xm0_w}
.param x_dut_xm24_w = {x_dut_xm0_w}
.param x_dut_xm5_w = {x_dut_xm0_w}
.param x_dut_xm6_w = {x_dut_xm0_w}
.param x_dut_xm1_l = {x_dut_xm0_l}
.param x_dut_xm2_l = {x_dut_xm0_l}
.param x_dut_xm3_l = {x_dut_xm0_l}
.param x_dut_xm4_l = {x_dut_xm0_l}
.param x_dut_xm7_l = {x_dut_xm0_l}
.param x_dut_xm24_l = {x_dut_xm0_l}
.param x_dut_xm5_l = {x_dut_xm0_l}
.param x_dut_xm6_l = {x_dut_xm0_l}
.param x_dut_xm9_w = {x_dut_xm8_w}
.param x_dut_xm9_l = {x_dut_xm8_l}
.param x_dut_xm9_m = {x_dut_xm8_m}
.param x_dut_xm12_w = {x_dut_xm14_w}
.param x_dut_xm13_w = {x_dut_xm14_w}
.param x_dut_xm15_w = {x_dut_xm14_w}
.param x_dut_xm16_w = {x_dut_xm14_w}
.param x_dut_xm17_w = {x_dut_xm14_w}
.param x_dut_xm18_w = {x_dut_xm14_w}
.param x_dut_xm19_w = {x_dut_xm14_w}
.param x_dut_xm20_w = {x_dut_xm14_w}
.param x_dut_xm12_l = {x_dut_xm14_l}
.param x_dut_xm13_l = {x_dut_xm14_l}
.param x_dut_xm15_l = {x_dut_xm14_l}
.param x_dut_xm16_l = {x_dut_xm14_l}
.param x_dut_xm17_l = {x_dut_xm14_l}
.param x_dut_xm18_l = {x_dut_xm14_l}
.param x_dut_xm19_l = {x_dut_xm14_l}
.param x_dut_xm20_l = {x_dut_xm14_l}
.param x_dut_xm21_w = {x_dut_xm22_w}
.param x_dut_xm21_l = {x_dut_xm22_l}
.param x_dut_xm21_m = {x_dut_xm22_m}
.param x_dut_xm1_m = {x_dut_xm0_m*1}
.param x_dut_xm2_m = {x_dut_xm0_m*1}
.param x_dut_xm3_m = {x_dut_xm0_m*1}
.param x_dut_xm4_m = {x_dut_xm0_m*2}
.param x_dut_xm7_m = {x_dut_xm0_m*1}
.param x_dut_xm24_m = {x_dut_xm0_m*1}
.param x_dut_xm5_m = {x_dut_xm0_m*1}
.param x_dut_xm6_m = {x_dut_xm0_m*1}
.param x_dut_xm12_m = {x_dut_xm14_m*4}
.param x_dut_xm13_m = {x_dut_xm14_m*4}
.param x_dut_xm15_m = {x_dut_xm14_m*4}
.param x_dut_xm16_m = {x_dut_xm14_m*4}
.param x_dut_xm17_m = {x_dut_xm14_m*4}
.param x_dut_xm18_m = {x_dut_xm14_m*4}
.param x_dut_xm19_m = {x_dut_xm14_m*8}
.param x_dut_xm20_m = {x_dut_xm14_m*8}
.subckt ldo_001_analoggym_basic vdd vout vss
C0 net106 vout 'c_comp'
IBIAS ib vss dc {i_bias}
R1 vout vfb 'r_top'
R2 vfb vss 'r_bot'
VREF vref vss dc {vref_val}
XM0 ib ib vdd vdd sky130_fd_pr__pfet_01v8 l=x_dut_xm0_l m=x_dut_xm0_m w=x_dut_xm0_w
XM1 vb4 ib vdd vdd sky130_fd_pr__pfet_01v8 l=x_dut_xm1_l m=x_dut_xm1_m w=x_dut_xm1_w
XM10 net12 net10 net1 net1 sky130_fd_pr__pfet_01v8 l=x_dut_xm10_l m=x_dut_xm10_m w=x_dut_xm10_w
XM11 vout net1 vdd vdd sky130_fd_pr__pfet_01v8 l=x_dut_xm11_l m=x_dut_xm11_m w=x_dut_xm11_w
XM12 vb4 vb3 net28 vss sky130_fd_pr__nfet_01v8 l=x_dut_xm12_l m=x_dut_xm12_m w=x_dut_xm12_w
XM13 dm_1 vb3 net31 vss sky130_fd_pr__nfet_01v8 l=x_dut_xm13_l m=x_dut_xm13_m w=x_dut_xm13_w
XM14 vb3 vb3 vss vss sky130_fd_pr__nfet_01v8 l=x_dut_xm14_l m=x_dut_xm14_m w=x_dut_xm14_w
XM15 voutn vb3 dm_2 vss sky130_fd_pr__nfet_01v8 l=x_dut_xm15_l m=x_dut_xm15_m w=x_dut_xm15_w
XM16 net10 vb3 net106 vss sky130_fd_pr__nfet_01v8 l=x_dut_xm16_l m=x_dut_xm16_m w=x_dut_xm16_w
XM17 net28 vb4 vss vss sky130_fd_pr__nfet_01v8 l=x_dut_xm17_l m=x_dut_xm17_m w=x_dut_xm17_w
XM18 net31 vb4 vss vss sky130_fd_pr__nfet_01v8 l=x_dut_xm18_l m=x_dut_xm18_m w=x_dut_xm18_w
XM19 dm_2 vb4 vss vss sky130_fd_pr__nfet_01v8 l=x_dut_xm19_l m=x_dut_xm19_m w=x_dut_xm19_w
XM2 dm_1 ib vdd vdd sky130_fd_pr__pfet_01v8 l=x_dut_xm2_l m=x_dut_xm2_m w=x_dut_xm2_w
XM20 net106 vb4 vss vss sky130_fd_pr__nfet_01v8 l=x_dut_xm20_l m=x_dut_xm20_m w=x_dut_xm20_w
XM21 net12 net7 vss vss sky130_fd_pr__nfet_01v8 l=x_dut_xm21_l m=x_dut_xm21_m w=x_dut_xm21_w
XM22 net7 net7 vss vss sky130_fd_pr__nfet_01v8 l=x_dut_xm22_l m=x_dut_xm22_m w=x_dut_xm22_w
XM24 net1 ib vdd vdd sky130_fd_pr__pfet_01v8 l=x_dut_xm24_l m=x_dut_xm24_m w=x_dut_xm24_w
XM3 vb3 ib vdd vdd sky130_fd_pr__pfet_01v8 l=x_dut_xm3_l m=x_dut_xm3_m w=x_dut_xm3_w
XM4 net20 ib vdd vdd sky130_fd_pr__pfet_01v8 l=x_dut_xm4_l m=x_dut_xm4_m w=x_dut_xm4_w
XM5 voutn voutn vdd vdd sky130_fd_pr__pfet_01v8 l=x_dut_xm5_l m=x_dut_xm5_m w=x_dut_xm5_w
XM6 net10 voutn vdd vdd sky130_fd_pr__pfet_01v8 l=x_dut_xm6_l m=x_dut_xm6_m w=x_dut_xm6_w
XM7 net7 ib vdd vdd sky130_fd_pr__pfet_01v8 l=x_dut_xm7_l m=x_dut_xm7_m w=x_dut_xm7_w
XM8 dm_2 vfb net20 net20 sky130_fd_pr__pfet_01v8 l=x_dut_xm8_l m=x_dut_xm8_m w=x_dut_xm8_w
XM9 net106 vref net20 net20 sky130_fd_pr__pfet_01v8 l=x_dut_xm9_l m=x_dut_xm9_m w=x_dut_xm9_w
.ends
