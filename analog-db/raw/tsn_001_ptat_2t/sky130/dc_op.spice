** GENERATED by `analog-db export-raw` — DO NOT EDIT.
** circuit=tsn_001_ptat_2t  class=temp_sensor  pdk=sky130  testbench=dc_op  corner=tt
** Self-contained deck: testbench + bound params + lowered DUT (.subckt tsn_001_ptat_2t).
** PDK corner libs resolve by BARE NAME on the image's ngspice sourcepath — run in a
** PDK-enabled env (the base image / api container), NOT a bare host:
**   docker run --rm -i spicexplorer-spice-base:local \
**     bash -lc 'd=$(mktemp -d) && cat > $d/c.spice && cd $d && ngspice -b c.spice' < raw/tsn_001_ptat_2t/sky130/dc_op.spice
*----------------------------------------------------------*
** params: 6 free + 0 frozen knobs (sizing.yaml) · 0 tied · 0 ratio-derived (abstract/params.yaml) · 1 testbench params
** AUTHORED TEMPLATE — temp_sensor/dc_op (plan D-4): DC operating point of a PTAT sensor core.
** Supply-only 3-terminal block (vdd vout vss); reports the DC output and the supply current
** (power). Bindings: DUT PORT_LINE VDD PDK_INCLUDE.
.lib sky130.lib.spice tt
.temp 27

.param VDD=1.2

Vdd  vdd 0 dc {VDD}
Vss  vss 0 dc 0

XDUT vdd vout vss tsn_001_ptat_2t

.control
  set filetype=ascii
  op
  let i_supply = abs(i(Vdd))
  let v_out = v(vout)
  print i_supply
  print v_out
  write
  quit
.endc
.param x_dut_xm0_w=8
.param x_dut_xm0_l=0.2
.param x_dut_xm0_m=8
.param x_dut_xm1_w=4
.param x_dut_xm1_l=1
.param x_dut_xm1_m=8
.subckt tsn_001_ptat_2t vdd vout vss
XM0 vdd vout vout vss sky130_fd_pr__nfet_01v8 l=x_dut_xm0_l m=x_dut_xm0_m w=x_dut_xm0_w
XM1 vout vout vss vss sky130_fd_pr__nfet_01v8 l=x_dut_xm1_l m=x_dut_xm1_m w=x_dut_xm1_w
.ends
.end
