** GENERATED by `analog-db export-raw` — DO NOT EDIT.
** circuit=amp_023_fer_fd2s  class=amplifier  pdk=sky130  testbench=psrr_vdd  corner=tt
** Self-contained deck: testbench + bound params + lowered DUT (.subckt amp_023_fer_fd2s).
** PDK corner libs resolve by BARE NAME on the image's ngspice sourcepath — run in a
** PDK-enabled env (the base image / api container), NOT a bare host:
**   docker run --rm -i spicexplorer-spice-base:local \
**     bash -lc 'd=$(mktemp -d) && cat > $d/c.spice && cd $d && ngspice -b c.spice' < raw/amp_023_fer_fd2s/sky130/psrr_vdd.spice
*----------------------------------------------------------*
** params: 20 free + 30 frozen knobs (sizing.yaml) · 44 tied · 0 ratio-derived (abstract/params.yaml) · 3 testbench params
** AUTHORED TEMPLATE — amplifier/psrr_vdd_diff: positive-supply rejection of a fully-
** differential (self-biased, voutp/voutn) DUT, in the same CM-pinned differential
** unity-feedback network stb_diff uses.
**
** CONFIGURATION (see stb_diff.spice for the full why). The differential loop is closed by two
** ideal VCVSs, fbn/fbp = VCM +/- (voutp-voutn)/2, feeding the inputs through quiet 0 V sources;
** the input CM is pinned at VCM and the DC operating point is the matched-inputs-at-VCM point
** of dc_op_diff/ac_open_loop_diff. No CM loop is closed by the bench — the output CM is left to
** the DUT's own CMFB; small-signal, so it works regardless of CMFB quality.
**
** STIMULUS + MATH (the exact FD analog of psrr_vdd.spice). The supply Vdd carries a 1 V AC
** ripple and every input is AC-quiet, so all AC at the output is supply feed-through. With
** A_vd = the supply -> differential-output gain and the loop holding vin_d = -vout_d:
**     vout_d = A_vd*vac + Add*vin_d  =>  vout_d = A_vd/(1+Add) * vac,
** the closed-loop (buffer-application) differential supply feed-through, so
** psrr_vdd_db = -20*log10|vout_d| (vac = 1), read at FSTART (the DC-band floor) — the same
** loop-suppressed figure the SE bench reports for the unity buffer.
**
** SOLVER-RESOLUTION CEILING (why the 1e-15 floor exists — same argument as cmrr_vcm_diff, in
** full there). On a perfectly symmetric netlist the supply disturbs both half-circuits
** identically, the TRUE A_vd of the deck is zero, and the solved vout_d is matrix round-off
** (~1e-16 of the ~1 V node signals). The `+ 1e-15` magnitude floor caps the reportable figure
** at 300 dB and keeps -db() finite; a psrr_vdd_db at or near 300 means "beyond what the solver
** can resolve on a symmetric netlist", NOT a physical rejection (real PSRR- and PSRR+ of FD
** silicon are mismatch-set). Treat anything above ~200 dB as unresolved-by-construction.
**
** psrr_cm_db — the SECONDARY, always-physical figure. The OUTPUT-CM response to the same
** ripple, vocm = (voutp+voutn)/2, psrr_cm_db = -db|vocm|: the supply rejection of the cell's
** CM path (CMFB loop included). It is finite even on a perfect netlist — supply ripple feeds
** the CM of both branches with the same sign, nothing cancels — so it is the number that
** actually discriminates between FD cells whose differential figure saturates the solver.
** (Not a canonical datasheet metric; it rides the scoreboard entry's analyses block.)
**
** DIFFERENTIAL-GAIN CORRECTION (downstream, scoreboard.record). psrr_cm_db here is the RAW CM
** supply residual -db|vocm|, NOT yet a rejection FIGURE. PSRR is (differential gain)/(supply
** gain), so the physical FD PSRR+ adds the differential open-loop gain back:
** psrr_cm_corr_db = dc_gain_db + psrr_cm_db (the SE unity-buffer psrr_vdd_db folds this in via
** its closed loop; the FD CM path does not, so the term is added when the scoreboard entry is
** assembled). psrr_cm_corr_db is the figure the paper prints.
**
** Bindings: DUT PORT_LINE VDD VCM CL FSTART FSTOP PPD PDK_INCLUDE.
.lib sky130.lib.spice tt
.temp 27

.param VDD=1.5
.param VCM=0.9
.param CL=10p

Vdd  vdd 0 dc {VDD} ac 1     ; 1 V supply-ripple stimulus
Vss  vss 0 dc 0
CLoadp voutp 0 {CL}
CLoadn voutn 0 {CL}

* differential unity feedback, CM pinned at VCM (see stb_diff.spice); inputs AC-quiet —
* isolate the supply path
Vcm  vcm 0 dc {VCM}
Efbn fbn vcm voutp voutn 0.5
Efbp fbp vcm voutp voutn -0.5
Vfbn vinn fbn dc 0
Vfbp vinp fbp dc 0

XDUT vinp vinn voutp voutn vdd vss amp_023_fer_fd2s

.control
  set filetype=ascii
  ac dec 101 100 1G
  let vodm = v(voutp) - v(voutn)
  let vocm = (v(voutp) + v(voutn))/2
  * 1e-15 magnitude floor: caps the figure at 300 dB = "beyond solver resolution" (see header);
  * also keeps -db() finite on a bit-symmetric netlist whose true response is exactly 0.
  let psrr   = -db(mag(vodm) + 1e-15)
  let psrrcm = -db(mag(vocm) + 1e-15)
  meas ac psrr_vdd_db FIND psrr   AT=100
  meas ac psrr_cm_db  FIND psrrcm AT=100
  write
  quit
.endc
.param x_dut_xmbd_w=4
.param x_dut_xmpd1_w=6
.param x_dut_xmpd2_w=1.5
.param x_dut_xmnd1_w=0.75
.param x_dut_xmi1_w=6
.param x_dut_xmsa_w=6
.param x_dut_xmca_w=6
.param x_dut_xmna_w=4
.param x_dut_xmka_w=3
.param x_dut_xm2a_w=8
.param x_dut_xmla_w=6
.param x_dut_xmepd_w=3
.param x_dut_xmncd_w=1.5
.param x_dut_xmbd_l=0.4
.param x_dut_xmi1_l=0.3
.param x_dut_xmca_l=0.2
.param x_dut_rza_value=1500
.param x_dut_cca_value=2e-12
.param x_dut_rca_value=2e5
.param x_dut_cma_value=150e-15
.param x_ibias_val=20e-6
.param x_vcmr_val=0.75
.param x_dut_xmbd_m=1
.param x_dut_xmb1_m=1
.param x_dut_xmpd1_m=1
.param x_dut_xmb2_m=1
.param x_dut_xmpd2_m=1
.param x_dut_xmpm1_m=1
.param x_dut_xmnd1_m=1
.param x_dut_xmt_m=2
.param x_dut_xmi1_m=2
.param x_dut_xmi2_m=2
.param x_dut_xmsa_m=2
.param x_dut_xmsb_m=2
.param x_dut_xmca_m=1
.param x_dut_xmcb_m=1
.param x_dut_xmna_m=1
.param x_dut_xmnb_m=1
.param x_dut_xmka_m=1
.param x_dut_xmkb_m=1
.param x_dut_xm2a_m=4
.param x_dut_xm2b_m=4
.param x_dut_xmla_m=6
.param x_dut_xmlb_m=6
.param x_dut_xmea1_m=1
.param x_dut_xmea2_m=1
.param x_dut_xmepd_m=1
.param x_dut_xmepm_m=2
.param x_dut_xmncd_m=1
.param x_dut_xmeat_m=1
* ---- GENERATED parameter ties (abstract/params.yaml groups/ratios) ----
* Each tied symbol is defined exactly once, by its line below; rewrite that
* .param to untie just that symbol (untying = shadowing, plan D-3).
.param x_dut_xmb1_l = {x_dut_xmbd_l}
.param x_dut_xmpd1_l = {x_dut_xmbd_l}
.param x_dut_xmb2_l = {x_dut_xmbd_l}
.param x_dut_xmpd2_l = {x_dut_xmbd_l}
.param x_dut_xmpm1_l = {x_dut_xmbd_l}
.param x_dut_xmnd1_l = {x_dut_xmbd_l}
.param x_dut_xmt_l = {x_dut_xmbd_l}
.param x_dut_xmsa_l = {x_dut_xmbd_l}
.param x_dut_xmsb_l = {x_dut_xmbd_l}
.param x_dut_xmka_l = {x_dut_xmbd_l}
.param x_dut_xmkb_l = {x_dut_xmbd_l}
.param x_dut_xmla_l = {x_dut_xmbd_l}
.param x_dut_xmlb_l = {x_dut_xmbd_l}
.param x_dut_xmepd_l = {x_dut_xmbd_l}
.param x_dut_xmepm_l = {x_dut_xmbd_l}
.param x_dut_xmncd_l = {x_dut_xmbd_l}
.param x_dut_xmeat_l = {x_dut_xmbd_l}
.param x_dut_xmb1_w = {x_dut_xmbd_w}
.param x_dut_xmb2_w = {x_dut_xmbd_w}
.param x_dut_xmt_w = {x_dut_xmbd_w}
.param x_dut_xmea1_w = {x_dut_xmbd_w}
.param x_dut_xmea2_w = {x_dut_xmbd_w}
.param x_dut_xmeat_w = {x_dut_xmbd_w}
.param x_dut_xmpm1_w = {x_dut_xmpd1_w}
.param x_dut_xmi2_l = {x_dut_xmi1_l}
.param x_dut_xm2a_l = {x_dut_xmi1_l}
.param x_dut_xm2b_l = {x_dut_xmi1_l}
.param x_dut_xmi2_w = {x_dut_xmi1_w}
.param x_dut_xmsb_w = {x_dut_xmsa_w}
.param x_dut_xmcb_l = {x_dut_xmca_l}
.param x_dut_xmna_l = {x_dut_xmca_l}
.param x_dut_xmnb_l = {x_dut_xmca_l}
.param x_dut_xmea1_l = {x_dut_xmca_l}
.param x_dut_xmea2_l = {x_dut_xmca_l}
.param x_dut_xmcb_w = {x_dut_xmca_w}
.param x_dut_xmnb_w = {x_dut_xmna_w}
.param x_dut_xmkb_w = {x_dut_xmka_w}
.param x_dut_xm2b_w = {x_dut_xm2a_w}
.param x_dut_xmlb_w = {x_dut_xmla_w}
.param x_dut_xmepm_w = {x_dut_xmepd_w}
.param x_dut_rzb_value = {x_dut_rza_value}
.param x_dut_ccb_value = {x_dut_cca_value}
.param x_dut_rcb_value = {x_dut_rca_value}
.param x_dut_cmb_value = {x_dut_cma_value}
.subckt amp_023_fer_fd2s vinp vinn voutp voutn vdd vss
CCA za voutp x_dut_cca_value
CCB zb voutn x_dut_ccb_value
CMA voutp vsen x_dut_cma_value
CMB voutn vsen x_dut_cmb_value
IB vdd ibias dc {x_ibias_val}
RCA voutp vsen x_dut_rca_value
RCB voutn vsen x_dut_rcb_value
RZA o1a za x_dut_rza_value
RZB o1b zb x_dut_rzb_value
VCR vcmr vss dc {x_vcmr_val}
XM2A voutp o1a vss vss sky130_fd_pr__nfet_01v8 l=x_dut_xm2a_l m=x_dut_xm2a_m w=x_dut_xm2a_w
XM2B voutn o1b vss vss sky130_fd_pr__nfet_01v8 l=x_dut_xm2b_l m=x_dut_xm2b_m w=x_dut_xm2b_w
XMB1 vbp ibias vss vss sky130_fd_pr__nfet_01v8 l=x_dut_xmb1_l m=x_dut_xmb1_m w=x_dut_xmb1_w
XMB2 vcp ibias vss vss sky130_fd_pr__nfet_01v8 l=x_dut_xmb2_l m=x_dut_xmb2_m w=x_dut_xmb2_w
XMBD ibias ibias vss vss sky130_fd_pr__nfet_01v8 l=x_dut_xmbd_l m=x_dut_xmbd_m w=x_dut_xmbd_w
XMCA o1a vcp fp vdd sky130_fd_pr__pfet_01v8 l=x_dut_xmca_l m=x_dut_xmca_m w=x_dut_xmca_w
XMCB o1b vcp fn vdd sky130_fd_pr__pfet_01v8 l=x_dut_xmcb_l m=x_dut_xmcb_m w=x_dut_xmcb_w
XMEA1 ead vcmr eatail vss sky130_fd_pr__nfet_01v8 l=x_dut_xmea1_l m=x_dut_xmea1_m w=x_dut_xmea1_w
XMEA2 vcmfb vsen eatail vss sky130_fd_pr__nfet_01v8 l=x_dut_xmea2_l m=x_dut_xmea2_m w=x_dut_xmea2_w
XMEAT eatail ibias vss vss sky130_fd_pr__nfet_01v8 l=x_dut_xmeat_l m=x_dut_xmeat_m w=x_dut_xmeat_w
XMEPD ead ead vdd vdd sky130_fd_pr__pfet_01v8 l=x_dut_xmepd_l m=x_dut_xmepd_m w=x_dut_xmepd_w
XMEPM vcmfb ead vdd vdd sky130_fd_pr__pfet_01v8 l=x_dut_xmepm_l m=x_dut_xmepm_m w=x_dut_xmepm_w
XMI1 fp vinp tail vss sky130_fd_pr__nfet_01v8 l=x_dut_xmi1_l m=x_dut_xmi1_m w=x_dut_xmi1_w
XMI2 fn vinn tail vss sky130_fd_pr__nfet_01v8 l=x_dut_xmi2_l m=x_dut_xmi2_m w=x_dut_xmi2_w
XMKA x1a vcmfb vss vss sky130_fd_pr__nfet_01v8 l=x_dut_xmka_l m=x_dut_xmka_m w=x_dut_xmka_w
XMKB x1b vcmfb vss vss sky130_fd_pr__nfet_01v8 l=x_dut_xmkb_l m=x_dut_xmkb_m w=x_dut_xmkb_w
XMLA voutp vbp vdd vdd sky130_fd_pr__pfet_01v8 l=x_dut_xmla_l m=x_dut_xmla_m w=x_dut_xmla_w
XMLB voutn vbp vdd vdd sky130_fd_pr__pfet_01v8 l=x_dut_xmlb_l m=x_dut_xmlb_m w=x_dut_xmlb_w
XMNA o1a vcn x1a vss sky130_fd_pr__nfet_01v8 l=x_dut_xmna_l m=x_dut_xmna_m w=x_dut_xmna_w
XMNB o1b vcn x1b vss sky130_fd_pr__nfet_01v8 l=x_dut_xmnb_l m=x_dut_xmnb_m w=x_dut_xmnb_w
XMNCD vcmfb vcmfb vss vss sky130_fd_pr__nfet_01v8 l=x_dut_xmncd_l m=x_dut_xmncd_m w=x_dut_xmncd_w
XMND1 vcn vcn vss vss sky130_fd_pr__nfet_01v8 l=x_dut_xmnd1_l m=x_dut_xmnd1_m w=x_dut_xmnd1_w
XMPD1 vbp vbp vdd vdd sky130_fd_pr__pfet_01v8 l=x_dut_xmpd1_l m=x_dut_xmpd1_m w=x_dut_xmpd1_w
XMPD2 vcp vcp vdd vdd sky130_fd_pr__pfet_01v8 l=x_dut_xmpd2_l m=x_dut_xmpd2_m w=x_dut_xmpd2_w
XMPM1 vcn vbp vdd vdd sky130_fd_pr__pfet_01v8 l=x_dut_xmpm1_l m=x_dut_xmpm1_m w=x_dut_xmpm1_w
XMSA fp vbp vdd vdd sky130_fd_pr__pfet_01v8 l=x_dut_xmsa_l m=x_dut_xmsa_m w=x_dut_xmsa_w
XMSB fn vbp vdd vdd sky130_fd_pr__pfet_01v8 l=x_dut_xmsb_l m=x_dut_xmsb_m w=x_dut_xmsb_w
XMT tail ibias vss vss sky130_fd_pr__nfet_01v8 l=x_dut_xmt_l m=x_dut_xmt_m w=x_dut_xmt_w
.ends
.end
