** GENERATED by `analog-db export-raw` — DO NOT EDIT.
** circuit=amp_011_peng_iac  class=amplifier  pdk=sky130  testbench=dc_op  corner=tt
** Self-contained deck: testbench + bound params + lowered DUT (.subckt amp_011_peng_iac).
** PDK corner libs resolve by BARE NAME on the image's ngspice sourcepath — run in a
** PDK-enabled env (the base image / api container), NOT a bare host:
**   docker run --rm -i spicexplorer-spice-base:local \
**     bash -lc 'd=$(mktemp -d) && cat > $d/c.spice && cd $d && ngspice -b c.spice' < raw/amp_011_peng_iac/sky130/dc_op.spice
*----------------------------------------------------------*
** params: 31 free + 0 frozen knobs (sizing.yaml) · 52 tied · 23 ratio-derived (abstract/params.yaml) · 2 testbench params
** AUTHORED TEMPLATE — amplifier/dc_op_biaswrap: DC operating point + supply current for DUTs on
** the AnalogGym self-bias convention (ports vss vdd vinn vinp vout; NO ibias port). Self-bias
** companion of the universal dc_op (M4 follow-up): a high-gain multistage OTA has no stable
** open-loop DC op point (it rails), so i_supply read open-loop is non-representative. Close the DC
** feedback exactly as ac_open_loop_biaswrap does — Lfb DC-shorts vout back to the inverting input
** (unity DC feedback), pinning the real quiescent operating point (vout ≈ VCM) — then read the
** supply current there. No Cin/Vac: this is a pure DC .op (an inductor is a DC short, so the loop
** is closed at DC).
**
** Assumes the AnalogGym canonical DUT port order (self-biased; NO ibias port):
**   .subckt <id> vss vdd vinn vinp vout
** Bindings: DUT VDD VCM PDK_INCLUDE.
** FIXED 2026-07-20: this template used to hardcode `X1 0 vdd opout_dc opin opout amp_011_peng_iac`,
** which silently assumed the AnalogGym port order [vss vdd vinn vinp vout] and MIS-WIRED any
** DUT declaring a different order (e.g. the amplifier-class [vdd vout vinp vinn vss] swaps
** vdd<->vss). It now uses XDUT vss vdd vinn vinp vout with canonical node names, exactly like the
** *_biaswrap_ibias sibling. For the AnalogGym DUTs this is a no-op: their vss port binds to
** node `vss`, which `Vss vss 0 dc 0` ties to ground just as the old direct-to-0 wiring did.
.lib sky130.lib.spice tt
.temp 27

.param VDD=1.8
.param VCM=240m

Vdd  vdd 0 dc {VDD}
Vss  vss 0 dc 0
Vcm  vinp 0 dc {VCM}          ; common-mode bias on the non-inverting input
Lfb  vout vinn 1T        ; 1 TH: DC short → unity feedback sets the quiescent op point

XDUT vss vdd vinn vinp vout amp_011_peng_iac
.control
  set filetype=ascii
  op
  let i_supply = abs(i(Vdd))
  * Input-referred systematic offset: the Lfb DC short makes this a unity-gain follower, so the
  * settled (vout - vinp) IS the input offset. Additive metric (2026-07-20) — existing measures
  * are untouched; a topology with a deliberately ratioed sink (e.g. the TI LDO error amp's
  * mirror_e) shows a large vos here, which also caps its ICMR tracking band.
  let vos = v(vout) - v(vinp)
  print i_supply vos
  write
  quit
.endc
.param CAPACITOR_0=0.5p
.param CAPACITOR_1=1.1p
.param CURRENT_0_BIAS=1.25u
.param x_dut_xm7_l=1
.param x_dut_xm65_m=4
.param x_dut_xm7_w=1
.param x_dut_xm10_l=0.350
.param x_dut_xm10_m=24
.param x_dut_xm10_w=1
.param x_dut_xm11_l=0.350
.param x_dut_xm11_m=9
.param x_dut_xm11_w=1
.param x_dut_xm19_l=0.350
.param x_dut_xm14_m=2
.param x_dut_xm19_w=1
.param x_dut_xm23_l=0.350
.param x_dut_xm23_m=3
.param x_dut_xm23_w=1
.param x_dut_xm66_l=1
.param x_dut_xm66_m=16
.param x_dut_xm66_w=1
.param x_dut_xm68_l=0.350
.param x_dut_xm68_m=3
.param x_dut_xm68_w=1
.param x_dut_xm70_l=0.350
.param x_dut_xm70_m=3
.param x_dut_xm70_w=1
.param x_dut_xm9_l=0.350
.param x_dut_xm9_m=3
.param x_dut_xm9_w=1
.param RESISTOR_0=750k
* ---- GENERATED parameter ties (abstract/params.yaml groups/ratios) ----
* Each tied symbol is defined exactly once, by its line below; rewrite that
* .param to untie just that symbol (untying = shadowing, plan D-3).
.param x_dut_xm57_w = {x_dut_xm7_w}
.param x_dut_xm65_w = {x_dut_xm7_w}
.param x_dut_xm6_w = {x_dut_xm7_w}
.param x_dut_xm5_w = {x_dut_xm7_w}
.param x_dut_xm4_w = {x_dut_xm7_w}
.param x_dut_xm62_w = {x_dut_xm7_w}
.param x_dut_xm3_w = {x_dut_xm7_w}
.param x_dut_xm61_w = {x_dut_xm7_w}
.param x_dut_xm2_w = {x_dut_xm7_w}
.param x_dut_xm58_w = {x_dut_xm7_w}
.param x_dut_xm1_w = {x_dut_xm7_w}
.param x_dut_xm0_w = {x_dut_xm7_w}
.param x_dut_xm57_l = {x_dut_xm7_l}
.param x_dut_xm65_l = {x_dut_xm7_l}
.param x_dut_xm6_l = {x_dut_xm7_l}
.param x_dut_xm5_l = {x_dut_xm7_l}
.param x_dut_xm4_l = {x_dut_xm7_l}
.param x_dut_xm62_l = {x_dut_xm7_l}
.param x_dut_xm3_l = {x_dut_xm7_l}
.param x_dut_xm61_l = {x_dut_xm7_l}
.param x_dut_xm2_l = {x_dut_xm7_l}
.param x_dut_xm58_l = {x_dut_xm7_l}
.param x_dut_xm1_l = {x_dut_xm7_l}
.param x_dut_xm0_l = {x_dut_xm7_l}
.param x_dut_xm8_w = {x_dut_xm9_w}
.param x_dut_xm8_l = {x_dut_xm9_l}
.param x_dut_xm8_m = {x_dut_xm9_m}
.param x_dut_xm69_w = {x_dut_xm70_w}
.param x_dut_xm69_l = {x_dut_xm70_l}
.param x_dut_xm69_m = {x_dut_xm70_m}
.param x_dut_xm15_w = {x_dut_xm19_w}
.param x_dut_xm20_w = {x_dut_xm19_w}
.param x_dut_xm16_w = {x_dut_xm19_w}
.param x_dut_xm17_w = {x_dut_xm19_w}
.param x_dut_xm67_w = {x_dut_xm19_w}
.param x_dut_xm14_w = {x_dut_xm19_w}
.param x_dut_xm12_w = {x_dut_xm19_w}
.param x_dut_xm18_w = {x_dut_xm19_w}
.param x_dut_xm13_w = {x_dut_xm19_w}
.param x_dut_xm64_w = {x_dut_xm19_w}
.param x_dut_xm63_w = {x_dut_xm19_w}
.param x_dut_xm15_l = {x_dut_xm19_l}
.param x_dut_xm20_l = {x_dut_xm19_l}
.param x_dut_xm16_l = {x_dut_xm19_l}
.param x_dut_xm17_l = {x_dut_xm19_l}
.param x_dut_xm67_l = {x_dut_xm19_l}
.param x_dut_xm14_l = {x_dut_xm19_l}
.param x_dut_xm12_l = {x_dut_xm19_l}
.param x_dut_xm18_l = {x_dut_xm19_l}
.param x_dut_xm13_l = {x_dut_xm19_l}
.param x_dut_xm64_l = {x_dut_xm19_l}
.param x_dut_xm63_l = {x_dut_xm19_l}
.param x_dut_xm7_m = {x_dut_xm65_m*16}
.param x_dut_xm57_m = {x_dut_xm65_m*4}
.param x_dut_xm6_m = {x_dut_xm65_m*4}
.param x_dut_xm5_m = {x_dut_xm65_m*4}
.param x_dut_xm4_m = {x_dut_xm65_m*8}
.param x_dut_xm62_m = {x_dut_xm65_m*4}
.param x_dut_xm3_m = {x_dut_xm65_m*4}
.param x_dut_xm61_m = {x_dut_xm65_m*4}
.param x_dut_xm2_m = {x_dut_xm65_m*4}
.param x_dut_xm58_m = {x_dut_xm65_m*4}
.param x_dut_xm1_m = {x_dut_xm65_m*4}
.param x_dut_xm0_m = {x_dut_xm65_m*4}
.param x_dut_xm19_m = {x_dut_xm14_m*8}
.param x_dut_xm15_m = {x_dut_xm14_m*8}
.param x_dut_xm20_m = {x_dut_xm14_m*8}
.param x_dut_xm16_m = {x_dut_xm14_m*8}
.param x_dut_xm17_m = {x_dut_xm14_m*4}
.param x_dut_xm67_m = {x_dut_xm14_m*32}
.param x_dut_xm12_m = {x_dut_xm14_m*4}
.param x_dut_xm18_m = {x_dut_xm14_m*4}
.param x_dut_xm13_m = {x_dut_xm14_m*4}
.param x_dut_xm64_m = {x_dut_xm14_m*4}
.param x_dut_xm63_m = {x_dut_xm14_m*4}
.subckt amp_011_peng_iac vss vdd vinn vinp vout
C0 VOUTP VOUT 'CAPACITOR_0'
C1 net10 net4 'CAPACITOR_1'
I0 VB1 vss 'CURRENT_0_BIAS'
R0 net4 vss 'RESISTOR_0'
XM0 net2 VB1 vdd vdd sky130_fd_pr__pfet_01v8 l=x_dut_xm0_l m=x_dut_xm0_m w=x_dut_xm0_w
XM1 net3 VB1 vdd vdd sky130_fd_pr__pfet_01v8 l=x_dut_xm1_l m=x_dut_xm1_m w=x_dut_xm1_w
XM10 net043 VOUTP vdd vdd sky130_fd_pr__pfet_01v8 l=x_dut_xm10_l m=x_dut_xm10_m w=x_dut_xm10_w
XM11 VOUT VOUTP vdd vdd sky130_fd_pr__pfet_01v8 l=x_dut_xm11_l m=x_dut_xm11_m w=x_dut_xm11_w
XM12 VB4 VB3 net54 vss sky130_fd_pr__nfet_01v8 l=x_dut_xm12_l m=x_dut_xm12_m w=x_dut_xm12_w
XM13 net7 VB3 net56 vss sky130_fd_pr__nfet_01v8 l=x_dut_xm13_l m=x_dut_xm13_m w=x_dut_xm13_w
XM14 VB3 VB3 vss vss sky130_fd_pr__nfet_01v8 l=x_dut_xm14_l m=x_dut_xm14_m w=x_dut_xm14_w
XM15 VOUTN VB3 DM_2 vss sky130_fd_pr__nfet_01v8 l=x_dut_xm15_l m=x_dut_xm15_m w=x_dut_xm15_w
XM16 VOUTP VB3 net063 vss sky130_fd_pr__nfet_01v8 l=x_dut_xm16_l m=x_dut_xm16_m w=x_dut_xm16_w
XM17 net54 VB4 vss vss sky130_fd_pr__nfet_01v8 l=x_dut_xm17_l m=x_dut_xm17_m w=x_dut_xm17_w
XM18 net56 VB4 vss vss sky130_fd_pr__nfet_01v8 l=x_dut_xm18_l m=x_dut_xm18_m w=x_dut_xm18_w
XM19 DM_2 VB4 vss vss sky130_fd_pr__nfet_01v8 l=x_dut_xm19_l m=x_dut_xm19_m w=x_dut_xm19_w
XM2 net6 VB1 vdd vdd sky130_fd_pr__pfet_01v8 l=x_dut_xm2_l m=x_dut_xm2_m w=x_dut_xm2_w
XM20 net063 VB4 vss vss sky130_fd_pr__nfet_01v8 l=x_dut_xm20_l m=x_dut_xm20_m w=x_dut_xm20_w
XM23 VOUT net10 vss vss sky130_fd_pr__nfet_01v8 l=x_dut_xm23_l m=x_dut_xm23_m w=x_dut_xm23_w
XM3 net8 VB1 vdd vdd sky130_fd_pr__pfet_01v8 l=x_dut_xm3_l m=x_dut_xm3_m w=x_dut_xm3_w
XM4 net31 VB1 vdd vdd sky130_fd_pr__pfet_01v8 l=x_dut_xm4_l m=x_dut_xm4_m w=x_dut_xm4_w
XM5 VOUTN VOUTN vdd vdd sky130_fd_pr__pfet_01v8 l=x_dut_xm5_l m=x_dut_xm5_m w=x_dut_xm5_w
XM57 VB1 VB2 net2 vdd sky130_fd_pr__pfet_01v8 l=x_dut_xm57_l m=x_dut_xm57_m w=x_dut_xm57_w
XM58 VB4 VB2 net3 vdd sky130_fd_pr__pfet_01v8 l=x_dut_xm58_l m=x_dut_xm58_m w=x_dut_xm58_w
XM6 VOUTP VOUTN vdd vdd sky130_fd_pr__pfet_01v8 l=x_dut_xm6_l m=x_dut_xm6_m w=x_dut_xm6_w
XM61 net7 VB2 net6 vdd sky130_fd_pr__pfet_01v8 l=x_dut_xm61_l m=x_dut_xm61_m w=x_dut_xm61_w
XM62 VB3 VB2 net8 vdd sky130_fd_pr__pfet_01v8 l=x_dut_xm62_l m=x_dut_xm62_m w=x_dut_xm62_w
XM63 VB2 VB3 net9 vss sky130_fd_pr__nfet_01v8 l=x_dut_xm63_l m=x_dut_xm63_m w=x_dut_xm63_w
XM64 net9 VB4 vss vss sky130_fd_pr__nfet_01v8 l=x_dut_xm64_l m=x_dut_xm64_m w=x_dut_xm64_w
XM65 VB2 VB2 vdd vdd sky130_fd_pr__pfet_01v8 l=x_dut_xm65_l m=x_dut_xm65_m w=x_dut_xm65_w
XM66 net10 VB2 net049 vdd sky130_fd_pr__pfet_01v8 l=x_dut_xm66_l m=x_dut_xm66_m w=x_dut_xm66_w
XM67 net043 VB3 net1 vss sky130_fd_pr__nfet_01v8 l=x_dut_xm67_l m=x_dut_xm67_m w=x_dut_xm67_w
XM68 net1 VB4 vss vss sky130_fd_pr__nfet_01v8 l=x_dut_xm68_l m=x_dut_xm68_m w=x_dut_xm68_w
XM69 net10 net043 vss vss sky130_fd_pr__nfet_01v8 l=x_dut_xm69_l m=x_dut_xm69_m w=x_dut_xm69_w
XM7 net049 VB1 vdd vdd sky130_fd_pr__pfet_01v8 l=x_dut_xm7_l m=x_dut_xm7_m w=x_dut_xm7_w
XM70 net1 net043 vss vss sky130_fd_pr__nfet_01v8 l=x_dut_xm70_l m=x_dut_xm70_m w=x_dut_xm70_w
XM8 DM_2 VINN net31 net31 sky130_fd_pr__pfet_01v8 l=x_dut_xm8_l m=x_dut_xm8_m w=x_dut_xm8_w
XM9 net063 VINP net31 net31 sky130_fd_pr__pfet_01v8 l=x_dut_xm9_l m=x_dut_xm9_m w=x_dut_xm9_w
.ends
.end
