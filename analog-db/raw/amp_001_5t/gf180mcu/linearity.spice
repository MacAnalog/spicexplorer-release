** GENERATED by `analog-db export-raw` — DO NOT EDIT.
** circuit=amp_001_5t  class=amplifier  pdk=gf180mcu  testbench=linearity  corner=tt
** Self-contained deck: testbench + bound params + lowered DUT (.subckt amp_001_5t).
** PDK corner libs resolve by BARE NAME on the image's ngspice sourcepath — run in a
** PDK-enabled env (the base image / api container), NOT a bare host:
**   docker run --rm -i spicexplorer-spice-base:local \
**     bash -lc 'd=$(mktemp -d) && cat > $d/c.spice && cd $d && ngspice -b c.spice' < raw/amp_001_5t/gf180mcu/linearity.spice
*----------------------------------------------------------*
** params: 8 free + 4 frozen knobs (sizing.yaml) · 6 tied · 0 ratio-derived (abstract/params.yaml) · 4 testbench params
** AUTHORED TEMPLATE — amplifier/linearity (plan D-4; the cascode 5th analysis, distilled).
** SCAFFOLD: input common-mode range (ICMR) via a buffer-connected DC sweep — the input
** range over which the follower tracks within VTRACK. The legacy cascode TB additionally
** gated on the tail-current plateau via an internal ammeter (v.xota.vmeas1#branch), which
** depends on legacy-DUT internals; this distilled form is DUT-agnostic. Bind with
** `enabled: false` until per-circuit thresholds are reviewed.
** Bindings: DUT PORT_LINE VDD VCM IBIAS CL VTRACK VSWEEP_STEP SLOPE_TOL PDK_INCLUDE.
.include design.ngspice
.lib sm141064.ngspice noise_corner
.lib sm141064.ngspice nfet_03v3_t
.lib sm141064.ngspice pfet_03v3_t
.lib sm141064.ngspice fets_mm
.temp 27

.param VDD=1.5
.param VCM=0.8
.param IBIAS=20u
.param CL=10p

Vdd  vdd 0 dc {VDD}
Vss  vss 0 dc 0
Ibias vdd ibias dc {IBIAS}
CLoad vout 0 {CL}

* buffer-connected: vinn shorted to vout; sweep the common-mode input
Vinp vinp 0 dc {VCM}
Vfb  vinn vout dc 0

XDUT vdd vout vinp vinn ibias vss amp_001_5t

.control
  set filetype=ascii
  dc Vinp 0 1.5 0.005
  let verr = abs(v(vout) - v(vinp))
  * ICMR = widest CONTIGUOUS run of points that both track in absolute terms
  * (|verr| <= VTRACK) and are ACTIVE (dvout/dvin ~ 1). This mirrors the platform registry's
  * `{meas: icmr_range}` (spicexplorer_core waveforms.icmr_band) exactly, so the analog-db
  * run/verify lane and the optimizer lane report the same number.
  *
  * REWRITTEN 2026-07-20. The previous form was `meas dc ... WHEN verr=VTRACK CROSS=1/LAST`,
  * which was wrong two ways. (1) CROSS=1 finds the band EXIT on a DUT that already tracks at
  * vin=0, so the pair returned the complement of the real band — it read amp_022 as 0.105 V
  * against a true 1.400 V. (2) More fundamentally, an absolute-error test ALONE cannot tell
  * "the follower is tracking" from "both ends sit near the same rail": where the input pair
  * is cut off vout is pinned at a rail, and if vin is near that rail too then verr is small
  * by coincidence. That reported a 3.23 V band on a 3.3 V supply for amp_033. The slope test
  * rejects those dead points because a railed output has dvout/dvin ~ 0.
  let vsw = v(vinp)
  let dvout = deriv(v(vout))
  let dvin  = deriv(vsw)
  let slope = dvout / dvin
  let intrack = (verr <= 20m) & (abs(slope - 1) <= 0.1)
  let npts = length(intrack)
  let k = 0
  let best = 0
  let bstart = 0
  let bend = 0
  let cstart = 0
  let inband = 0
  while k < npts
    if intrack[k] > 0.5
      if inband < 0.5
        let cstart = vsw[k]
        let inband = 1
      end
      if (vsw[k] - cstart) > best
        let best = vsw[k] - cstart
        let bstart = cstart
        let bend = vsw[k]
      end
    else
      let inband = 0
    end
    let k = k + 1
  end
  let icmr_min = bstart
  let icmr_max = bend
  let icmr_range = best
  print icmr_min icmr_max icmr_range
  write
  quit
.endc
.param x_dut_xm1_w=0.5u
.param x_dut_xm1_l=5u
.param x_dut_xm3_w=1.5u
.param x_dut_xm3_l=5u
.param x_dut_xm5_w=2u
.param x_dut_xm5_l=5u
.param x_dut_xm6_w=2u
.param x_dut_xm6_l=5u
.param x_dut_xm1_m=1
.param x_dut_xm3_m=1
.param x_dut_xm5_m=1
.param x_dut_xm6_m=1
* ---- GENERATED parameter ties (abstract/params.yaml groups/ratios) ----
* Each tied symbol is defined exactly once, by its line below; rewrite that
* .param to untie just that symbol (untying = shadowing, plan D-3).
.param x_dut_xm2_w = {x_dut_xm1_w}
.param x_dut_xm2_l = {x_dut_xm1_l}
.param x_dut_xm2_m = {x_dut_xm1_m}
.param x_dut_xm4_w = {x_dut_xm3_w}
.param x_dut_xm4_l = {x_dut_xm3_l}
.param x_dut_xm4_m = {x_dut_xm3_m}
.subckt amp_001_5t vdd vout vinp vinn ibias vss
XM1 outm vinp tail vss nfet_03v3 l=x_dut_xm1_l m=x_dut_xm1_m w=x_dut_xm1_w
XM2 vout vinn tail vss nfet_03v3 l=x_dut_xm2_l m=x_dut_xm2_m w=x_dut_xm2_w
XM3 outm outm vdd vdd pfet_03v3 l=x_dut_xm3_l m=x_dut_xm3_m w=x_dut_xm3_w
XM4 vout outm vdd vdd pfet_03v3 l=x_dut_xm4_l m=x_dut_xm4_m w=x_dut_xm4_w
XM5 tail ibias vss vss nfet_03v3 l=x_dut_xm5_l m=x_dut_xm5_m w=x_dut_xm5_w
XM6 ibias ibias vss vss nfet_03v3 l=x_dut_xm6_l m=x_dut_xm6_m w=x_dut_xm6_w
.ends
.end
