** GENERATED by `analog-db generate` — DO NOT EDIT. Source: abstract/netlist.spice → ihp-sg13g2
* vref_001_vgs (emitted by spicexplorer-circuitgraph)
XM0 vdd vref vref vss sg13_lv_nmos l=x_dut_xm0_l m=x_dut_xm0_m w=x_dut_xm0_w
XM1 vref vref vss vss sg13_hv_nmos l=x_dut_xm1_l m=x_dut_xm1_m w=x_dut_xm1_w
.end
