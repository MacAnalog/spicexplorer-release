* TB[msb] bias point (ramp and hold)
Vcc vcc 0 PWL(0 0 8n 4)
Vcasc vcasc 0 PWL(0 0 8n 3.25)
Vcmb vcmb 0 PWL(0 0 8n 1.9)
Vbias bias 0 PWL(0 0 8n 16)
XDUT inp inn outp outn vcc vcasc vcmb bias pam4drv_msb
Rlp outp vcc 50
Rln outn vcc 50
Vsinp sinp 0 PWL(0 0 8n 1.9)
Vsinn sinn 0 PWL(0 0 8n 1.9)
Rsinp sinp inp 50
Rsinn sinn inn 50
.include ../dut/dut_msb.spice
.lib "cornerHBT.lib" hbt_typ
.options gmin=1e-12 reltol=1e-3
.control
tran 0.0233333n 14n uic
wrdata bias.csv v(outp) v(xdut.c1M0) v(xdut.e1M0) v(xdut.tmsb0) i(Vcc)
.endc
.GLOBAL GND
.end
