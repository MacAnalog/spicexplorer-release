** GENERATED by `analog-db export-raw` — DO NOT EDIT.
** circuit=ldo_002_analoggym_folded_cascode  class=ldo  pdk=ihp-sg13g2  testbench=noise  corner=tt
** Self-contained deck: testbench + bound params + lowered DUT (.subckt ldo_002_analoggym_folded_cascode).
** PDK corner libs resolve by BARE NAME on the image's ngspice sourcepath — run in a
** PDK-enabled env (the base image / api container), NOT a bare host:
**   docker run --rm -i spicexplorer-spice-base:local \
**     bash -lc 'd=$(mktemp -d) && cat > $d/c.spice && cd $d && ngspice -b c.spice' < raw/ldo_002_analoggym_folded_cascode/ihp-sg13g2/noise.spice
*----------------------------------------------------------*
** params: 19 free + 0 frozen knobs (sizing.yaml) · 8 tied · 0 ratio-derived (abstract/params.yaml) · 1 testbench params
** AUTHORED TEMPLATE — ldo/noise: closed-loop output noise, integrated over a band.
** Methodology from the LDO literature benches vendored at circuits/ldo_004_basic_pmos/reference/
** ltspice/Noise_6p38..42.asc (`.noise v(vout)` + integrated output noise). ngspice's `.noise`
** needs an independent source as its "input"; the supply Vdd serves (the DUT's reference is
** internal to the 3-port subckt), so only the OUTPUT-referred noise is meaningful here:
** vn_out_rms = sqrt(onoise_total) over FSTART..FSTOP.
** Bindings: DUT PORT_LINE VDD ILOAD COUT FSTART FSTOP PPD PDK_INCLUDE.
.lib cornerMOShv.lib mos_tt
.lib cornerRES.lib res_typ
.temp 27

.param VDD=2.0

Vdd  vdd 0 dc {VDD} ac 1
Vss  vss 0 dc 0
Iload vout 0 dc 10m
CLoad vout 0 50p

XDUT vdd vout vss ldo_002_analoggym_folded_cascode

.control
  set filetype=ascii
  noise v(vout) Vdd dec 10 10 10meg
  let vn_out_rms = sqrt(onoise_total)
  print onoise_total vn_out_rms
  write
  quit
.endc
.param x_dut_xm1_w=20u
.param x_dut_xm1_l=1u
.param x_dut_xm3_w=30u
.param x_dut_xm3_l=0.5u
.param x_dut_xm5_w=10u
.param x_dut_xm5_l=0.5u
.param x_dut_xm7_w=20u
.param x_dut_xm7_l=2u
.param x_dut_xm9_w=30u
.param x_dut_xm9_l=0.5u
.param x_dut_xmp_w=10u
.param x_dut_xmp_l=0.5u
.param x_dut_xmp_m=250
.param r_z=3k
.param c_comp=2p
.param vref_val=1.8
.param vb1_val=1.0
.param vb2_val=0.025
.param r_bleed=100k
* ---- GENERATED parameter ties (abstract/params.yaml groups/ratios) ----
* Each tied symbol is defined exactly once, by its line below; rewrite that
* .param to untie just that symbol (untying = shadowing, plan D-3).
.param x_dut_xm2_w = {x_dut_xm1_w}
.param x_dut_xm2_l = {x_dut_xm1_l}
.param x_dut_xm4_w = {x_dut_xm3_w}
.param x_dut_xm4_l = {x_dut_xm3_l}
.param x_dut_xm6_w = {x_dut_xm5_w}
.param x_dut_xm6_l = {x_dut_xm5_l}
.param x_dut_xm8_w = {x_dut_xm7_w}
.param x_dut_xm8_l = {x_dut_xm7_l}
.subckt ldo_002_analoggym_folded_cascode vdd vout vss
CC ncz vout 'c_comp'
RZ ncz ngate 'r_z'
R_BLEED vout vss 'r_bleed'
VB1 vb1 vss dc {vb1_val}
VB2 vb2 vss dc {vb2_val}
VREF vref vss dc {vref_val}
XM1 n2 vout n4 vss sg13_hv_nmos l=x_dut_xm1_l w=x_dut_xm1_w
XM2 n3 vref n4 vss sg13_hv_nmos l=x_dut_xm2_l w=x_dut_xm2_w
XM3 n2 nmir vdd vdd sg13_hv_pmos l=x_dut_xm3_l w=x_dut_xm3_w
XM4 n3 nmir vdd vdd sg13_hv_pmos l=x_dut_xm4_l w=x_dut_xm4_w
XM5 nmir vb2 n2 vdd sg13_hv_pmos l=x_dut_xm5_l w=x_dut_xm5_w
XM6 ngate vb2 n3 vdd sg13_hv_pmos l=x_dut_xm6_l w=x_dut_xm6_w
XM7 nmir vb1 vss vss sg13_hv_nmos l=x_dut_xm7_l w=x_dut_xm7_w
XM8 ngate vb1 vss vss sg13_hv_nmos l=x_dut_xm8_l w=x_dut_xm8_w
XM9 n4 vb1 vss vss sg13_hv_nmos l=x_dut_xm9_l w=x_dut_xm9_w
XMP vout ngate vdd vdd sg13_hv_pmos l=x_dut_xmp_l m=x_dut_xmp_m w=x_dut_xmp_w
.ends
.end
