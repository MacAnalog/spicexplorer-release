** GENERATED by `analog-db generate` — DO NOT EDIT. Source: abstract/netlist.spice → ihp-sg13g2
* ldo_007_pmos (emitted by spicexplorer-circuitgraph)
CC ncz vout 'c_comp'
CFF vout fb 'c_ff'
IBIAS vdd ebias dc {i_tail}
R1 vout fb 'r_top'
R2 fb vss 'r_bot'
RZ egate ncz 'r_z'
VREF vref vss dc {vref_val}
XM1 noutm fb etail vss sg13_lv_nmos l=x_dut_xm1_l w=x_dut_xm1_w
XM2 egate vref etail vss sg13_lv_nmos l=x_dut_xm2_l w=x_dut_xm2_w
XM3 noutm noutm vdd vdd sg13_lv_pmos l=x_dut_xm3_l w=x_dut_xm3_w
XM4 egate noutm vdd vdd sg13_lv_pmos l=x_dut_xm4_l w=x_dut_xm4_w
XM5 etail ebias vss vss sg13_lv_nmos l=x_dut_xm5_l w=x_dut_xm5_w
XM6 ebias ebias vss vss sg13_lv_nmos l=x_dut_xm6_l w=x_dut_xm6_w
XMP vout egate vdd vdd sg13_lv_pmos l=x_dut_xmp_l m=x_dut_xmp_m w=x_dut_xmp_w
.end
