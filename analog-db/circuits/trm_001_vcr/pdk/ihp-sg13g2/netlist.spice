** GENERATED by `analog-db generate` — DO NOT EDIT. Source: abstract/netlist.spice → ihp-sg13g2
* trm_001_vcr (emitted by spicexplorer-circuitgraph)
R0 vdd vout x_dut_r0_value
XM0 vout vcode vss vss sg13_lv_nmos l=x_dut_xm0_l m=x_dut_xm0_m w=x_dut_xm0_w
.end
