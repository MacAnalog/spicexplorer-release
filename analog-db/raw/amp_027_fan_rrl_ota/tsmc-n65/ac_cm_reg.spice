** GENERATED by `analog-db export-raw` — DO NOT EDIT.
** circuit=amp_027_fan_rrl_ota  class=amplifier  pdk=tsmc-n65  testbench=ac_cm_reg  corner=tt
** Self-contained deck: testbench + bound params + lowered DUT (.subckt amp_027_fan_rrl_ota).
** PDK corner libs resolve by BARE NAME on the image's ngspice sourcepath — run in a
** PDK-enabled env (the base image / api container), NOT a bare host:
**   docker run --rm -i spicexplorer-spice-base:local \
**     bash -lc 'd=$(mktemp -d) && cat > $d/c.spice && cd $d && ngspice -b c.spice' < raw/amp_027_fan_rrl_ota/tsmc-n65/ac_cm_reg.spice
*----------------------------------------------------------*
** params: 20 free + 9 frozen knobs (sizing.yaml) · 23 tied · 0 ratio-derived (abstract/params.yaml) · 3 testbench params
** AUTHORED TEMPLATE — amplifier/ac_cm_reg (CM-loop health, frequency domain).
** Closed-loop COMMON-MODE output impedance: a unit AC common-mode current (0.5 A per
** side) is injected into both outputs; vocm/(1 A) = |Zcm(f)|. The CM feedback loop
** suppresses Zcm in-band, so:
**   zcm_lf_ohm     low-frequency Zcm — the CM stiffness the servo achieves
**   zcm_peak_ohm   the sweep maximum
**   cm_peaking_db  20*log10(peak/lf) — impedance peaking; a large value flags an
**                  underdamped CM loop (the external signature of poor CM phase margin)
** HONESTY NOTE: the internal CM loop gain/phase (T_cm, PM_cm) cannot be probed from a
** bench without breaking the loop inside the DUT — that is a composition-time
** measurement (insert a VIPRB/stb probe in the CMFB path of a composed variant). This
** bench measures the closed-loop observables that T_cm determines.
**
** Assumes a self-biased, differential-output DUT with a CM control loop:
**   .subckt <id> vinp vinn voutp voutn vdd vss
** Required bindings: DUT PORT_LINE VDD VCM CL FSTART FSTOP PPD PDK_INCLUDE.
.lib tsmc_n65_models.scs tt
.temp 27

.param VDD=1.2
.param VCM=0.6
.param CL=10p

Vdd  vdd 0 dc {VDD}
Vss  vss 0 dc 0
CLoadp voutp 0 {CL}
CLoadn voutn 0 {CL}
Vcm  vcm 0 dc {VCM}
Vinp vinp vcm dc 0
Vinn vinn vcm dc 0
* unit common-mode current injection (0.5 A AC per side -> 1 A total CM)
Icmp 0 voutp dc 0 ac 0.5
Icmn 0 voutn dc 0 ac 0.5

XDUT vinp vinn voutp voutn vdd vss amp_027_fan_rrl_ota

.control
  set filetype=ascii
  ac dec 41 100 1G
  let zcm = mag((v(voutp)+v(voutn))/2)
  meas ac zcm_lf_ohm FIND zcm AT=100
  meas ac zcm_pk MAX zcm
  * MAX meas lines carry an `at=` suffix the result parser skips - re-print clean
  let zcm_peak_ohm = zcm_pk
  let cm_peaking_db = 20*log10(zcm_pk/zcm_lf_ohm)
  print zcm_peak_ohm cm_peaking_db
  write
  quit
.endc
.param x_dut_xm1_w=13.551u
.param x_dut_xm1_l=1u
.param x_dut_xm2_w=13.8u
.param x_dut_xm2_l=0.5u
.param x_dut_xm4_w=6.775u
.param x_dut_xm5_w=1.578u
.param x_dut_xm5_l=0.5u
.param x_dut_xm6_w=1.578u
.param x_dut_xm6_l=0.5u
.param x_dut_xm9_w=4.031u
.param x_dut_xm9_l=0.3u
.param x_dut_xm11_w=1.022u
.param x_dut_xm11_l=0.3u
.param x_dut_xm13_w=0.666u
.param x_dut_xm15_w=0.333u
.param x_dut_xm15_l=0.5u
.param vb1=0.292504
.param vb2=0.612061
.param vb3=0.796166
.param vb4=0.5
.param x_dut_xm1_m=1
.param x_dut_xm2_m=1
.param x_dut_xm4_m=1
.param x_dut_xm5_m=1
.param x_dut_xm6_m=1
.param x_dut_xm9_m=1
.param x_dut_xm11_m=1
.param x_dut_xm13_m=1
.param x_dut_xm15_m=1
* ---- GENERATED parameter ties (abstract/params.yaml groups/ratios) ----
* Each tied symbol is defined exactly once, by its line below; rewrite that
* .param to untie just that symbol (untying = shadowing, plan D-3).
.param x_dut_xm13_l = {x_dut_xm15_l}
.param x_dut_xm14_l = {x_dut_xm15_l}
.param x_dut_xm3_w = {x_dut_xm2_w}
.param x_dut_xm3_l = {x_dut_xm2_l}
.param x_dut_xm3_m = {x_dut_xm2_m}
.param x_dut_xm10_w = {x_dut_xm9_w}
.param x_dut_xm10_l = {x_dut_xm9_l}
.param x_dut_xm10_m = {x_dut_xm9_m}
.param x_dut_xm12_w = {x_dut_xm11_w}
.param x_dut_xm12_l = {x_dut_xm11_l}
.param x_dut_xm12_m = {x_dut_xm11_m}
.param x_dut_xm14_w = {x_dut_xm13_w}
.param x_dut_xm14_m = {x_dut_xm13_m}
.param x_dut_xm7_w = {x_dut_xm5_w}
.param x_dut_xm7_l = {x_dut_xm5_l}
.param x_dut_xm7_m = {x_dut_xm5_m}
.param x_dut_xm8_w = {x_dut_xm6_w}
.param x_dut_xm8_l = {x_dut_xm6_l}
.param x_dut_xm8_m = {x_dut_xm6_m}
.param x_dut_xm16_w = {x_dut_xm15_w}
.param x_dut_xm16_l = {x_dut_xm15_l}
.param x_dut_xm16_m = {x_dut_xm15_m}
.param x_dut_xm4_l = {x_dut_xm1_l}
.subckt amp_027_fan_rrl_ota vinp vinn voutp voutn vdd vss
VB1 vb1 vss dc {vb1}
VB2 vb2 vss dc {vb2}
VB3 vb3 vss dc {vb3}
VB4 vb4 vss dc {vb4}
XM1 tail vb3 vdd vdd pch_lvt l=x_dut_xm1_l m=x_dut_xm1_m w=x_dut_xm1_w
XM10 voutp vb1 d1p vdd pch_lvt l=x_dut_xm10_l m=x_dut_xm10_m w=x_dut_xm10_w
XM11 voutn vb2 csrc_n vss nch_lvt l=x_dut_xm11_l m=x_dut_xm11_m w=x_dut_xm11_w
XM12 voutp vb2 csrc_p vss nch_lvt l=x_dut_xm12_l m=x_dut_xm12_m w=x_dut_xm12_w
XM13 csrc_n cm_bias vss vss nch_lvt l=x_dut_xm13_l m=x_dut_xm13_m w=x_dut_xm13_w
XM14 csrc_p cm_bias vss vss nch_lvt l=x_dut_xm14_l m=x_dut_xm14_m w=x_dut_xm14_w
XM15 cm_bias cm_bias vss vss nch_lvt l=x_dut_xm15_l m=x_dut_xm15_m w=x_dut_xm15_w
XM16 cm_sense cm_sense vss vss nch_lvt l=x_dut_xm16_l m=x_dut_xm16_m w=x_dut_xm16_w
XM2 d1n vinp tail vdd pch_lvt l=x_dut_xm2_l m=x_dut_xm2_m w=x_dut_xm2_w
XM3 d1p vinn tail vdd pch_lvt l=x_dut_xm3_l m=x_dut_xm3_m w=x_dut_xm3_w
XM4 cm_tail vb3 vdd vdd pch_lvt l=x_dut_xm4_l m=x_dut_xm4_m w=x_dut_xm4_w
XM5 cm_sense voutn cm_tail vdd pch_lvt l=x_dut_xm5_l m=x_dut_xm5_m w=x_dut_xm5_w
XM6 cm_bias vb4 cm_tail vdd pch_lvt l=x_dut_xm6_l m=x_dut_xm6_m w=x_dut_xm6_w
XM7 cm_sense voutp cm_tail vdd pch_lvt l=x_dut_xm7_l m=x_dut_xm7_m w=x_dut_xm7_w
XM8 cm_bias vb4 cm_tail vdd pch_lvt l=x_dut_xm8_l m=x_dut_xm8_m w=x_dut_xm8_w
XM9 voutn vb1 d1n vdd pch_lvt l=x_dut_xm9_l m=x_dut_xm9_m w=x_dut_xm9_w
.ends
.end
