* ldo_010_capless_lowiq — abstract (PDK-free) netlist. Generic tokens nmos/pmos/resistor/capacitor;
* sizes are the sizing.yaml symbols. Passives are PDK devices too (resistor/capacitor ->
* rhigh/cap_cmim, geometry knobs) so the LVS reference and the post-layout deck simulate the same
* models as this one. Ports: vdd vout vss.
*
* PORTED from an agent-first design repo @ 40cad45 (feat/001-reference),
* circuits/ldo_ihp_capless/. There the ihp binding was lowered BY HAND; here it is GENERATED by
* `analog-db generate` from this file, so this file carries the drawn device set verbatim and the
* two netlists are byte-comparable.
*
*   VREF   ideal reference (a real bandgap is out of scope, same convention as the reference)
*   XR1/XR2 feedback divider (high-ohmic poly, w = r_w, l = r_fb_l each: 1:1 -> vout = 2*vref), sensed
*            through the 0 V loop-break marker VLP (ac_loopgain bench)
*   XCFF   feed-forward MIM across XR1: a lead zero at 1/(2*pi*R1*Cff) that cancels the divider-node pole
*            the resistors' own substrate capacitance makes (~16 fF per rhigh terminal at 340u)
*   XRB/XMB0 resistor-referenced bias: I_ref = (VDD - Vgs) / R(r_bias_l); XMB1/XMBP mirror it to a PMOS diode
*   XMT/XM1/XM2/XM3/XM4  error-amp stage 1: PMOS-input 5T OTA (XM1: fb -> diode side, XM2: vref -> output side)
*   XM5/XM6  error-amp stage 2: NMOS common source under a PMOS current source (ea_out = FVF control voltage)
*   XCC    Miller MIM cap across stage 2 (dominant pole at ea_o1), c_comp_w square
*   XMC    flipped-voltage-follower control device (source = vout, gate = ea_out): the fast local loop
*   XMA/XMB + XMCP/XMD  NMOS then PMOS 1:1 current mirrors that fold XMC's current up to the pass gate
*            as a PULL-UP (double-mirror FVF): the pass gate can reach vdd - Vsd,sat, so the pass device
*            turns fully off at hot/fast corners, which the plain FVF (gate <= vout) cannot do, and the
*            gate pull-down XMS keeps the plain FVF's pull-down slew
*   XMS    constant gate-node sink (I_B)
*   XMP    pass device
*   XCOUT  on-chip output capacitor: c_out_m parallel MIM units of c_out_w square
*
* DRAWN DEVICE SET (design repo, 2026-09-05, layout review F19). The cards below are the devices
* the layout of record actually draws, not their schematic shorthand, because the difference is
* electrical and the benches simulate this file:
*   - XMP is m*nf_mult UNIT FINGERS of w/nf_mult, not m units of w.  Not `ng`: the PDK subckt's
*     `ng` passes nf to the PSP model, and at constant total W and constant junction area that
*     alone reads the load-step undershoot 105.2 mV where the unit-finger card reads 115.1 mV
*     (measured, both areas forced equal). kpex extracts the drawn array as 76 ng=1 cards, so the
*     unit-finger card is the one that puts the certified yardstick and the extracted measurement
*     on one device model; `ng` would bank a 10 mV pre->post credit that is a model parameter, not
*     a layout.
*   - every common-centroid member (XM1..XM4, XMS, XMB1, XMB0) is drawn as TWO half-width
*     instances, so it is netlisted as two. Any matched pattern the brief's sigma implies draws
*     unit devices, so this is not specific to common centroid.
*   - XR1/XR2 are 8 series segments each and XRB is 5, as the serpentines are drawn.
* LVS is unaffected: the deck compares W and L with --combine_devices, which folds the halves and
* the chains back together (the layout entry's netlist_ref.py emits exactly this set).
VREF vref vss dc {vref_val}
VLP lp_brk vout dc 0
XR1_1 lp_brk n_r1_1 vss rhigh w=r_w l={r_fb_l/8}
XR1_2 n_r1_1 n_r1_2 vss rhigh w=r_w l={r_fb_l/8}
XR1_3 n_r1_2 n_r1_3 vss rhigh w=r_w l={r_fb_l/8}
XR1_4 n_r1_3 n_r1_4 vss rhigh w=r_w l={r_fb_l/8}
XR1_5 n_r1_4 n_r1_5 vss rhigh w=r_w l={r_fb_l/8}
XR1_6 n_r1_5 n_r1_6 vss rhigh w=r_w l={r_fb_l/8}
XR1_7 n_r1_6 n_r1_7 vss rhigh w=r_w l={r_fb_l/8}
XR1_8 n_r1_7 fb vss rhigh w=r_w l={r_fb_l/8}
XCFF lp_brk fb cap_cmim w=c_ff_w l=c_ff_w
XR2_1 fb n_r2_1 vss rhigh w=r_w l={r_fb_l/8}
XR2_2 n_r2_1 n_r2_2 vss rhigh w=r_w l={r_fb_l/8}
XR2_3 n_r2_2 n_r2_3 vss rhigh w=r_w l={r_fb_l/8}
XR2_4 n_r2_3 n_r2_4 vss rhigh w=r_w l={r_fb_l/8}
XR2_5 n_r2_4 n_r2_5 vss rhigh w=r_w l={r_fb_l/8}
XR2_6 n_r2_5 n_r2_6 vss rhigh w=r_w l={r_fb_l/8}
XR2_7 n_r2_6 n_r2_7 vss rhigh w=r_w l={r_fb_l/8}
XR2_8 n_r2_7 vss vss rhigh w=r_w l={r_fb_l/8}
XRB_1 vdd n_rb_1 vss rhigh w=r_w l={r_bias_l/5}
XRB_2 n_rb_1 n_rb_2 vss rhigh w=r_w l={r_bias_l/5}
XRB_3 n_rb_2 n_rb_3 vss rhigh w=r_w l={r_bias_l/5}
XRB_4 n_rb_3 n_rb_4 vss rhigh w=r_w l={r_bias_l/5}
XRB_5 n_rb_4 nbias vss rhigh w=r_w l={r_bias_l/5}
XMB0A nbias nbias vss vss nmos l=x_dut_xmb0_l w={x_dut_xmb0_w/2}
XMB0B nbias nbias vss vss nmos l=x_dut_xmb0_l w={x_dut_xmb0_w/2}
XMB1A pbias nbias vss vss nmos l=x_dut_xmb0_l w={x_dut_xmb1_w/2}
XMB1B pbias nbias vss vss nmos l=x_dut_xmb0_l w={x_dut_xmb1_w/2}
XMBP pbias pbias vdd vdd pmos l=x_dut_xmbp_l w=x_dut_xmbp_w
XMT ea_tail pbias vdd vdd pmos l=x_dut_xmbp_l w=x_dut_xmt_w
XM1A ea_n fb ea_tail vdd pmos l=x_dut_xm1_l w={x_dut_xm1_w/2}
XM1B ea_n fb ea_tail vdd pmos l=x_dut_xm1_l w={x_dut_xm1_w/2}
XM2A ea_o1 vref ea_tail vdd pmos l=x_dut_xm1_l w={x_dut_xm1_w/2}
XM2B ea_o1 vref ea_tail vdd pmos l=x_dut_xm1_l w={x_dut_xm1_w/2}
XM3A ea_n ea_n vss vss nmos l=x_dut_xm3_l w={x_dut_xm3_w/2}
XM3B ea_n ea_n vss vss nmos l=x_dut_xm3_l w={x_dut_xm3_w/2}
XM4A ea_o1 ea_n vss vss nmos l=x_dut_xm3_l w={x_dut_xm3_w/2}
XM4B ea_o1 ea_n vss vss nmos l=x_dut_xm3_l w={x_dut_xm3_w/2}
XM5 ea_out ea_o1 vss vss nmos l=x_dut_xm5_l w=x_dut_xm5_w
XM6 ea_out pbias vdd vdd pmos l=x_dut_xmbp_l w=x_dut_xm6_w
XCC ea_out ea_o1 cap_cmim w=c_comp_w l=c_comp_w
XMC x1 ea_out vout vdd pmos l=x_dut_xmc_l w=x_dut_xmc_w
XMA x1 x1 vss vss nmos l=x_dut_xma_l w=x_dut_xma_w
XMB y x1 vss vss nmos l=x_dut_xma_l w=x_dut_xma_w
XMCP y y vdd vdd pmos l=x_dut_xmcp_l w=x_dut_xmcp_w
XMD gate y vdd vdd pmos l=x_dut_xmcp_l w=x_dut_xmcp_w
XMSA gate nbias vss vss nmos l=x_dut_xms_l w={x_dut_xms_w/2}
XMSB gate nbias vss vss nmos l=x_dut_xms_l w={x_dut_xms_w/2}
XMP vout gate vdd vdd pmos l=x_dut_xmp_l w={x_dut_xmp_w/x_dut_xmp_nf_mult} m={x_dut_xmp_m*x_dut_xmp_nf_mult}
XCOUT vout vss cap_cmim w=c_out_w l=c_out_w m=c_out_m
.end
