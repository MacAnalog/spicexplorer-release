** GENERATED by `analog-db export-raw` — DO NOT EDIT.
** circuit=adc_001_inv1b  class=adc  pdk=ihp-sg13g2  testbench=dc_op  corner=tt
** Self-contained deck: testbench + bound params + lowered DUT (.subckt adc_001_inv1b).
** PDK corner libs resolve by BARE NAME on the image's ngspice sourcepath — run in a
** PDK-enabled env (the base image / api container), NOT a bare host:
**   docker run --rm -i spicexplorer-spice-base:local \
**     bash -lc 'd=$(mktemp -d) && cat > $d/c.spice && cd $d && ngspice -b c.spice' < raw/adc_001_inv1b/ihp-sg13g2/dc_op.spice
*----------------------------------------------------------*
** params: 6 free + 0 frozen knobs (sizing.yaml) · 0 tied · 0 ratio-derived (abstract/params.yaml) · 2 testbench params
** AUTHORED TEMPLATE — adc/dc_op: DC operating point + supply current of a converter's analog core.
** [VALIDATED 2026-07-16 on ihp-sg13g2 against adc_001_inv1b — live ngspice].
** Holds the analog input at mid-scale and reports the static supply draw (power) and output level.
** Port convention: vdd vin vout vss. Bindings: DUT PORT_LINE VDD VCM PDK_INCLUDE.
.lib cornerMOSlv.lib mos_tt
.temp 27

.param VDD=1.2
.param VCM=0.6

Vdd vdd 0 dc {VDD}
Vss vss 0 dc 0
Vin vin 0 dc {VCM}

XDUT vdd vin vout vss adc_001_inv1b

.control
  set filetype=ascii
  op
  let i_supply = abs(i(Vdd))
  let v_out = v(vout)
  print i_supply v_out
  write
  quit
.endc
.param x_dut_xmn_w=1.0u
.param x_dut_xmn_l=0.13u
.param x_dut_xmn_m=1
.param x_dut_xmp_w=2.5u
.param x_dut_xmp_l=0.13u
.param x_dut_xmp_m=1
.subckt adc_001_inv1b vdd vin vout vss
XMN vout vin vss vss sg13_lv_nmos l=x_dut_xmn_l m=x_dut_xmn_m w=x_dut_xmn_w
XMP vout vin vdd vdd sg13_lv_pmos l=x_dut_xmp_l m=x_dut_xmp_m w=x_dut_xmp_w
.ends
.end
