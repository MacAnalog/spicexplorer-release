** GENERATED by `analog-db export-raw` — DO NOT EDIT.
** circuit=amp_024_smcnr  class=amplifier  pdk=gf180mcu  testbench=noise  corner=tt
** Self-contained deck: testbench + bound params + lowered DUT (.subckt amp_024_smcnr).
** PDK corner libs resolve by BARE NAME on the image's ngspice sourcepath — run in a
** PDK-enabled env (the base image / api container), NOT a bare host:
**   docker run --rm -i spicexplorer-spice-base:local \
**     bash -lc 'd=$(mktemp -d) && cat > $d/c.spice && cd $d && ngspice -b c.spice' < raw/amp_024_smcnr/gf180mcu/noise.spice
*----------------------------------------------------------*
** params: 9 free + 9 frozen knobs (sizing.yaml) · 9 tied · 0 ratio-derived (abstract/params.yaml) · 4 testbench params
** AUTHORED TEMPLATE — universal/noise (plan D-4): input-referred noise over a band.
** Bindings: DUT PORT_LINE VDD VCM IBIAS CL
**   FSTART FSTOP PPD PDK_INCLUDE.
.include design.ngspice
.lib sm141064.ngspice noise_corner
.lib sm141064.ngspice nfet_03v3_t
.lib sm141064.ngspice pfet_03v3_t
.lib sm141064.ngspice fets_mm
.lib sm141064.ngspice res_typical
.lib sm141064.ngspice mimcap_typical
.lib sm141064.ngspice cap_mim
.temp 27

.param VDD=1.5
.param VCM=0.5
.param IBIAS=0
.param CL=10p

Vdd  vdd 0 dc {VDD}
Vss  vss 0 dc 0
Ibias vdd ibias dc {IBIAS}
CLoad vout 0 {CL}
Vcm  vcm 0 dc {VCM}
Vinp vinp vcm dc 0 ac 1
Vinn vinn vcm dc 0

XDUT vss vdd vinn vinp vout amp_024_smcnr

.control
  set filetype=ascii
  noise v(vout) Vinp dec 50 1 1MEG
  print inoise_total onoise_total
  write
  quit
.endc
.param x_dut_xm7_w=0.25u
.param x_dut_xm7_l=10u
.param x_dut_xm0_w=7.5u
.param x_dut_xm0_l=8u
.param x_dut_xm1_w=1.5u
.param x_dut_xm1_l=10u
.param x_dut_xm4_w=1.5u
.param x_rz=1e5
.param x_c0=2e-12
.param x_ibias_val=1e-7
.param x_dut_xm7_m=1
.param x_dut_xm6_m=2
.param x_dut_xm5_m=10
.param x_dut_xm0_m=1
.param x_dut_xm2_m=1
.param x_dut_xm1_m=1
.param x_dut_xm3_m=1
.param x_dut_xm4_m=10
* ---- GENERATED parameter ties (abstract/params.yaml groups/ratios) ----
* Each tied symbol is defined exactly once, by its line below; rewrite that
* .param to untie just that symbol (untying = shadowing, plan D-3).
.param x_dut_xm6_w = {x_dut_xm7_w}
.param x_dut_xm5_w = {x_dut_xm7_w}
.param x_dut_xm6_l = {x_dut_xm7_l}
.param x_dut_xm5_l = {x_dut_xm7_l}
.param x_dut_xm2_w = {x_dut_xm0_w}
.param x_dut_xm2_l = {x_dut_xm0_l}
.param x_dut_xm3_l = {x_dut_xm1_l}
.param x_dut_xm4_l = {x_dut_xm1_l}
.param x_dut_xm3_w = {x_dut_xm1_w}
.subckt amp_024_smcnr vss vdd vinn vinp vout
C0 outn nzo x_c0
IBS ibias vss dc {x_ibias_val}
R0 nzo vout x_rz
XM0 outp vinn tailp vdd pfet_03v3 l=x_dut_xm0_l m=x_dut_xm0_m w=x_dut_xm0_w
XM1 outp outp vss vss nfet_03v3 l=x_dut_xm1_l m=x_dut_xm1_m w=x_dut_xm1_w
XM2 outn vinp tailp vdd pfet_03v3 l=x_dut_xm2_l m=x_dut_xm2_m w=x_dut_xm2_w
XM3 outn outp vss vss nfet_03v3 l=x_dut_xm3_l m=x_dut_xm3_m w=x_dut_xm3_w
XM4 vout outn vss vss nfet_03v3 l=x_dut_xm4_l m=x_dut_xm4_m w=x_dut_xm4_w
XM5 vout ibias vdd vdd pfet_03v3 l=x_dut_xm5_l m=x_dut_xm5_m w=x_dut_xm5_w
XM6 tailp ibias vdd vdd pfet_03v3 l=x_dut_xm6_l m=x_dut_xm6_m w=x_dut_xm6_w
XM7 ibias ibias vdd vdd pfet_03v3 l=x_dut_xm7_l m=x_dut_xm7_m w=x_dut_xm7_w
.ends
.end
