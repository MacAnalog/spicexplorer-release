** GENERATED by `analog-db export-raw` — DO NOT EDIT.
** circuit=vref_001_vgs  class=voltage_reference  pdk=ihp-sg13g2  testbench=psrr  corner=tt
** Self-contained deck: testbench + bound params + lowered DUT (.subckt vref_001_vgs).
** PDK corner libs resolve by BARE NAME on the image's ngspice sourcepath — run in a
** PDK-enabled env (the base image / api container), NOT a bare host:
**   docker run --rm -i spicexplorer-spice-base:local \
**     bash -lc 'd=$(mktemp -d) && cat > $d/c.spice && cd $d && ngspice -b c.spice' < raw/vref_001_vgs/ihp-sg13g2/psrr.spice
*----------------------------------------------------------*
** params: 6 free + 0 frozen knobs (sizing.yaml) · 0 tied · 0 ratio-derived (abstract/params.yaml) · 1 testbench params
** AUTHORED TEMPLATE — voltage_reference/psrr: low-frequency supply rejection.
** [VALIDATED 2026-07-16 on ihp-sg13g2 against vref_001_vgs — live ngspice, 4/4 benches pass].
** Drives the supply with a 1 V AC and reports the supply→reference gain at the low-frequency edge
** (dB; more-negative = better rejection). Port convention: vdd vref vss.
** Bindings: DUT PORT_LINE VDD FSTART FSTOP PPD PDK_INCLUDE.
.lib cornerMOSlv.lib mos_tt
.lib cornerMOShv.lib mos_tt
.temp 27

.param VDD=1.2

Vdd vdd 0 dc {VDD} ac 1
Vss vss 0 dc 0

XDUT vdd vref vss vref_001_vgs

.control
  set filetype=ascii
  ac dec 10 10 10meg
  meas ac psrr_db FIND vdb(vref) AT=10
  print psrr_db
  write
  quit
.endc
.param x_dut_xm0_w=2.5u
.param x_dut_xm0_l=2.0u
.param x_dut_xm0_m=1
.param x_dut_xm1_w=1.0u
.param x_dut_xm1_l=2.0u
.param x_dut_xm1_m=1
.subckt vref_001_vgs vdd vref vss
XM0 vdd vref vref vss sg13_lv_nmos l=x_dut_xm0_l m=x_dut_xm0_m w=x_dut_xm0_w
XM1 vref vref vss vss sg13_hv_nmos l=x_dut_xm1_l m=x_dut_xm1_m w=x_dut_xm1_w
.ends
.end
