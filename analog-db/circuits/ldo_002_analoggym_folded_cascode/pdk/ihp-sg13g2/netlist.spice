** GENERATED by `analog-db generate` — DO NOT EDIT. Source: abstract/netlist.spice → ihp-sg13g2
* ldo_002_analoggym_folded_cascode (emitted by spicexplorer-circuitgraph)
CC ncz vout 'c_comp'
RZ ncz ngate 'r_z'
R_BLEED vout vss 'r_bleed'
VB1 vb1 vss dc {vb1_val}
VB2 vb2 vss dc {vb2_val}
VLP lp_brk vout dc 0
VREF vref vss dc {vref_val}
XM1 n2 lp_brk n4 vss sg13_hv_nmos l=x_dut_xm1_l w=x_dut_xm1_w
XM2 n3 vref n4 vss sg13_hv_nmos l=x_dut_xm2_l w=x_dut_xm2_w
XM3 n2 nmir vdd vdd sg13_hv_pmos l=x_dut_xm3_l w=x_dut_xm3_w
XM4 n3 nmir vdd vdd sg13_hv_pmos l=x_dut_xm4_l w=x_dut_xm4_w
XM5 nmir vb2 n2 vdd sg13_hv_pmos l=x_dut_xm5_l w=x_dut_xm5_w
XM6 ngate vb2 n3 vdd sg13_hv_pmos l=x_dut_xm6_l w=x_dut_xm6_w
XM7 nmir vb1 vss vss sg13_hv_nmos l=x_dut_xm7_l w=x_dut_xm7_w
XM8 ngate vb1 vss vss sg13_hv_nmos l=x_dut_xm8_l w=x_dut_xm8_w
XM9 n4 vb1 vss vss sg13_hv_nmos l=x_dut_xm9_l w=x_dut_xm9_w
XMP vout ngate vdd vdd sg13_hv_pmos l=x_dut_xmp_l m=x_dut_xmp_m w=x_dut_xmp_w
.end
