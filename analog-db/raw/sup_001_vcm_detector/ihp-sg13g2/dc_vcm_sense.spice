** GENERATED by `analog-db export-raw` — DO NOT EDIT.
** circuit=sup_001_vcm_detector  class=support  pdk=ihp-sg13g2  testbench=dc_vcm_sense  corner=tt
** Self-contained deck: testbench + bound params + lowered DUT (.subckt sup_001_vcm_detector).
** PDK corner libs resolve by BARE NAME on the image's ngspice sourcepath — run in a
** PDK-enabled env (the base image / api container), NOT a bare host:
**   docker run --rm -i spicexplorer-spice-base:local \
**     bash -lc 'd=$(mktemp -d) && cat > $d/c.spice && cd $d && ngspice -b c.spice' < raw/sup_001_vcm_detector/ihp-sg13g2/dc_vcm_sense.spice
*----------------------------------------------------------*
** params: 1 free + 0 frozen knobs (sizing.yaml) · 1 tied · 0 ratio-derived (abstract/params.yaml) · 3 testbench params
** AUTHORED TEMPLATE — support/dc_vcm_sense (plan_hierarchical_composition P3).
** Common-mode detector sense accuracy: the two inputs are driven to VCM +/- VDIFF/2;
** an ideal CM detector reports vcm_out = VCM regardless of VDIFF. vos is the sense
** error. The DUT is passive/supply-less (e.g. a resistive averager) or self-biased;
** supply rails are provided for DUTs that declare them.
**
** Assumes the CM-detector port order (supplies optional — extra driven nets are
** harmless):  .subckt <id> vcm_out vinp vinn [vdd vss]
** Required bindings: DUT PORT_LINE VDD VCM VDIFF PDK_INCLUDE.
.lib cornerMOSlv.lib mos_tt
.temp 27

.param VDD=1.2
.param VCM=0.6
.param VDIFF=0.2

Vdd  vdd 0 dc {VDD}
Vss  vss 0 dc 0
Vinp vinp 0 dc {VCM+VDIFF/2}
Vinn vinn 0 dc {VCM-VDIFF/2}

XDUT vcm_out vinp vinn sup_001_vcm_detector

.control
  set filetype=ascii
  op
  let vcm_out = v(vcm_out)
  let vos = v(vcm_out) - 0.6
  print vcm_out vos
  write
  quit
.endc
.param x_dut_rmp_value=1Meg
* ---- GENERATED parameter ties (abstract/params.yaml groups/ratios) ----
* Each tied symbol is defined exactly once, by its line below; rewrite that
* .param to untie just that symbol (untying = shadowing, plan D-3).
.param x_dut_rmn_value = {x_dut_rmp_value}
.subckt sup_001_vcm_detector vcm_out vinp vinn
RMN vinn vcm_out 'x_dut_rmn_value'
RMP vcm_out vinp 'x_dut_rmp_value'
.ends
.end
