** AUTHORED TEMPLATE — voltage_reference/psrr: low-frequency supply rejection.
** [VALIDATED 2026-07-16 on ihp-sg13g2 against vref_001_vgs — live ngspice, 4/4 benches pass].
** Drives the supply with a 1 V AC and reports the supply→reference gain at the low-frequency edge
** (dB; more-negative = better rejection). Port convention: vdd vref vss.
** Bindings: DUT PORT_LINE VDD FSTART FSTOP PPD PDK_INCLUDE.
${PDK_INCLUDE}

.param VDD=${VDD}

Vdd vdd 0 dc {VDD} ac 1
Vss vss 0 dc 0

${PORT_LINE} ${DUT}

.control
  set filetype=ascii
  ac dec ${PPD} ${FSTART} ${FSTOP}
  meas ac psrr_db FIND vdb(vref) AT=${FSTART}
  print psrr_db
  write
  quit
.endc
.end
