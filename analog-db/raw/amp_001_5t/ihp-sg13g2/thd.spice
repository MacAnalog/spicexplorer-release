** GENERATED by `analog-db export-raw` — DO NOT EDIT.
** circuit=amp_001_5t  class=amplifier  pdk=ihp-sg13g2  testbench=thd  corner=tt
** Self-contained deck: testbench + bound params + lowered DUT (.subckt amp_001_5t).
** PDK corner libs resolve by BARE NAME on the image's ngspice sourcepath — run in a
** PDK-enabled env (the base image / api container), NOT a bare host:
**   docker run --rm -i spicexplorer-spice-base:local \
**     bash -lc 'd=$(mktemp -d) && cat > $d/c.spice && cd $d && ngspice -b c.spice' < raw/amp_001_5t/ihp-sg13g2/thd.spice
*----------------------------------------------------------*
** params: 8 free + 4 frozen knobs (sizing.yaml) · 6 tied · 0 ratio-derived (abstract/params.yaml) · 5 testbench params
** AUTHORED TEMPLATE — amplifier/thd: large-signal harmonic distortion in the unity buffer.
** A single sine at F0 (amplitude ASIG, offset VCM) drives the + input; the buffer output's
** harmonic content IS the DUT's distortion. ngspice lane: plain tran written to the raw —
** THD computed by the platform registry {meas: thd_pct, f0: F0} (coherent FFT, the .four
** analogue; the `fourier` print in the log is an eyeball hint only). Spectre lane: the
** platform composes a NATIVE pss at F0 instead (fd-PSF harmonics -> {meas: thd_pss_*}) —
** ngspice has no PSS, so tran+FFT is the engine-neutral default and pss the closed-lane
** upgrade. Bindings: DUT PORT_LINE VDD VCM IBIAS CL ASIG F0 TSTEP TSTOP PDK_INCLUDE.
.lib cornerMOSlv.lib mos_tt
.temp 27

.param VDD=1.5
.param VCM=0.8
.param IBIAS=20u
.param CL=50f
.param ASIG=0.1

Vdd  vdd 0 dc {VDD}
Vss  vss 0 dc 0
Ibias vdd ibias dc {IBIAS}
CLoad vout 0 {CL}

* unity buffer; the sine offset VCM doubles as the DC operating point
Vinp vinp 0 sin({VCM} {ASIG} 1.0e6)
Vfb  vinn vout dc 0

XDUT vdd vout vinp vinn ibias vss amp_001_5t

.control
  set filetype=ascii
  tran 2n 20u
  fourier 1.0e6 v(vout)
  write
  quit
.endc
.param x_dut_xm1_w=10.0u
.param x_dut_xm1_l=10.0u
.param x_dut_xm3_w=10.0u
.param x_dut_xm3_l=7.0u
.param x_dut_xm5_w=3.8u
.param x_dut_xm5_l=1.0u
.param x_dut_xm6_w=3.8u
.param x_dut_xm6_l=1.0u
.param x_dut_xm1_m=1
.param x_dut_xm3_m=1
.param x_dut_xm5_m=1
.param x_dut_xm6_m=1
* ---- GENERATED parameter ties (abstract/params.yaml groups/ratios) ----
* Each tied symbol is defined exactly once, by its line below; rewrite that
* .param to untie just that symbol (untying = shadowing, plan D-3).
.param x_dut_xm2_w = {x_dut_xm1_w}
.param x_dut_xm2_l = {x_dut_xm1_l}
.param x_dut_xm2_m = {x_dut_xm1_m}
.param x_dut_xm4_w = {x_dut_xm3_w}
.param x_dut_xm4_l = {x_dut_xm3_l}
.param x_dut_xm4_m = {x_dut_xm3_m}
.subckt amp_001_5t vdd vout vinp vinn ibias vss
XM1 outm vinp tail vss sg13_lv_nmos l=x_dut_xm1_l m=x_dut_xm1_m w=x_dut_xm1_w
XM2 vout vinn tail vss sg13_lv_nmos l=x_dut_xm2_l m=x_dut_xm2_m w=x_dut_xm2_w
XM3 outm outm vdd vdd sg13_lv_pmos l=x_dut_xm3_l m=x_dut_xm3_m w=x_dut_xm3_w
XM4 vout outm vdd vdd sg13_lv_pmos l=x_dut_xm4_l m=x_dut_xm4_m w=x_dut_xm4_w
XM5 tail ibias vss vss sg13_lv_nmos l=x_dut_xm5_l m=x_dut_xm5_m w=x_dut_xm5_w
XM6 ibias ibias vss vss sg13_lv_nmos l=x_dut_xm6_l m=x_dut_xm6_m w=x_dut_xm6_w
.ends
.end
