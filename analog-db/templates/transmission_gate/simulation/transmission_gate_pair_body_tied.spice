** sch_path: transmission_gate_pair_body_tied.sch
**.subckt transmission_gate_pair_body_tied port_A port_B vctl vctl_not
*.ipin port_A
*.ipin port_B
*.ipin vctl
*.ipin vctl_not
XM1 port_A vctl port_B port_B sg13_lv_nmos w=0.15u l=0.13u ng=1 m=1
XM2 port_B vctl_not port_A port_A sg13_lv_pmos w=0.15u l=0.13u ng=1 m=1
**.ends
.end
