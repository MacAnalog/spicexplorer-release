** GENERATED by `analog-db export-raw` — DO NOT EDIT.
** circuit=trm_001_vcr  class=trim  pdk=ihp-sg13g2  testbench=dc_code_sweep  corner=tt
** Self-contained deck: testbench + bound params + lowered DUT (.subckt trm_001_vcr).
** PDK corner libs resolve by BARE NAME on the image's ngspice sourcepath — run in a
** PDK-enabled env (the base image / api container), NOT a bare host:
**   docker run --rm -i spicexplorer-spice-base:local \
**     bash -lc 'd=$(mktemp -d) && cat > $d/c.spice && cd $d && ngspice -b c.spice' < raw/trm_001_vcr/ihp-sg13g2/dc_code_sweep.spice
*----------------------------------------------------------*
** params: 4 free + 0 frozen knobs (sizing.yaml) · 0 tied · 0 ratio-derived (abstract/params.yaml) · 1 testbench params
** AUTHORED TEMPLATE — trim/dc_code_sweep: static trim-code transfer + linearity.
** Sweeps the trim control Vcode across its range (each CODE_STEP increment is one "code") and
** extracts, from the swept transfer v(vout): the full-scale range, the average LSB step, peak INL
** (deviation from the endpoint line, in LSB), and a monotonicity flag (all step signs equal).
** Port convention: vdd vcode vout vss. Bindings: DUT PORT_LINE VDD CODE_LO CODE_HI CODE_STEP PDK_INCLUDE.
.lib cornerMOSlv.lib mos_tt
.temp 27

.param VDD=1.2

Vdd vdd 0 dc {VDD}
Vss vss 0 dc 0
Vcode vcode 0 dc 0

XDUT vdd vcode vout vss trm_001_vcr

.control
  set filetype=ascii
  dc Vcode 0 1.2 0.05
  let np = length(v(vout))
  let out_lo = v(vout)[0]
  let out_hi = v(vout)[np-1]
  let full_range = abs(out_hi - out_lo)
  let lsb = (out_hi - out_lo) / (np - 1)
  let lsb_step = abs(lsb)
  * INL = peak deviation from the endpoint straight line, in LSB
  let ideal = out_lo + lsb * vector(np)
  let inl_v = (v(vout) - ideal) / lsb
  let inl_lsb = maximum(abs(inl_v))
  * monotonic = 1 when the transfer never reverses beyond 2% of its steepest slope (a robust
  * check that tolerates deriv sign-noise in the flat end regions of the sweep)
  let dv = deriv(v(vout))
  let slope = max(abs(minimum(dv)), abs(maximum(dv)))
  let monotonic = (maximum(dv) le 0.02 * slope) | (minimum(dv) ge -0.02 * slope)
  print full_range lsb_step inl_lsb monotonic
  write
  quit
.endc
.param x_dut_r0_value=200k
.param x_dut_xm0_w=2.0u
.param x_dut_xm0_l=0.5u
.param x_dut_xm0_m=1
.subckt trm_001_vcr vdd vcode vout vss
R0 vdd vout x_dut_r0_value
XM0 vout vcode vss vss sg13_lv_nmos l=x_dut_xm0_l m=x_dut_xm0_m w=x_dut_xm0_w
.ends
.end
