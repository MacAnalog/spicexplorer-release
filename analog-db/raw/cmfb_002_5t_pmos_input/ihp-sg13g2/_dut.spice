** GENERATED by `analog-db export-raw` — DO NOT EDIT.
** Standalone lowered DUT subckt for cmfb_002_5t_pmos_input on ihp-sg13g2 (sizing .param defaults + .subckt).
** Not a runnable deck on its own — include it under your own testbench:
**   .include _dut.spice
**   XDUT vinp vinn vcmfb vref vdd vss cmfb_002_5t_pmos_input
** Source: pdk/ihp-sg13g2/netlist.spice (run `analog-db generate` to refresh).
*----------------------------------------------------------*
** params: 11 free + 5 frozen knobs (sizing.yaml) · 7 tied · 0 ratio-derived (abstract/params.yaml)
.param x_dut_xm4_w=1.42u
.param x_dut_xm4_l=0.27u
.param x_dut_xm2_w=2.32u
.param x_dut_xm2_l=1.31u
.param x_dut_xm1_w=0.329u
.param x_dut_xm1_l=0.267u
.param x_dut_xm7_w=0.293u
.param x_dut_xm7_l=0.22u
.param x_dut_xm3_w=0.881u
.param x_dut_xm3_l=0.259u
.param x_dut_rmp_value=1Meg
.param x_dut_xm1_m=1
.param x_dut_xm2_m=1
.param x_dut_xm3_m=1
.param x_dut_xm4_m=1
.param x_dut_xm7_m=1
* ---- GENERATED parameter ties (abstract/params.yaml groups/ratios) ----
* Each tied symbol is defined exactly once, by its line below; rewrite that
* .param to untie just that symbol (untying = shadowing, plan D-3).
.param x_dut_xm5_w = {x_dut_xm4_w}
.param x_dut_xm5_l = {x_dut_xm4_l}
.param x_dut_xm5_m = {x_dut_xm4_m}
.param x_dut_xm6_w = {x_dut_xm2_w}
.param x_dut_xm6_l = {x_dut_xm2_l}
.param x_dut_xm6_m = {x_dut_xm2_m}
.param x_dut_rmn_value = {x_dut_rmp_value}
.subckt cmfb_002_5t_pmos_input vinp vinn vcmfb vref vdd vss
RMN vinn cm_sense 'x_dut_rmn_value'
RMP cm_sense vinp 'x_dut_rmp_value'
XM1 ptail bias vdd vdd sg13_lv_pmos l=x_dut_xm1_l m=x_dut_xm1_m w=x_dut_xm1_w
XM2 vcmfb mirr vss vss sg13_lv_nmos l=x_dut_xm2_l m=x_dut_xm2_m w=x_dut_xm2_w
XM3 bias bias vdd vdd sg13_lv_pmos l=x_dut_xm3_l m=x_dut_xm3_m w=x_dut_xm3_w
XM4 mirr cm_sense ptail vdd sg13_lv_pmos l=x_dut_xm4_l m=x_dut_xm4_m w=x_dut_xm4_w
XM5 vcmfb vref ptail vdd sg13_lv_pmos l=x_dut_xm5_l m=x_dut_xm5_m w=x_dut_xm5_w
XM6 mirr mirr vss vss sg13_lv_nmos l=x_dut_xm6_l m=x_dut_xm6_m w=x_dut_xm6_w
XM7 bias bias vss vss sg13_lv_nmos l=x_dut_xm7_l m=x_dut_xm7_m w=x_dut_xm7_w
.ends
