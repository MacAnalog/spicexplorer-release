** GENERATED by `analog-db generate` — DO NOT EDIT. Source: abstract/netlist.spice → sky130
* amp_019_ti_ldo_error (emitted by spicexplorer-circuitgraph)
CC ncz vout 'c_comp'
RND na nd 'r_nd'
RZ nb ncz 'r_z'
XM1 na vinn tail vss sky130_fd_pr__nfet_g5v0d10v5 l=x_dut_xm1_l w=x_dut_xm1_w
XM2 nb vinp tail vss sky130_fd_pr__nfet_g5v0d10v5 l=x_dut_xm2_l w=x_dut_xm2_w
XM3 na nd vdd vdd sky130_fd_pr__pfet_g5v0d10v5 l=x_dut_xm3_l w=x_dut_xm3_w
XM4 nlev na nd vdd sky130_fd_pr__pfet_g5v0d10v5 l=x_dut_xm4_l w=x_dut_xm4_w
XM5 nb nd vdd vdd sky130_fd_pr__pfet_g5v0d10v5 l=x_dut_xm5_l w=x_dut_xm5_w
XM6 vout ne vdd vdd sky130_fd_pr__pfet_g5v0d10v5 l=x_dut_xm6_l w=x_dut_xm6_w
XM7 ne ne nb vdd sky130_fd_pr__pfet_g5v0d10v5 l=x_dut_xm7_l w=x_dut_xm7_w
XMB0 ibias ibias vss vss sky130_fd_pr__nfet_g5v0d10v5 l=x_dut_xmb0_l w=x_dut_xmb0_w
XMBC tail ibias vss vss sky130_fd_pr__nfet_g5v0d10v5 l=x_dut_xmbc_l m=x_dut_xmbc_m w=x_dut_xmbc_w
XMBE ne ibias vss vss sky130_fd_pr__nfet_g5v0d10v5 l=x_dut_xmbe_l w=x_dut_xmbe_w
XMBF nlev ibias vss vss sky130_fd_pr__nfet_g5v0d10v5 l=x_dut_xmbf_l w=x_dut_xmbf_w
XMBO vout ibias vss vss sky130_fd_pr__nfet_g5v0d10v5 l=x_dut_xmbo_l m=x_dut_xmbo_m w=x_dut_xmbo_w
.end
