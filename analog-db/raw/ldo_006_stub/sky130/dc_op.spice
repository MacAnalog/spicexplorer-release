** GENERATED by `analog-db export-raw` — DO NOT EDIT.
** circuit=ldo_006_stub  class=ldo  pdk=sky130  testbench=dc_op  corner=tt
** Self-contained deck: testbench + bound params + lowered DUT (.subckt ldo_006_stub).
** PDK corner libs resolve by BARE NAME on the image's ngspice sourcepath — run in a
** PDK-enabled env (the base image / api container), NOT a bare host:
**   docker run --rm -i spicexplorer-spice-base:local \
**     bash -lc 'd=$(mktemp -d) && cat > $d/c.spice && cd $d && ngspice -b c.spice' < raw/ldo_006_stub/sky130/dc_op.spice
*----------------------------------------------------------*
** params: 4 free + 1 frozen knobs (sizing.yaml) · 0 tied · 0 ratio-derived (abstract/params.yaml) · 1 testbench params
** AUTHORED TEMPLATE — ldo/dc_op: DC operating point for a regulator.
** Superset of universal/dc_op: also reports the regulated output v(vout). The DUT generates its
** own reference + bias internally, so the testbench only drives vdd/vss (no load = quiescent).
** Bindings: DUT PORT_LINE VDD PDK_INCLUDE.
.lib sky130.lib.spice tt
.temp 27

.param VDD=1.5

Vdd  vdd 0 dc {VDD}
Vss  vss 0 dc 0

XDUT vdd vout vss ldo_006_stub

.control
  set filetype=ascii
  op
  let i_supply = abs(i(Vdd))
  let vout_dc = v(vout)
  print i_supply vout_dc
  write
  quit
.endc
.param x_dut_xm1_w=50
.param x_dut_xm1_l=0.5
.param r_top=100k
.param r_bot=100k
.param x_dut_xm1_m=1
.subckt ldo_006_stub vdd vout vss
R1 vdd vref r_top
R2 vref vss r_bot
XM1 vdd vref vout vss sky130_fd_pr__nfet_01v8 l=x_dut_xm1_l m=x_dut_xm1_m w=x_dut_xm1_w
.ends
.end
