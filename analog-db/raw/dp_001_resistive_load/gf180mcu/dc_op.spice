** GENERATED by `analog-db export-raw` — DO NOT EDIT.
** circuit=dp_001_resistive_load  class=diff_pair  pdk=gf180mcu  testbench=dc_op  corner=tt
** Self-contained deck: testbench + bound params + lowered DUT (.subckt dp_001_resistive_load).
** PDK corner libs resolve by BARE NAME on the image's ngspice sourcepath — run in a
** PDK-enabled env (the base image / api container), NOT a bare host:
**   docker run --rm -i spicexplorer-spice-base:local \
**     bash -lc 'd=$(mktemp -d) && cat > $d/c.spice && cd $d && ngspice -b c.spice' < raw/dp_001_resistive_load/gf180mcu/dc_op.spice
*----------------------------------------------------------*
** params: 7 free + 3 frozen knobs (sizing.yaml) · 4 tied · 0 ratio-derived (abstract/params.yaml) · 3 testbench params
** AUTHORED TEMPLATE — diff_pair/dc_op (plan D-4): DC operating point of a differential pair.
** Biases the mirror tail from an external Ibias, sets the input common-mode, and reports the tail
** (supply) current and the output common-mode level.
** Bindings: DUT PORT_LINE VDD VCM IBIAS PDK_INCLUDE.
.include design.ngspice
.lib sm141064.ngspice noise_corner
.lib sm141064.ngspice nfet_03v3_t
.lib sm141064.ngspice pfet_03v3_t
.lib sm141064.ngspice fets_mm
.lib sm141064.ngspice res_typical
.lib sm141064.ngspice mimcap_typical
.lib sm141064.ngspice cap_mim
.temp 27

.param VDD=1.5
.param VCM=0.75
.param IBIAS=20u

Vdd   vdd 0 dc {VDD}
Vss   vss 0 dc 0
Ibias vdd ibias dc {IBIAS}
Vcm   vcm 0 dc {VCM}
Vinp  vinp vcm dc 0
Vinn  vinn vcm dc 0

XDUT vdd voutp voutn vinp vinn ibias vss dp_001_resistive_load

.control
  set filetype=ascii
  op
  let i_supply = abs(i(Vdd))
  let v_ocm = (v(voutp) + v(voutn)) / 2
  print i_supply
  print v_ocm
  write
  quit
.endc
.param x_dut_xmp_w=12u
.param x_dut_xmp_l=0.3u
.param x_dut_rp_value=22000
.param x_dut_xmt_w=24u
.param x_dut_xmr_l=0.3u
.param x_dut_xmt_m=1
.param x_dut_xmr_w=24u
.param x_dut_xmp_m=1
.param x_dut_xmn_m=1
.param x_dut_xmr_m=1
* ---- GENERATED parameter ties (abstract/params.yaml groups/ratios) ----
* Each tied symbol is defined exactly once, by its line below; rewrite that
* .param to untie just that symbol (untying = shadowing, plan D-3).
.param x_dut_xmn_w = {x_dut_xmp_w}
.param x_dut_xmn_l = {x_dut_xmp_l}
.param x_dut_xmt_l = {x_dut_xmr_l}
.param x_dut_rn_value = {x_dut_rp_value}
.subckt dp_001_resistive_load vdd voutp voutn vinp vinn ibias vss
RN vdd voutn x_dut_rn_value
RP vdd voutp x_dut_rp_value
XMN voutn vinn tail vss nfet_03v3 l=x_dut_xmn_l m=x_dut_xmn_m w=x_dut_xmn_w
XMP voutp vinp tail vss nfet_03v3 l=x_dut_xmp_l m=x_dut_xmp_m w=x_dut_xmp_w
XMR ibias ibias vss vss nfet_03v3 l=x_dut_xmr_l m=x_dut_xmr_m w=x_dut_xmr_w
XMT tail ibias vss vss nfet_03v3 l=x_dut_xmt_l m=x_dut_xmt_m w=x_dut_xmt_w
.ends
.end
