// Library name: SAR_11B_ZZS
// Cell name: LB_CUNIT_X3
// View name: schematic
// Inherited view list: spectre cmos_sch cmos.sch schematic veriloga ahdl
// pspice dspf
subckt LB_CUNIT_X3 BOT TOP
    C2 (TOP BOT) capacitor c=200.0a
    C1 (TOP BOT) capacitor c=200.0a
    C0 (TOP BOT) capacitor c=200.0a
ends LB_CUNIT_X3
// End of subcircuit definition.
