** GENERATED by `analog-db export-raw` — DO NOT EDIT.
** Standalone lowered DUT subckt for sw_003_binary_capbank on ihp-sg13g2 (sizing .param defaults + .subckt).
** Not a runnable deck on its own — include it under your own testbench:
**   .include _dut.spice
**   XDUT vinp vout VCM VDD VSS V_D0 V_D0_NOT V_D1 V_D1_NOT V_D2 V_D2_NOT sw_003_binary_capbank
** Source: pdk/ihp-sg13g2/netlist.spice (run `analog-db generate` to refresh).
*----------------------------------------------------------*
** params: 5 free + 6 frozen knobs (sizing.yaml) · 30 tied · 0 ratio-derived (abstract/params.yaml)
.param x_dut_xm1_w=0.15u
.param x_dut_xm1_l=0.13u
.param x_dut_xm2_w=0.15u
.param x_dut_xm2_l=0.13u
.param Cu=1p
.param x_dut_xm1_m=1
.param x_dut_xm2_m=1
.param x_dut_c1_m=1
.param x_dut_c2_m=1
.param x_dut_c3_m=2
.param x_dut_c4_m=4
* ---- GENERATED parameter ties (abstract/params.yaml groups/ratios) ----
* Each tied symbol is defined exactly once, by its line below; rewrite that
* .param to untie just that symbol (untying = shadowing, plan D-3).
.param x_dut_xm3_w = {x_dut_xm1_w}
.param x_dut_xm5_w = {x_dut_xm1_w}
.param x_dut_xm7_w = {x_dut_xm1_w}
.param x_dut_xm9_w = {x_dut_xm1_w}
.param x_dut_xm11_w = {x_dut_xm1_w}
.param x_dut_xm3_l = {x_dut_xm1_l}
.param x_dut_xm5_l = {x_dut_xm1_l}
.param x_dut_xm7_l = {x_dut_xm1_l}
.param x_dut_xm9_l = {x_dut_xm1_l}
.param x_dut_xm11_l = {x_dut_xm1_l}
.param x_dut_xm3_m = {x_dut_xm1_m}
.param x_dut_xm5_m = {x_dut_xm1_m}
.param x_dut_xm7_m = {x_dut_xm1_m}
.param x_dut_xm9_m = {x_dut_xm1_m}
.param x_dut_xm11_m = {x_dut_xm1_m}
.param x_dut_xm4_w = {x_dut_xm2_w}
.param x_dut_xm6_w = {x_dut_xm2_w}
.param x_dut_xm8_w = {x_dut_xm2_w}
.param x_dut_xm10_w = {x_dut_xm2_w}
.param x_dut_xm12_w = {x_dut_xm2_w}
.param x_dut_xm4_l = {x_dut_xm2_l}
.param x_dut_xm6_l = {x_dut_xm2_l}
.param x_dut_xm8_l = {x_dut_xm2_l}
.param x_dut_xm10_l = {x_dut_xm2_l}
.param x_dut_xm12_l = {x_dut_xm2_l}
.param x_dut_xm4_m = {x_dut_xm2_m}
.param x_dut_xm6_m = {x_dut_xm2_m}
.param x_dut_xm8_m = {x_dut_xm2_m}
.param x_dut_xm10_m = {x_dut_xm2_m}
.param x_dut_xm12_m = {x_dut_xm2_m}
.subckt sw_003_binary_capbank vinp vout VCM VDD VSS V_D0 V_D0_NOT V_D1 V_D1_NOT V_D2 V_D2_NOT
C1 vout vinp 'Cu' m=x_dut_c1_m
C2 vout bot0 'Cu' m=x_dut_c2_m
C3 vout bot1 'Cu' m=x_dut_c3_m
C4 vout bot2 'Cu' m=x_dut_c4_m
XM1 vinp V_D0 bot0 VSS sg13_lv_nmos l=x_dut_xm1_l m=x_dut_xm1_m w=x_dut_xm1_w
XM10 bot2 V_D2_NOT vinp VDD sg13_lv_pmos l=x_dut_xm10_l m=x_dut_xm10_m w=x_dut_xm10_w
XM11 VCM V_D2_NOT bot2 VSS sg13_lv_nmos l=x_dut_xm11_l m=x_dut_xm11_m w=x_dut_xm11_w
XM12 bot2 V_D2 VCM VDD sg13_lv_pmos l=x_dut_xm12_l m=x_dut_xm12_m w=x_dut_xm12_w
XM2 bot0 V_D0_NOT vinp VDD sg13_lv_pmos l=x_dut_xm2_l m=x_dut_xm2_m w=x_dut_xm2_w
XM3 VCM V_D0_NOT bot0 VSS sg13_lv_nmos l=x_dut_xm3_l m=x_dut_xm3_m w=x_dut_xm3_w
XM4 bot0 V_D0 VCM VDD sg13_lv_pmos l=x_dut_xm4_l m=x_dut_xm4_m w=x_dut_xm4_w
XM5 vinp V_D1 bot1 VSS sg13_lv_nmos l=x_dut_xm5_l m=x_dut_xm5_m w=x_dut_xm5_w
XM6 bot1 V_D1_NOT vinp VDD sg13_lv_pmos l=x_dut_xm6_l m=x_dut_xm6_m w=x_dut_xm6_w
XM7 VCM V_D1_NOT bot1 VSS sg13_lv_nmos l=x_dut_xm7_l m=x_dut_xm7_m w=x_dut_xm7_w
XM8 bot1 V_D1 VCM VDD sg13_lv_pmos l=x_dut_xm8_l m=x_dut_xm8_m w=x_dut_xm8_w
XM9 vinp V_D2 bot2 VSS sg13_lv_nmos l=x_dut_xm9_l m=x_dut_xm9_m w=x_dut_xm9_w
.ends
