** GENERATED by `analog-db export-raw` — DO NOT EDIT.
** Standalone lowered DUT subckt for sup_001_vcm_detector on ihp-sg13g2 (sizing .param defaults + .subckt).
** Not a runnable deck on its own — include it under your own testbench:
**   .include _dut.spice
**   XDUT vcm_out vinp vinn sup_001_vcm_detector
** Source: pdk/ihp-sg13g2/netlist.spice (run `analog-db generate` to refresh).
*----------------------------------------------------------*
** params: 1 free + 0 frozen knobs (sizing.yaml) · 1 tied · 0 ratio-derived (abstract/params.yaml)
.param x_dut_rmp_value=1Meg
* ---- GENERATED parameter ties (abstract/params.yaml groups/ratios) ----
* Each tied symbol is defined exactly once, by its line below; rewrite that
* .param to untie just that symbol (untying = shadowing, plan D-3).
.param x_dut_rmn_value = {x_dut_rmp_value}
.subckt sup_001_vcm_detector vcm_out vinp vinn
RMN vinn vcm_out 'x_dut_rmn_value'
RMP vcm_out vinp 'x_dut_rmp_value'
.ends
