** GENERATED by `analog-db generate` — DO NOT EDIT. Source: abstract/netlist.spice → ihp-sg13g2
* drv_001_pam4_sige_dac (emitted by spicexplorer-circuitgraph)
CDEGL0 e1L0 e2L0 {x_dut_cdeg_ff*1f}
CDEGM0 e1M0 e2M0 {x_dut_cdeg_ff*1f}
CDEGM1 e1M1 e2M1 {x_dut_cdeg_ff*1f}
GTAILL0 tlsb0 0 blsb 0 1m
GTAILM0 tmsb0 0 bmsb 0 1m
GTAILM1 tmsb1 0 bmsb 0 1m
RBLSBN lsbn vcmb {x_dut_rb}
RBLSBP lsbp vcmb {x_dut_rb}
RBMSBN msbn vcmb {x_dut_rb}
RBMSBP msbp vcmb {x_dut_rb}
RCN outn vcc {x_dut_rc}
RCP outp vcc {x_dut_rc}
RE1L0 e1L0 tlsb0 {x_dut_re}
RE1M0 e1M0 tmsb0 {x_dut_re}
RE1M1 e1M1 tmsb1 {x_dut_re}
RE2L0 e2L0 tlsb0 {x_dut_re}
RE2M0 e2M0 tmsb0 {x_dut_re}
RE2M1 e2M1 tmsb1 {x_dut_re}
XQ1L0 c1L0 lsbp e1L0 0 npn13G2 Nx=x_dut_nx
XQ1M0 c1M0 msbp e1M0 0 npn13G2 Nx=x_dut_nx
XQ1M1 c1M1 msbp e1M1 0 npn13G2 Nx=x_dut_nx
XQ2L0 c2L0 lsbn e2L0 0 npn13G2 Nx=x_dut_nx
XQ2M0 c2M0 msbn e2M0 0 npn13G2 Nx=x_dut_nx
XQ2M1 c2M1 msbn e2M1 0 npn13G2 Nx=x_dut_nx
XQ3L0 outp vcasc c1L0 0 npn13G2 Nx=x_dut_nx
XQ3M0 outp vcasc c1M0 0 npn13G2 Nx=x_dut_nx
XQ3M1 outp vcasc c1M1 0 npn13G2 Nx=x_dut_nx
XQ4L0 outn vcasc c2L0 0 npn13G2 Nx=x_dut_nx
XQ4M0 outn vcasc c2M0 0 npn13G2 Nx=x_dut_nx
XQ4M1 outn vcasc c2M1 0 npn13G2 Nx=x_dut_nx
.end
