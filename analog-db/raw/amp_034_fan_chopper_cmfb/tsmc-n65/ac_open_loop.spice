** GENERATED by `analog-db export-raw` — DO NOT EDIT.
** circuit=amp_034_fan_chopper_cmfb  class=amplifier  pdk=tsmc-n65  testbench=ac_open_loop  corner=tt
** Self-contained deck: testbench + bound params + lowered DUT (.subckt amp_034_fan_chopper_cmfb).
** PDK corner libs resolve by BARE NAME on the image's ngspice sourcepath — run in a
** PDK-enabled env (the base image / api container), NOT a bare host:
**   docker run --rm -i spicexplorer-spice-base:local \
**     bash -lc 'd=$(mktemp -d) && cat > $d/c.spice && cd $d && ngspice -b c.spice' < raw/amp_034_fan_chopper_cmfb/tsmc-n65/ac_open_loop.spice
*----------------------------------------------------------*
** params: 36 free + 15 frozen knobs (sizing.yaml) · 49 tied · 0 ratio-derived (abstract/params.yaml) · 3 testbench params
** AUTHORED TEMPLATE — amplifier/ac_open_loop_diff (fully-differential open-loop AC).
** Open-loop DIFFERENTIAL gain/phase of a self-biased FD OTA (internal current reference,
** no external ibias port; e.g. amp_020_two_stage_miller_cmfb). Differential input driven directly
** — no AnalogGym-style bias-wrap needed: unlike a single-ended amp with no output
** feedback of any kind, a genuinely SYMMETRIC differential topology driven by MATCHED
** (vinp=vinn=VCM) inputs gives a well-defined output OFFSET regardless of open-loop gain
** — both branches move together, not apart, so there is nothing for the gain to amplify
** into a rail. (The output COMMON MODE still has to be centered by sizing — see
** pdk/<pdk>/sizing.yaml — but that's a device-sizing concern, not a testbench one.)
**
** Required bindings: DUT (subckt name), PORT_LINE (instance port order = circuit.yaml
**   ports: vinp vinn voutp voutn vdd vss), VDD VCM CL, FSTART FSTOP PPD,
**   PDK_INCLUDE (.lib/.include lines for the bound PDK+corner).
*----------------------------------------------------------*
.lib tsmc_n65_models.scs tt
.temp 27

.param VDD=1.2
.param VCM=0.6
.param CL=10p

Vdd  vdd 0 dc {VDD}
Vss  vss 0 dc 0
CLoadp voutp 0 {CL}
CLoadn voutn 0 {CL}

* DUT instance (port order = circuit.yaml ports)
XDUT vinp vinn voutp voutn vdd vss amp_034_fan_chopper_cmfb

* --- input drive (AC open loop, differential) ---
Vcm  vcm 0 dc {VCM}
Vinp vinp vcm dc 0 ac 0.5
Vinn vinn vcm dc 0 ac -0.5

.control
  set filetype=ascii
  ac dec 101 10 1G
  let vodm = v(voutp) - v(voutn)
  * db()/cph() must be precomputed as their own vectors before use in .meas FIND/WHEN —
  * ngspice's vdb()/cph() shorthand only resolves against real circuit nodes, not a
  * `let`-derived vector like vodm, so a bare `FIND db(vodm)` fails to resolve.
  let dbvodm = db(vodm)
  meas ac dcgain  FIND dbvodm  AT=10
  meas ac ugf     WHEN dbvodm=0 FALL=1
  * cph() = continuous (unwrapped) phase — vp() wraps at +/-180 and corrupts PM for
  * multi-pole phase trajectories; normalize to the DC phase so PM = 180 - total phase lag.
  let phc = cph(vodm)*180/3.14159265
  let ph = 180 + phc - phc[0]
  meas ac pm      FIND ph WHEN dbvodm=0 FALL=1
  write
  quit
.endc
.param x_dut_xm4_cmfb_w=6.65u
.param x_dut_xm4_cmfb_l=1u
.param x_dut_xm2_cmfb_w=0.168u
.param x_dut_xm2_cmfb_l=6u
.param x_dut_xm1_cmfb_w=3.82u
.param x_dut_xm7_cmfb_w=0.180u
.param x_dut_xm7_cmfb_l=10u
.param x_dut_xm3_cmfb_w=1.91u
.param x_dut_xm3_cmfb_l=1u
.param x_dut_rmp_cmfb_value=1Meg
.param x_dut_xm1_cmfb_m=1
.param x_dut_xm2_cmfb_m=1
.param x_dut_xm3_cmfb_m=1
.param x_dut_xm4_cmfb_m=1
.param x_dut_xm7_cmfb_m=1
.param x_dut_xm1_core_w=5.629u
.param x_dut_xm1_core_l=1u
.param x_dut_xm2_core_w=4.933u
.param x_dut_xm2_core_l=0.5u
.param x_dut_xm4_core_w=2.51u
.param x_dut_xm4_core_l=1u
.param x_dut_xm6_core_w=2.814u
.param x_dut_xm10_core_w=2.398u
.param x_dut_xm10_core_l=0.3u
.param x_dut_xm12_core_w=0.792u
.param x_dut_xm12_core_l=0.3u
.param x_dut_xm14_core_w=1.043u
.param x_dut_xm14_core_l=0.25u
.param x_dut_xm16_core_w=2u
.param x_dut_xm16_core_l=0.13u
.param x_dut_xm17_core_w=2u
.param x_dut_xm17_core_l=0.13u
.param x_dut_cm1_core_value=2p
.param vb1_core=0.324117
.param vb2_core=0.472198
.param vb3_core=0.438401
.param vb4_core=0.785955
.param x_dut_xm1_core_m=1
.param x_dut_xm2_core_m=1
.param x_dut_xm4_core_m=1
.param x_dut_xm6_core_m=1
.param x_dut_xm10_core_m=1
.param x_dut_xm12_core_m=1
.param x_dut_xm14_core_m=1
.param x_dut_xm16_core_m=1
.param x_dut_xm17_core_m=1
.param vcm_ref=0.6
.param x_dut_xm8o_w=11.257u
.param x_dut_xm8o_l=1u
.param x_dut_xm8o_m=1
.param c_cm=5p
* ---- GENERATED parameter ties (abstract/params.yaml groups/ratios) ----
* Each tied symbol is defined exactly once, by its line below; rewrite that
* .param to untie just that symbol (untying = shadowing, plan D-3).
.param x_dut_xm9o_w = {x_dut_xm8o_w}
.param x_dut_xm9o_l = {x_dut_xm8o_l}
.param x_dut_xm9o_m = {x_dut_xm8o_m}
.param x_dut_xm5_cmfb_w = {x_dut_xm4_cmfb_w}
.param x_dut_xm5_cmfb_l = {x_dut_xm4_cmfb_l}
.param x_dut_xm5_cmfb_m = {x_dut_xm4_cmfb_m}
.param x_dut_xm6_cmfb_w = {x_dut_xm2_cmfb_w}
.param x_dut_xm6_cmfb_l = {x_dut_xm2_cmfb_l}
.param x_dut_xm6_cmfb_m = {x_dut_xm2_cmfb_m}
.param x_dut_rmn_cmfb_value = {x_dut_rmp_cmfb_value}
.param x_dut_xm3_core_w = {x_dut_xm2_core_w}
.param x_dut_xm3_core_l = {x_dut_xm2_core_l}
.param x_dut_xm3_core_m = {x_dut_xm2_core_m}
.param x_dut_xm5_core_w = {x_dut_xm4_core_w}
.param x_dut_xm5_core_l = {x_dut_xm4_core_l}
.param x_dut_xm5_core_m = {x_dut_xm4_core_m}
.param x_dut_xm13_core_w = {x_dut_xm12_core_w}
.param x_dut_xm13_core_l = {x_dut_xm12_core_l}
.param x_dut_xm13_core_m = {x_dut_xm12_core_m}
.param x_dut_xm11_core_w = {x_dut_xm10_core_w}
.param x_dut_xm11_core_l = {x_dut_xm10_core_l}
.param x_dut_xm11_core_m = {x_dut_xm10_core_m}
.param x_dut_xm7_core_w = {x_dut_xm6_core_w}
.param x_dut_xm7_core_m = {x_dut_xm6_core_m}
.param x_dut_xm6_core_l = {x_dut_xm1_core_l}
.param x_dut_xm7_core_l = {x_dut_xm1_core_l}
.param x_dut_xm15_core_w = {x_dut_xm14_core_w}
.param x_dut_xm15_core_l = {x_dut_xm14_core_l}
.param x_dut_xm15_core_m = {x_dut_xm14_core_m}
.param x_dut_xm18_core_w = {x_dut_xm16_core_w}
.param x_dut_xm20_core_w = {x_dut_xm16_core_w}
.param x_dut_xm22_core_w = {x_dut_xm16_core_w}
.param x_dut_xm18_core_l = {x_dut_xm16_core_l}
.param x_dut_xm20_core_l = {x_dut_xm16_core_l}
.param x_dut_xm22_core_l = {x_dut_xm16_core_l}
.param x_dut_xm18_core_m = {x_dut_xm16_core_m}
.param x_dut_xm20_core_m = {x_dut_xm16_core_m}
.param x_dut_xm22_core_m = {x_dut_xm16_core_m}
.param x_dut_xm19_core_w = {x_dut_xm17_core_w}
.param x_dut_xm21_core_w = {x_dut_xm17_core_w}
.param x_dut_xm23_core_w = {x_dut_xm17_core_w}
.param x_dut_xm19_core_l = {x_dut_xm17_core_l}
.param x_dut_xm21_core_l = {x_dut_xm17_core_l}
.param x_dut_xm23_core_l = {x_dut_xm17_core_l}
.param x_dut_xm19_core_m = {x_dut_xm17_core_m}
.param x_dut_xm21_core_m = {x_dut_xm17_core_m}
.param x_dut_xm23_core_m = {x_dut_xm17_core_m}
.param x_dut_cm2_core_value = {x_dut_cm1_core_value}
.param x_dut_xm1_cmfb_l = {x_dut_xm3_cmfb_l}
.param x_dut_xm20_core_w = {x_dut_xm16_core_w}
.param x_dut_xm20_core_l = {x_dut_xm16_core_l}
.param x_dut_xm20_core_m = {x_dut_xm16_core_m}
.param x_dut_xm23_core_w = {x_dut_xm17_core_w}
.param x_dut_xm23_core_l = {x_dut_xm17_core_l}
.param x_dut_xm23_core_m = {x_dut_xm17_core_m}
.param x_dut_xm22_core_w = {x_dut_xm18_core_w}
.param x_dut_xm22_core_l = {x_dut_xm18_core_l}
.param x_dut_xm22_core_m = {x_dut_xm18_core_m}
.param x_dut_xm21_core_w = {x_dut_xm19_core_w}
.param x_dut_xm21_core_l = {x_dut_xm19_core_l}
.param x_dut_xm21_core_m = {x_dut_xm19_core_m}
.subckt amp_034_fan_chopper_cmfb vinp vinn voutp voutn vdd vss
CCM vb4o vss 'c_cm'
CM1_CORE core__g2_p voutp 'x_dut_cm1_core_value'
CM2_CORE core__g2_n voutn 'x_dut_cm2_core_value'
RMN_CMFB voutn cmfb__cm_sense 'x_dut_rmn_cmfb_value'
RMP_CMFB cmfb__cm_sense voutp 'x_dut_rmp_cmfb_value'
VB1_CORE core__vb1 vss dc {vb1_core}
VB2_CORE core__vb2 vss dc {vb2_core}
VB3_CORE core__vb3 vss dc {vb3_core}
VB4_CORE core__vb4 vss dc {vb4_core}
VREFCM vref_cm vss dc {vcm_ref}
XM10_CORE core__out1_n core__vb3 core__casc_src_n vdd pch_lvt l=x_dut_xm10_core_l m=x_dut_xm10_core_m w=x_dut_xm10_core_w
XM11_CORE core__out1_p core__vb3 core__casc_src_p vdd pch_lvt l=x_dut_xm11_core_l m=x_dut_xm11_core_m w=x_dut_xm11_core_w
XM12_CORE core__out1_p core__vb2 core__fold_p vss nch_lvt l=x_dut_xm12_core_l m=x_dut_xm12_core_m w=x_dut_xm12_core_w
XM13_CORE core__out1_n core__vb2 core__fold_n vss nch_lvt l=x_dut_xm13_core_l m=x_dut_xm13_core_m w=x_dut_xm13_core_w
XM14_CORE voutp core__g2_p vss vss nch_lvt l=x_dut_xm14_core_l m=x_dut_xm14_core_m w=x_dut_xm14_core_w
XM15_CORE voutn core__g2_n vss vss nch_lvt l=x_dut_xm15_core_l m=x_dut_xm15_core_m w=x_dut_xm15_core_w
XM16_CORE core__out1_n vdd core__g2_n vss nch_lvt l=x_dut_xm16_core_l m=x_dut_xm16_core_m w=x_dut_xm16_core_w
XM17_CORE core__g2_n vss core__out1_n vdd pch_lvt l=x_dut_xm17_core_l m=x_dut_xm17_core_m w=x_dut_xm17_core_w
XM18_CORE core__out1_p vdd core__g2_p vss nch_lvt l=x_dut_xm18_core_l m=x_dut_xm18_core_m w=x_dut_xm18_core_w
XM19_CORE core__g2_p vss core__out1_p vdd pch_lvt l=x_dut_xm19_core_l m=x_dut_xm19_core_m w=x_dut_xm19_core_w
XM1_CMFB cmfb__ptail cmfb__bias vdd vdd pch_lvt l=x_dut_xm1_cmfb_l m=x_dut_xm1_cmfb_m w=x_dut_xm1_cmfb_w
XM1_CORE core__tail core__vb4 vdd vdd pch_lvt l=x_dut_xm1_core_l m=x_dut_xm1_core_m w=x_dut_xm1_core_w
XM20_CORE core__out1_p vss core__g2_n vss nch_lvt l=x_dut_xm20_core_l m=x_dut_xm20_core_m w=x_dut_xm20_core_w
XM21_CORE core__g2_n vdd core__out1_p vdd pch_lvt l=x_dut_xm21_core_l m=x_dut_xm21_core_m w=x_dut_xm21_core_w
XM22_CORE core__out1_n vss core__g2_p vss nch_lvt l=x_dut_xm22_core_l m=x_dut_xm22_core_m w=x_dut_xm22_core_w
XM23_CORE core__g2_p vdd core__out1_n vdd pch_lvt l=x_dut_xm23_core_l m=x_dut_xm23_core_m w=x_dut_xm23_core_w
XM2_CMFB vb4o cmfb__mirr vss vss nch_lvt l=x_dut_xm2_cmfb_l m=x_dut_xm2_cmfb_m w=x_dut_xm2_cmfb_w
XM2_CORE core__fold_p vinp core__tail vdd pch_lvt l=x_dut_xm2_core_l m=x_dut_xm2_core_m w=x_dut_xm2_core_w
XM3_CMFB cmfb__bias cmfb__bias vdd vdd pch_lvt l=x_dut_xm3_cmfb_l m=x_dut_xm3_cmfb_m w=x_dut_xm3_cmfb_w
XM3_CORE core__fold_n vinn core__tail vdd pch_lvt l=x_dut_xm3_core_l m=x_dut_xm3_core_m w=x_dut_xm3_core_w
XM4_CMFB cmfb__mirr cmfb__cm_sense cmfb__ptail vdd pch_lvt l=x_dut_xm4_cmfb_l m=x_dut_xm4_cmfb_m w=x_dut_xm4_cmfb_w
XM4_CORE core__fold_p core__vb1 vss vss nch_lvt l=x_dut_xm4_core_l m=x_dut_xm4_core_m w=x_dut_xm4_core_w
XM5_CMFB vb4o vref_cm cmfb__ptail vdd pch_lvt l=x_dut_xm5_cmfb_l m=x_dut_xm5_cmfb_m w=x_dut_xm5_cmfb_w
XM5_CORE core__fold_n core__vb1 vss vss nch_lvt l=x_dut_xm5_core_l m=x_dut_xm5_core_m w=x_dut_xm5_core_w
XM6_CMFB cmfb__mirr cmfb__mirr vss vss nch_lvt l=x_dut_xm6_cmfb_l m=x_dut_xm6_cmfb_m w=x_dut_xm6_cmfb_w
XM6_CORE core__casc_src_n core__vb4 vdd vdd pch_lvt l=x_dut_xm6_core_l m=x_dut_xm6_core_m w=x_dut_xm6_core_w
XM7_CMFB cmfb__bias cmfb__bias vss vss nch_lvt l=x_dut_xm7_cmfb_l m=x_dut_xm7_cmfb_m w=x_dut_xm7_cmfb_w
XM7_CORE core__casc_src_p core__vb4 vdd vdd pch_lvt l=x_dut_xm7_core_l m=x_dut_xm7_core_m w=x_dut_xm7_core_w
XM8O voutp vb4o vdd vdd pch_lvt l=x_dut_xm8o_l m=x_dut_xm8o_m w=x_dut_xm8o_w
XM9O voutn vb4o vdd vdd pch_lvt l=x_dut_xm9o_l m=x_dut_xm9o_m w=x_dut_xm9o_w
.ends
.end
