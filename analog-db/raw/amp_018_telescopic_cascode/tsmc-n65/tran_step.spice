** GENERATED by `analog-db export-raw` — DO NOT EDIT.
** circuit=amp_018_telescopic_cascode  class=amplifier  pdk=tsmc-n65  testbench=tran_step  corner=tt
** Self-contained deck: testbench + bound params + lowered DUT (.subckt amp_018_telescopic_cascode).
** PDK corner libs resolve by BARE NAME on the image's ngspice sourcepath — run in a
** PDK-enabled env (the base image / api container), NOT a bare host:
**   docker run --rm -i spicexplorer-spice-base:local \
**     bash -lc 'd=$(mktemp -d) && cat > $d/c.spice && cd $d && ngspice -b c.spice' < raw/amp_018_telescopic_cascode/tsmc-n65/tran_step.spice
*----------------------------------------------------------*
** params: 15 free + 10 frozen knobs (sizing.yaml) · 8 tied · 0 ratio-derived (abstract/params.yaml) · 5 testbench params
** AUTHORED TEMPLATE — universal/tran_step (plan D-4): unity-gain step → slew + settling.
** Bindings: DUT PORT_LINE VDD VCM IBIAS CL
**   VSTEP TSTEP TSTOP PDK_INCLUDE.
.lib tsmc_n65_models.scs tt
.temp 27

.param VDD=1.2
.param VCM=0.8
.param IBIAS=5u
.param CL=10p

Vdd  vdd 0 dc {VDD}
Vss  vss 0 dc 0
Ibias vdd ibias dc {IBIAS}
CLoad vout 0 {CL}

* unity-gain follower: vinn shorted to vout (0 V source = ideal feedback wire)
.param VSTEP=0.2
Vinp vinp 0 dc {VCM} pulse({VCM} {VCM+VSTEP} 1u 1n 1n 1 1)
Vfb  vinn vout dc 0

XDUT vdd vout vinp vinn ibias vss amp_018_telescopic_cascode

.control
  set filetype=ascii
  tran 1n 5u
  * settle to the FINAL value, not the input — a follower's systematic offset would
  * otherwise keep |vout - vinp| outside a tight tolerance band forever.
  meas tran vfinal FIND v(vout) AT=5u
  let verr = abs(v(vout) - vfinal)
  meas tran tcross WHEN verr=2m FALL=LAST
  let t_settle = tcross - 1u
  print t_settle
  write
  quit
.endc
.param x_dut_xm1_w=27.241u
.param x_dut_xm1_l=0.246u
.param x_dut_xm1c_w=48.148u
.param x_dut_xm1c_l=5.274u
.param x_dut_xm3_w=99.145u
.param x_dut_xm3_l=1.391u
.param x_dut_xm3c_w=78.432u
.param x_dut_xm3c_l=4.589u
.param x_dut_xm5_w=170.082u
.param x_dut_xm5_l=0.505u
.param x_dut_xm5_ng=2
.param x_dut_xm6_w=118.161u
.param x_dut_xm6_l=9.666u
.param x_dut_v_bias_1=0.509
.param x_dut_v_bias_2=1.032
.param x_dut_xm1_m=1
.param x_dut_xm2_m=1
.param x_dut_xm1c_m=1
.param x_dut_xm2c_m=1
.param x_dut_xm3_m=1
.param x_dut_xm4_m=1
.param x_dut_xm3c_m=1
.param x_dut_xm4c_m=1
.param x_dut_xm5_m=1
.param x_dut_xm6_m=1
* ---- GENERATED parameter ties (abstract/params.yaml groups/ratios) ----
* Each tied symbol is defined exactly once, by its line below; rewrite that
* .param to untie just that symbol (untying = shadowing, plan D-3).
.param x_dut_xm2_w = {x_dut_xm1_w}
.param x_dut_xm2_l = {x_dut_xm1_l}
.param x_dut_xm2c_w = {x_dut_xm1c_w}
.param x_dut_xm2c_l = {x_dut_xm1c_l}
.param x_dut_xm4_w = {x_dut_xm3_w}
.param x_dut_xm4_l = {x_dut_xm3_l}
.param x_dut_xm4c_w = {x_dut_xm3c_w}
.param x_dut_xm4c_l = {x_dut_xm3c_l}
.subckt amp_018_telescopic_cascode vdd vout vinp vinn ibias vss
V1 vdd gate_pc x_dut_v_bias_2
V2 casc_n tail x_dut_v_bias_1
XM1 d1 vinp tail vss nch_lvt l=x_dut_xm1_l m=x_dut_xm1_m w=x_dut_xm1_w
XM1C gate_p casc_n d1 vss nch_lvt l=x_dut_xm1c_l m=x_dut_xm1c_m w=x_dut_xm1c_w
XM2 d2 vinn tail vss nch_lvt l=x_dut_xm2_l m=x_dut_xm2_m w=x_dut_xm2_w
XM2C vout casc_n d2 vss nch_lvt l=x_dut_xm2c_l m=x_dut_xm2c_m w=x_dut_xm2c_w
XM3 s3 gate_p vdd vdd pch_lvt l=x_dut_xm3_l m=x_dut_xm3_m w=x_dut_xm3_w
XM3C gate_p gate_pc s3 vdd pch_lvt l=x_dut_xm3c_l m=x_dut_xm3c_m w=x_dut_xm3c_w
XM4 s4 gate_p vdd vdd pch_lvt l=x_dut_xm4_l m=x_dut_xm4_m w=x_dut_xm4_w
XM4C vout gate_pc s4 vdd pch_lvt l=x_dut_xm4c_l m=x_dut_xm4c_m w=x_dut_xm4c_w
XM5 tail ibias vss vss nch_lvt l=x_dut_xm5_l m=x_dut_xm5_m nf=x_dut_xm5_ng w=x_dut_xm5_w
XM6 ibias ibias vss vss nch_lvt l=x_dut_xm6_l m=x_dut_xm6_m w=x_dut_xm6_w
.ends
.end
