** GENERATED by `analog-db export-raw` — DO NOT EDIT.
** circuit=amp_031_srmc_core_cmfb  class=amplifier  pdk=ihp-sg13g2  testbench=psrr_vdd  corner=tt
** Self-contained deck: testbench + bound params + lowered DUT (.subckt amp_031_srmc_core_cmfb).
** PDK corner libs resolve by BARE NAME on the image's ngspice sourcepath — run in a
** PDK-enabled env (the base image / api container), NOT a bare host:
**   docker run --rm -i spicexplorer-spice-base:local \
**     bash -lc 'd=$(mktemp -d) && cat > $d/c.spice && cd $d && ngspice -b c.spice' < raw/amp_031_srmc_core_cmfb/ihp-sg13g2/psrr_vdd.spice
*----------------------------------------------------------*
** params: 22 free + 6 frozen knobs (sizing.yaml) · 17 tied · 0 ratio-derived (abstract/params.yaml) · 3 testbench params
** AUTHORED TEMPLATE — amplifier/psrr_vdd_diff: positive-supply rejection of a fully-
** differential (self-biased, voutp/voutn) DUT, in the same CM-pinned differential
** unity-feedback network stb_diff uses.
**
** CONFIGURATION (see stb_diff.spice for the full why). The differential loop is closed by two
** ideal VCVSs, fbn/fbp = VCM +/- (voutp-voutn)/2, feeding the inputs through quiet 0 V sources;
** the input CM is pinned at VCM and the DC operating point is the matched-inputs-at-VCM point
** of dc_op_diff/ac_open_loop_diff. No CM loop is closed by the bench — the output CM is left to
** the DUT's own CMFB; small-signal, so it works regardless of CMFB quality.
**
** STIMULUS + MATH (the exact FD analog of psrr_vdd.spice). The supply Vdd carries a 1 V AC
** ripple and every input is AC-quiet, so all AC at the output is supply feed-through. With
** A_vd = the supply -> differential-output gain and the loop holding vin_d = -vout_d:
**     vout_d = A_vd*vac + Add*vin_d  =>  vout_d = A_vd/(1+Add) * vac,
** the closed-loop (buffer-application) differential supply feed-through, so
** psrr_vdd_db = -20*log10|vout_d| (vac = 1), read at FSTART (the DC-band floor) — the same
** loop-suppressed figure the SE bench reports for the unity buffer.
**
** SOLVER-RESOLUTION CEILING (why the 1e-15 floor exists — same argument as cmrr_vcm_diff, in
** full there). On a perfectly symmetric netlist the supply disturbs both half-circuits
** identically, the TRUE A_vd of the deck is zero, and the solved vout_d is matrix round-off
** (~1e-16 of the ~1 V node signals). The `+ 1e-15` magnitude floor caps the reportable figure
** at 300 dB and keeps -db() finite; a psrr_vdd_db at or near 300 means "beyond what the solver
** can resolve on a symmetric netlist", NOT a physical rejection (real PSRR- and PSRR+ of FD
** silicon are mismatch-set). Treat anything above ~200 dB as unresolved-by-construction.
**
** psrr_cm_db — the SECONDARY, always-physical figure. The OUTPUT-CM response to the same
** ripple, vocm = (voutp+voutn)/2, psrr_cm_db = -db|vocm|: the supply rejection of the cell's
** CM path (CMFB loop included). It is finite even on a perfect netlist — supply ripple feeds
** the CM of both branches with the same sign, nothing cancels — so it is the number that
** actually discriminates between FD cells whose differential figure saturates the solver.
** (Not a canonical datasheet metric; it rides the scoreboard entry's analyses block.)
**
** DIFFERENTIAL-GAIN CORRECTION (downstream, scoreboard.record). psrr_cm_db here is the RAW CM
** supply residual -db|vocm|, NOT yet a rejection FIGURE. PSRR is (differential gain)/(supply
** gain), so the physical FD PSRR+ adds the differential open-loop gain back:
** psrr_cm_corr_db = dc_gain_db + psrr_cm_db (the SE unity-buffer psrr_vdd_db folds this in via
** its closed loop; the FD CM path does not, so the term is added when the scoreboard entry is
** assembled). psrr_cm_corr_db is the figure the paper prints.
**
** Bindings: DUT PORT_LINE VDD VCM CL FSTART FSTOP PPD PDK_INCLUDE.
.lib cornerMOSlv.lib mos_tt
.temp 27

.param VDD=1.2
.param VCM=0.5
.param CL=10p

Vdd  vdd 0 dc {VDD} ac 1     ; 1 V supply-ripple stimulus
Vss  vss 0 dc 0
CLoadp voutp 0 {CL}
CLoadn voutn 0 {CL}

* differential unity feedback, CM pinned at VCM (see stb_diff.spice); inputs AC-quiet —
* isolate the supply path
Vcm  vcm 0 dc {VCM}
Efbn fbn vcm voutp voutn 0.5
Efbp fbp vcm voutp voutn -0.5
Vfbn vinn fbn dc 0
Vfbp vinp fbp dc 0

XDUT vinp vinn voutp voutn vdd vss amp_031_srmc_core_cmfb

.control
  set filetype=ascii
  ac dec 101 10 1G
  let vodm = v(voutp) - v(voutn)
  let vocm = (v(voutp) + v(voutn))/2
  * 1e-15 magnitude floor: caps the figure at 300 dB = "beyond solver resolution" (see header);
  * also keeps -db() finite on a bit-symmetric netlist whose true response is exactly 0.
  let psrr   = -db(mag(vodm) + 1e-15)
  let psrrcm = -db(mag(vocm) + 1e-15)
  meas ac psrr_vdd_db FIND psrr   AT=10
  meas ac psrr_cm_db  FIND psrrcm AT=10
  write
  quit
.endc
.param x_dut_xm3_w=1.929899553930193e-06
.param x_dut_xm3_l=7.17160573582043e-07
.param x_dut_xm6_w=4.333517676791642e-06
.param x_dut_xm6_l=5.543754544025163e-07
.param x_dut_xm5_w=2.65342774731541e-06
.param x_dut_xm5_l=4.862864381993593e-07
.param x_dut_xm8_w=2.8635900612133323e-06
.param x_dut_xm8_l=4.4416626216939937e-07
.param x_dut_xm1_w=2.0223959132588594e-06
.param x_dut_xm1_l=4.2775106088068857e-07
.param x_dut_xm2_w=1.5914426355899998e-06
.param x_dut_xm2_l=5.757246674262767e-07
.param x_dut_c1_value=5e-12
.param x_dut_r1_value=7.0e3
.param x_dut_rm1p_value=1Meg
.param gm_val=100u
.param rout_val=10Meg
.param rin_val=1.0e12
.param cout_val=300f
.param cin_val=1f
.param vb2=0.7002027602191484
.param vref_cm=0.5
.param x_dut_xm1_m=1
.param x_dut_xm2_m=1
.param x_dut_xm3_m=1
.param x_dut_xm5_m=1
.param x_dut_xm6_m=1
.param x_dut_xm8_m=1
* ---- GENERATED parameter ties (abstract/params.yaml groups/ratios) ----
* Each tied symbol is defined exactly once, by its line below; rewrite that
* .param to untie just that symbol (untying = shadowing, plan D-3).
.param x_dut_xm4_w = {x_dut_xm3_w}
.param x_dut_xm4_l = {x_dut_xm3_l}
.param x_dut_xm4_m = {x_dut_xm3_m}
.param x_dut_xm7_w = {x_dut_xm6_w}
.param x_dut_xm7_l = {x_dut_xm6_l}
.param x_dut_xm7_m = {x_dut_xm6_m}
.param x_dut_xm9_w = {x_dut_xm1_w}
.param x_dut_xm9_l = {x_dut_xm1_l}
.param x_dut_xm9_m = {x_dut_xm1_m}
.param x_dut_xm10_w = {x_dut_xm2_w}
.param x_dut_xm10_l = {x_dut_xm2_l}
.param x_dut_xm10_m = {x_dut_xm2_m}
.param x_dut_c2_value = {x_dut_c1_value}
.param x_dut_r2_value = {x_dut_r1_value}
.param x_dut_rm1n_value = {x_dut_rm1p_value}
.param x_dut_rm2p_value = {x_dut_rm1p_value}
.param x_dut_rm2n_value = {x_dut_rm1p_value}
.subckt amp_031_srmc_core_cmfb vinp vinn voutp voutn vdd vss
C1 vo1n zc_p 'x_dut_c1_value'
C2 vo1p zc_n 'x_dut_c2_value'
CIN1 cm1_det vref_cm1 'cin_val'
CIN2 cm2_det vref_cm2 'cin_val'
COUT1 vss vcmfb1 'cout_val'
COUT2 vss vcmfb2 'cout_val'
GM1 vss vcmfb1 cm1_det vref_cm1 {gm_val}
GM2 vss vcmfb2 cm2_det vref_cm2 {gm_val}
R1 zc_p voutp 'x_dut_r1_value'
R2 zc_n voutn 'x_dut_r2_value'
RIN1 cm1_det vref_cm1 'rin_val'
RIN2 cm2_det vref_cm2 'rin_val'
RM1N vo1n cm1_det 'x_dut_rm1n_value'
RM1P cm1_det vo1p 'x_dut_rm1p_value'
RM2N voutn cm2_det 'x_dut_rm2n_value'
RM2P cm2_det voutp 'x_dut_rm2p_value'
ROUT1 vss vcmfb1 'rout_val'
ROUT2 vss vcmfb2 'rout_val'
VB2 vb2 vss dc {vb2}
VREF1 vref_cm1 vss dc {vref_cm}
VREF2 vref_cm2 vss dc {vref_cm}
XM1 voutp vo1n vss vss sg13_lv_nmos l=x_dut_xm1_l m=x_dut_xm1_m w=x_dut_xm1_w
XM10 voutn vcmfb2 vdd vdd sg13_lv_pmos l=x_dut_xm10_l m=x_dut_xm10_m w=x_dut_xm10_w
XM2 voutp vcmfb2 vdd vdd sg13_lv_pmos l=x_dut_xm2_l m=x_dut_xm2_m w=x_dut_xm2_w
XM3 vo1n vinp ntail vss sg13_lv_nmos l=x_dut_xm3_l m=x_dut_xm3_m w=x_dut_xm3_w
XM4 vo1p vinn ntail vss sg13_lv_nmos l=x_dut_xm4_l m=x_dut_xm4_m w=x_dut_xm4_w
XM5 ntail vb2 vss vss sg13_lv_nmos l=x_dut_xm5_l m=x_dut_xm5_m w=x_dut_xm5_w
XM6 vo1p vinn ptail vdd sg13_lv_pmos l=x_dut_xm6_l m=x_dut_xm6_m w=x_dut_xm6_w
XM7 vo1n vinp ptail vdd sg13_lv_pmos l=x_dut_xm7_l m=x_dut_xm7_m w=x_dut_xm7_w
XM8 ptail vcmfb1 vdd vdd sg13_lv_pmos l=x_dut_xm8_l m=x_dut_xm8_m w=x_dut_xm8_w
XM9 voutn vo1p vss vss sg13_lv_nmos l=x_dut_xm9_l m=x_dut_xm9_m w=x_dut_xm9_w
.ends
.end
