** Abstract classic PTAT reference core.
** AUTHORED source of truth (plan D-2). PDK-neutral model tokens (nmos/pmos + an ideal R); per-PDK
** device names + geometry come from circuitgraph lowering + pdk/<pdk>/{devices.map,sizing}.yaml.
** Subckt port order (= circuit.yaml ports): vdd vout vss
**
** Topology (AnalogGym "Sensing Front End" / PTAT_CLASSIC): a self-biased PTAT current reference.
**   XM3/XM4 = PMOS current mirror (XM3 diode-connected reference at vmir, XM4 the output leg).
**   XM0/XM1 = NMOS pair; XM1 diode-connected, XM0 source-degenerated by R0. The Vgs difference of
**            the (deliberately W-mismatched) pair develops across R0, setting a PTAT current the
**            mirror copies.
** Output choice: `vout` is exposed at the R0 top node (XM0 source), i.e. the PTAT voltage I·R0 —
** GROUND-referenced and supply-independent. (The upstream `vsense` = the PMOS-mirror diode node
** sits at VDD-|Vsg| and merely tracks the supply, so it is kept internal as `vmir`.)
** A W ratio XM0:XM1 (default 4:1) makes the loop bias at a non-degenerate PTAT current on the open
** PDKs (the upstream 1:1 upstream-foundry sizing sits at the trivial I=0 fixed point off-technology).
XM3 vmir vmir vdd vdd pmos w=x_dut_xm3_w l=x_dut_xm3_l m=x_dut_xm3_m
XM4 net1 vmir vdd vdd pmos w=x_dut_xm4_w l=x_dut_xm4_l m=x_dut_xm4_m
XM0 vmir net1 vout vout nmos w=x_dut_xm0_w  l=x_dut_xm0_l m=x_dut_xm0_m
XM1 net1 net1 vss  vss  nmos w=x_dut_xm1_w l=x_dut_xm1_l m=x_dut_xm1_m
R0  vout vss r=x_r0
.end
