** AUTHORED TEMPLATE — temp_sensor/line_sweep (plan D-4): supply (line) sensitivity of a PTAT
** sensor. Sweeps the supply and reports the output %-change over the swept range, referred to the
** nominal-supply output. Bindings: DUT PORT_LINE VDD, VDD_LO VDD_HI VDD_STEP, PDK_INCLUDE.
${PDK_INCLUDE}

.param VDD=${VDD}

Vdd  vdd 0 dc {VDD}
Vss  vss 0 dc 0

${PORT_LINE} ${DUT}

.control
  set filetype=ascii
  dc Vdd ${VDD_LO} ${VDD_HI} ${VDD_STEP}
  meas dc v_at_lo  FIND v(vout) AT=${VDD_LO}
  meas dc v_at_hi  FIND v(vout) AT=${VDD_HI}
  meas dc v_at_nom FIND v(vout) AT=${VDD}
  let line_sens_pct = abs((v_at_hi - v_at_lo) / v_at_nom) * 100
  print line_sens_pct
  write
  quit
.endc
.end
