** GENERATED by `analog-db export-raw` — DO NOT EDIT.
** circuit=amp_001_5t  class=amplifier  pdk=ihp-sg13g2  testbench=iip3  corner=tt
** Self-contained deck: testbench + bound params + lowered DUT (.subckt amp_001_5t).
** PDK corner libs resolve by BARE NAME on the image's ngspice sourcepath — run in a
** PDK-enabled env (the base image / api container), NOT a bare host:
**   docker run --rm -i spicexplorer-spice-base:local \
**     bash -lc 'd=$(mktemp -d) && cat > $d/c.spice && cd $d && ngspice -b c.spice' < raw/amp_001_5t/ihp-sg13g2/iip3.spice
*----------------------------------------------------------*
** params: 8 free + 4 frozen knobs (sizing.yaml) · 6 tied · 0 ratio-derived (abstract/params.yaml) · 5 testbench params
** AUTHORED TEMPLATE — amplifier/iip3: two-tone third-order intercept in the unity buffer.
** Two equal-amplitude tones (ASIG at F1 and F2, series-stacked on the input, offset VCM)
** intermodulate through the DUT; the IM3 products at 2F1-F2 / 2F2-F1 set the intercept.
** F1/F2 MUST share a common fundamental F0 = gcd(F1,F2) (e.g. 0.9/1.0 MHz -> 100 kHz):
** ngspice lane: plain tran written to the raw — the platform registry computes
** {meas: iip3_dbv, f1, f2, ampl_in} by coherent FFT at F0 (tones + IM3 are exact bins).
** Spectre lane: the platform composes a NATIVE pss at F0 instead (tones + IM3 are plain
** harmonics of the fd-PSF -> {meas: iip3_pss_*}); ngspice has no PSS. The record must
** capture whole beat periods: TSTOP >= a few / F0.
** Bindings: DUT PORT_LINE VDD VCM IBIAS CL ASIG F1 F2 TSTEP TSTOP PDK_INCLUDE.
.lib cornerMOSlv.lib mos_tt
.temp 27

.param VDD=1.5
.param VCM=0.8
.param IBIAS=20u
.param CL=50f
.param ASIG=0.05

Vdd  vdd 0 dc {VDD}
Vss  vss 0 dc 0
Ibias vdd ibias dc {IBIAS}
CLoad vout 0 {CL}

* unity buffer; two series-stacked tones — the lower source carries the VCM offset
Vton vinp mid sin(0 {ASIG} 0.9e6)
Vtwo mid  0   sin({VCM} {ASIG} 1.0e6)
Vfb  vinn vout dc 0

XDUT vdd vout vinp vinn ibias vss amp_001_5t

.control
  set filetype=ascii
  tran 25n 100u
  write
  quit
.endc
.param x_dut_xm1_w=0.5u
.param x_dut_xm1_l=5.0u
.param x_dut_xm3_w=1.5u
.param x_dut_xm3_l=5.0u
.param x_dut_xm5_w=2.0u
.param x_dut_xm5_l=5.0u
.param x_dut_xm6_w=2.0u
.param x_dut_xm6_l=5.0u
.param x_dut_xm1_m=1
.param x_dut_xm3_m=1
.param x_dut_xm5_m=1
.param x_dut_xm6_m=1
* ---- GENERATED parameter ties (abstract/params.yaml groups/ratios) ----
* Each tied symbol is defined exactly once, by its line below; rewrite that
* .param to untie just that symbol (untying = shadowing, plan D-3).
.param x_dut_xm2_w = {x_dut_xm1_w}
.param x_dut_xm2_l = {x_dut_xm1_l}
.param x_dut_xm2_m = {x_dut_xm1_m}
.param x_dut_xm4_w = {x_dut_xm3_w}
.param x_dut_xm4_l = {x_dut_xm3_l}
.param x_dut_xm4_m = {x_dut_xm3_m}
.subckt amp_001_5t vdd vout vinp vinn ibias vss
XM1 outm vinp tail vss sg13_lv_nmos l=x_dut_xm1_l m=x_dut_xm1_m w=x_dut_xm1_w
XM2 vout vinn tail vss sg13_lv_nmos l=x_dut_xm2_l m=x_dut_xm2_m w=x_dut_xm2_w
XM3 outm outm vdd vdd sg13_lv_pmos l=x_dut_xm3_l m=x_dut_xm3_m w=x_dut_xm3_w
XM4 vout outm vdd vdd sg13_lv_pmos l=x_dut_xm4_l m=x_dut_xm4_m w=x_dut_xm4_w
XM5 tail ibias vss vss sg13_lv_nmos l=x_dut_xm5_l m=x_dut_xm5_m w=x_dut_xm5_w
XM6 ibias ibias vss vss sg13_lv_nmos l=x_dut_xm6_l m=x_dut_xm6_m w=x_dut_xm6_w
.ends
.end
