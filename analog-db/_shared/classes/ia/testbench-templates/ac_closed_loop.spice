** AUTHORED TEMPLATE — amplifier/ac_closed_loop (plan D-4).
** Unity-gain buffer AC response: vinn shorted to vout (0 V source). This is the
** analog-circuit-design CACE "voltage buffer" measurement (gain ~1, -3 dB bandwidth).
** Bindings: DUT PORT_LINE VDD VCM IBIAS CL FSTART FSTOP PPD PDK_INCLUDE.
${PDK_INCLUDE}

.param VDD=${VDD}
.param VCM=${VCM}
.param IBIAS=${IBIAS}
.param CL=${CL}

Vdd  vdd 0 dc {VDD}
Vss  vss 0 dc 0
Ibias vdd ibias dc {IBIAS}
CLoad vout 0 {CL}

Vinp vinp 0 dc {VCM} ac 1
Vfb  vinn vout dc 0

${PORT_LINE} ${DUT}

.control
  set filetype=ascii
  ac dec ${PPD} ${FSTART} ${FSTOP}
  meas ac gain_cl FIND vmag(vout) AT=${FSTART}
  let g3db = gain_cl/sqrt(2)
  meas ac bw_cl WHEN vmag(vout)=g3db FALL=1
  write
  quit
.endc
.end
