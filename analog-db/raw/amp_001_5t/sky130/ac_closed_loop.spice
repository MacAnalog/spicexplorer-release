** GENERATED by `analog-db export-raw` — DO NOT EDIT.
** circuit=amp_001_5t  class=amplifier  pdk=sky130  testbench=ac_closed_loop  corner=tt
** Self-contained deck: testbench + bound params + lowered DUT (.subckt amp_001_5t).
** PDK corner libs resolve by BARE NAME on the image's ngspice sourcepath — run in a
** PDK-enabled env (the base image / api container), NOT a bare host:
**   docker run --rm -i spicexplorer-spice-base:local \
**     bash -lc 'd=$(mktemp -d) && cat > $d/c.spice && cd $d && ngspice -b c.spice' < raw/amp_001_5t/sky130/ac_closed_loop.spice
*----------------------------------------------------------*
** params: 8 free + 4 frozen knobs (sizing.yaml) · 6 tied · 0 ratio-derived (abstract/params.yaml) · 4 testbench params
** AUTHORED TEMPLATE — amplifier/ac_closed_loop (plan D-4).
** Unity-gain buffer AC response: vinn shorted to vout (0 V source). This is the
** analog-circuit-design CACE "voltage buffer" measurement (gain ~1, -3 dB bandwidth).
** Bindings: DUT PORT_LINE VDD VCM IBIAS CL FSTART FSTOP PPD PDK_INCLUDE.
.lib sky130.lib.spice tt
.temp 27

.param VDD=1.5
.param VCM=0.8
.param IBIAS=20u
.param CL=10p

Vdd  vdd 0 dc {VDD}
Vss  vss 0 dc 0
Ibias vdd ibias dc {IBIAS}
CLoad vout 0 {CL}

Vinp vinp 0 dc {VCM} ac 1
Vfb  vinn vout dc 0

XDUT vdd vout vinp vinn ibias vss amp_001_5t

.control
  set filetype=ascii
  ac dec 101 1k 1G
  meas ac gain_cl FIND vmag(vout) AT=1k
  let g3db = gain_cl/sqrt(2)
  meas ac bw_cl WHEN vmag(vout)=g3db FALL=1
  write
  quit
.endc
.param x_dut_xm1_w=1.0
.param x_dut_xm1_l=2.0
.param x_dut_xm3_w=2.0
.param x_dut_xm3_l=2.0
.param x_dut_xm5_w=3.0
.param x_dut_xm5_l=2.0
.param x_dut_xm6_w=3.0
.param x_dut_xm6_l=2.0
.param x_dut_xm1_m=1
.param x_dut_xm3_m=1
.param x_dut_xm5_m=1
.param x_dut_xm6_m=1
* ---- GENERATED parameter ties (abstract/params.yaml groups/ratios) ----
* Each tied symbol is defined exactly once, by its line below; rewrite that
* .param to untie just that symbol (untying = shadowing, plan D-3).
.param x_dut_xm2_w = {x_dut_xm1_w}
.param x_dut_xm2_l = {x_dut_xm1_l}
.param x_dut_xm2_m = {x_dut_xm1_m}
.param x_dut_xm4_w = {x_dut_xm3_w}
.param x_dut_xm4_l = {x_dut_xm3_l}
.param x_dut_xm4_m = {x_dut_xm3_m}
.subckt amp_001_5t vdd vout vinp vinn ibias vss
XM1 outm vinp tail vss sky130_fd_pr__nfet_01v8 l=x_dut_xm1_l m=x_dut_xm1_m w=x_dut_xm1_w
XM2 vout vinn tail vss sky130_fd_pr__nfet_01v8 l=x_dut_xm2_l m=x_dut_xm2_m w=x_dut_xm2_w
XM3 outm outm vdd vdd sky130_fd_pr__pfet_01v8 l=x_dut_xm3_l m=x_dut_xm3_m w=x_dut_xm3_w
XM4 vout outm vdd vdd sky130_fd_pr__pfet_01v8 l=x_dut_xm4_l m=x_dut_xm4_m w=x_dut_xm4_w
XM5 tail ibias vss vss sky130_fd_pr__nfet_01v8 l=x_dut_xm5_l m=x_dut_xm5_m w=x_dut_xm5_w
XM6 ibias ibias vss vss sky130_fd_pr__nfet_01v8 l=x_dut_xm6_l m=x_dut_xm6_m w=x_dut_xm6_w
.ends
.end
