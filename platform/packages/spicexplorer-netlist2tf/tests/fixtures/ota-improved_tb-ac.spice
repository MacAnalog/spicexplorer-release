** sch_path: ota-improved_tb-ac.sch
**.subckt ota-improved_tb-ac
Vdd v_dd GND VDD
xota v_dd v_out v_in v_out net1 v_ena v_ss ota-improved
Vss v_ss GND 0
C1 v_out v_ss CL m=1
Vin v_in v_ss dc V_CM ac 1
I0 v_dd net1 5u
Venable v_ena v_ss VDD
.save v(v_in)
.save v(v_out)
.save v(v_ena)
**** begin user architecture code

.lib cornerMOSlv.lib mos_tt
.lib cornerRES.lib res_typ

.temp 27
.control
    option sparse
    save all
    op
    write
    set appendwrite

    ac dec 101 1k 1G
    * plot 20*log10(v_out)

    meas ac dcgain MAX vmag(v_out) FROM=10 TO=10k
    let f3db = dcgain/sqrt(2)
    meas ac fbw WHEN vmag(v_out)=f3db FALL=1
    let gainerror=(dcgain-1)/1
    print dcgain
    print fbw
    print gainerror

    noise v(v_out) Vin dec 101 1k 100MEG 1000
    print onoise_total

    write
.endc

.include ota-improved_tb-ac.save

.param X_DUT_V_BIAS_1 = 0.6
.param X_DUT_V_BIAS_2 = 0.5

.param X_DUT_M5_L = 5u
.param X_DUT_M5_W = 6u
.param X_DUT_M5_NG = 3

.param X_DUT_M6_L = 5u
.param X_DUT_M6_W = 2u

.param X_DUT_M1M2_L = .5u
.param X_DUT_M1M2_W = 1u

.param X_DUT_M1CM2C_L = .5u
.param X_DUT_M1CM2C_W = 1u

.param X_DUT_M3CM4C_L = .5u
.param X_DUT_M3CM4C_W = 3u

.param X_DUT_M3M4_L = .5u
.param X_DUT_M3M4_W = 3u

.param VDD = 1.5
.param CL = 50f
.param V_CM = 0.8

**** end user architecture code
**.ends

* expanding   symbol:  ota-improved.sym # of pins=7
** sym_path: ota-improved.sym
** sch_path: ota-improved.sch
.subckt ota-improved vdd vout vinp vinn ibias_5u d_ena vss
*.ipin ibias_5u
*.iopin vdd
*.iopin vss
*.ipin vinp
*.ipin vinn
*.opin vout
*.ipin d_ena
XM5 net6 gate vss vss sg13_lv_nmos w=X_DUT_M5_W l=X_DUT_M5_L ng=X_DUT_M5_NG m=1
XM4 net2 gate_p vdd vdd sg13_lv_pmos w=X_DUT_M3M4_W l=X_DUT_M3M4_L ng=1 m=1
XM1 net4 vinp tail vss sg13_lv_nmos w=X_DUT_M1M2_W l=X_DUT_M1M2_L ng=1 m=1
XM2 net5 vinn tail vss sg13_lv_nmos w=X_DUT_M1M2_W l=X_DUT_M1M2_L ng=1 m=1
XM3 net3 gate_p vdd vdd sg13_lv_pmos w=X_DUT_M3M4_W l=X_DUT_M3M4_L ng=1 m=1
XM6 net1 gate vss vss sg13_lv_nmos w=X_DUT_M6_W l=X_DUT_M6_L ng=1 m=1
XMpd5 gate ena_n vss vss sg13_lv_nmos w=1u l=0.13u ng=1 m=1
XMpd3 ena ena_n vss vss sg13_lv_nmos w=1u l=0.13u ng=1 m=1
XMpd4 ena ena_n vdd vdd sg13_lv_pmos w=1u l=0.13u ng=1 m=1
XMpd6 net1 ena gate vss sg13_lv_nmos w=1u l=0.13u ng=1 m=1
XM2c vout dp_casc net5 vss sg13_lv_nmos w=X_DUT_M1CM2C_W l=X_DUT_M1CM2C_L ng=1 m=1
XM1c gate_p dp_casc net4 vss sg13_lv_nmos w=X_DUT_M1CM2C_W l=X_DUT_M1CM2C_L ng=1 m=1
XM4c vout gate_pc net2 vdd sg13_lv_pmos w=X_DUT_M3CM4C_W l=X_DUT_M3CM4C_L ng=1 m=1
XM3c gate_p gate_pc net3 vdd sg13_lv_pmos w=X_DUT_M3CM4C_W l=X_DUT_M3CM4C_L ng=1 m=1
XMpd8 gate_p ena vdd vdd sg13_lv_pmos w=1u l=0.13u ng=1 m=1
Vmeas1 tail net6 0
.save i(vmeas1)
XMpd1 ena_n d_ena vss vss sg13_lv_nmos w=1u l=0.13u ng=1 m=1
XMpd2 ena_n d_ena vdd vdd sg13_lv_pmos w=1u l=0.13u ng=1 m=1
Vmeas4 ibias_5u net1 0
.save i(vmeas4)
XMpd11 vout ena_n vss vss sg13_lv_nmos w=0.5u l=0.13u ng=1 m=1
XMdecoup1 vss gate vss vss sg13_lv_nmos w=8u l=1u ng=4 m=1
XMdecoup3 vdd gate_pc vdd vdd sg13_lv_pmos w=12u l=0.5u ng=4 m=1
V1 vdd gate_pc X_DUT_V_BIAS_2
V2 dp_casc tail X_DUT_V_BIAS_1
.ends

.GLOBAL GND
.end
