** AUTHORED TEMPLATE — amplifier/linearity_selfbias (2026-07-20): input common-mode range (ICMR)
** for SELF-BIASED DUTs (no ibias port). Identical to `linearity` except there is no external bias
** source — derived exactly as psrr_vdd_selfbias derives from psrr_vdd (drop `.param IBIAS` and the
** `Ibias` line), so a 5-port [vdd vout vinp vinn vss] DUT does not leave a current source driving
** a dangling `ibias` node (which makes the DC solve singular).
** ICMR via a buffer-connected DC sweep: the input range over which the follower tracks within
** VTRACK. The buffer-connected DC op point is the same one ac_open_loop_biaswrap already proves
** out for these DUTs, so biasing is safe.
** Bindings: DUT PORT_LINE VDD VCM CL VTRACK VSWEEP_STEP SLOPE_TOL PDK_INCLUDE.
${PDK_INCLUDE}

.param VDD=${VDD}
.param VCM=${VCM}
.param CL=${CL}

Vdd  vdd 0 dc {VDD}
Vss  vss 0 dc 0
CLoad vout 0 {CL}

* buffer-connected: vinn shorted to vout; sweep the common-mode input
Vinp vinp 0 dc {VCM}
Vfb  vinn vout dc 0

${PORT_LINE} ${DUT}

.control
  set filetype=ascii
  dc Vinp 0 ${VDD} ${VSWEEP_STEP}
  let verr = abs(v(vout) - v(vinp))
  * ICMR = widest CONTIGUOUS run of points that both track in absolute terms
  * (|verr| <= VTRACK) and are ACTIVE (dvout/dvin ~ 1). This mirrors the platform registry's
  * `{meas: icmr_range}` (spicexplorer_core waveforms.icmr_band) exactly, so the analog-db
  * run/verify lane and the optimizer lane report the same number.
  *
  * REWRITTEN 2026-07-20. The previous form was `meas dc ... WHEN verr=VTRACK CROSS=1/LAST`,
  * which was wrong two ways. (1) CROSS=1 finds the band EXIT on a DUT that already tracks at
  * vin=0, so the pair returned the complement of the real band — it read amp_022 as 0.105 V
  * against a true 1.400 V. (2) More fundamentally, an absolute-error test ALONE cannot tell
  * "the follower is tracking" from "both ends sit near the same rail": where the input pair
  * is cut off vout is pinned at a rail, and if vin is near that rail too then verr is small
  * by coincidence. That reported a 3.23 V band on a 3.3 V supply for amp_033. The slope test
  * rejects those dead points because a railed output has dvout/dvin ~ 0.
  let vsw = v(vinp)
  let dvout = deriv(v(vout))
  let dvin  = deriv(vsw)
  let slope = dvout / dvin
  let intrack = (verr <= ${VTRACK}) & (abs(slope - 1) <= ${SLOPE_TOL})
  let npts = length(intrack)
  let k = 0
  let best = 0
  let bstart = 0
  let bend = 0
  let cstart = 0
  let inband = 0
  while k < npts
    if intrack[k] > 0.5
      if inband < 0.5
        let cstart = vsw[k]
        let inband = 1
      end
      if (vsw[k] - cstart) > best
        let best = vsw[k] - cstart
        let bstart = cstart
        let bend = vsw[k]
      end
    else
      let inband = 0
    end
    let k = k + 1
  end
  let icmr_min = bstart
  let icmr_max = bend
  let icmr_range = best
  print icmr_min icmr_max icmr_range
  write
  quit
.endc
.end
