** GENERATED by `analog-db generate` — DO NOT EDIT. Source: abstract/netlist.spice → ihp-sg13g2
* ldo_010_capless_lowiq (emitted by spicexplorer-circuitgraph)
VLP lp_brk vout dc 0
VREF vref vss dc {vref_val}
XCC ea_out ea_o1 cap_cmim l=c_comp_w w=c_comp_w
XCFF lp_brk fb cap_cmim l=c_ff_w w=c_ff_w
XCOUT vout vss cap_cmim l=c_out_w m=c_out_m w=c_out_w
XM1A ea_n fb ea_tail vdd sg13_lv_pmos l=x_dut_xm1_l w={x_dut_xm1_w/2}
XM1B ea_n fb ea_tail vdd sg13_lv_pmos l=x_dut_xm1_l w={x_dut_xm1_w/2}
XM2A ea_o1 vref ea_tail vdd sg13_lv_pmos l=x_dut_xm1_l w={x_dut_xm1_w/2}
XM2B ea_o1 vref ea_tail vdd sg13_lv_pmos l=x_dut_xm1_l w={x_dut_xm1_w/2}
XM3A ea_n ea_n vss vss sg13_lv_nmos l=x_dut_xm3_l w={x_dut_xm3_w/2}
XM3B ea_n ea_n vss vss sg13_lv_nmos l=x_dut_xm3_l w={x_dut_xm3_w/2}
XM4A ea_o1 ea_n vss vss sg13_lv_nmos l=x_dut_xm3_l w={x_dut_xm3_w/2}
XM4B ea_o1 ea_n vss vss sg13_lv_nmos l=x_dut_xm3_l w={x_dut_xm3_w/2}
XM5 ea_out ea_o1 vss vss sg13_lv_nmos l=x_dut_xm5_l w=x_dut_xm5_w
XM6 ea_out pbias vdd vdd sg13_lv_pmos l=x_dut_xmbp_l w=x_dut_xm6_w
XMA x1 x1 vss vss sg13_lv_nmos l=x_dut_xma_l w=x_dut_xma_w
XMB y x1 vss vss sg13_lv_nmos l=x_dut_xma_l w=x_dut_xma_w
XMB0A nbias nbias vss vss sg13_lv_nmos l=x_dut_xmb0_l w={x_dut_xmb0_w/2}
XMB0B nbias nbias vss vss sg13_lv_nmos l=x_dut_xmb0_l w={x_dut_xmb0_w/2}
XMB1A pbias nbias vss vss sg13_lv_nmos l=x_dut_xmb0_l w={x_dut_xmb1_w/2}
XMB1B pbias nbias vss vss sg13_lv_nmos l=x_dut_xmb0_l w={x_dut_xmb1_w/2}
XMBP pbias pbias vdd vdd sg13_lv_pmos l=x_dut_xmbp_l w=x_dut_xmbp_w
XMC x1 ea_out vout vdd sg13_lv_pmos l=x_dut_xmc_l w=x_dut_xmc_w
XMCP y y vdd vdd sg13_lv_pmos l=x_dut_xmcp_l w=x_dut_xmcp_w
XMD gate y vdd vdd sg13_lv_pmos l=x_dut_xmcp_l w=x_dut_xmcp_w
XMP vout gate vdd vdd sg13_lv_pmos l=x_dut_xmp_l m={x_dut_xmp_m*x_dut_xmp_nf_mult} w={x_dut_xmp_w/x_dut_xmp_nf_mult}
XMSA gate nbias vss vss sg13_lv_nmos l=x_dut_xms_l w={x_dut_xms_w/2}
XMSB gate nbias vss vss sg13_lv_nmos l=x_dut_xms_l w={x_dut_xms_w/2}
XMT ea_tail pbias vdd vdd sg13_lv_pmos l=x_dut_xmbp_l w=x_dut_xmt_w
XR1_1 lp_brk n_r1_1 vss rhigh l={r_fb_l/8} w=r_w
XR1_2 n_r1_1 n_r1_2 vss rhigh l={r_fb_l/8} w=r_w
XR1_3 n_r1_2 n_r1_3 vss rhigh l={r_fb_l/8} w=r_w
XR1_4 n_r1_3 n_r1_4 vss rhigh l={r_fb_l/8} w=r_w
XR1_5 n_r1_4 n_r1_5 vss rhigh l={r_fb_l/8} w=r_w
XR1_6 n_r1_5 n_r1_6 vss rhigh l={r_fb_l/8} w=r_w
XR1_7 n_r1_6 n_r1_7 vss rhigh l={r_fb_l/8} w=r_w
XR1_8 n_r1_7 fb vss rhigh l={r_fb_l/8} w=r_w
XR2_1 fb n_r2_1 vss rhigh l={r_fb_l/8} w=r_w
XR2_2 n_r2_1 n_r2_2 vss rhigh l={r_fb_l/8} w=r_w
XR2_3 n_r2_2 n_r2_3 vss rhigh l={r_fb_l/8} w=r_w
XR2_4 n_r2_3 n_r2_4 vss rhigh l={r_fb_l/8} w=r_w
XR2_5 n_r2_4 n_r2_5 vss rhigh l={r_fb_l/8} w=r_w
XR2_6 n_r2_5 n_r2_6 vss rhigh l={r_fb_l/8} w=r_w
XR2_7 n_r2_6 n_r2_7 vss rhigh l={r_fb_l/8} w=r_w
XR2_8 n_r2_7 vss vss rhigh l={r_fb_l/8} w=r_w
XRB_1 vdd n_rb_1 vss rhigh l={r_bias_l/5} w=r_w
XRB_2 n_rb_1 n_rb_2 vss rhigh l={r_bias_l/5} w=r_w
XRB_3 n_rb_2 n_rb_3 vss rhigh l={r_bias_l/5} w=r_w
XRB_4 n_rb_3 n_rb_4 vss rhigh l={r_bias_l/5} w=r_w
XRB_5 n_rb_4 nbias vss rhigh l={r_bias_l/5} w=r_w
.end
