* TB[pam4] bias point (ramp and hold)
Vcc vcc 0 PWL(0 0 8n 4)
Vcasc vcasc 0 PWL(0 0 8n 3.25)
Vcmb vcmb 0 PWL(0 0 8n 1.9)
Vblsb blsb 0 PWL(0 0 8n 16)
Vbmsb bmsb 0 PWL(0 0 8n 16)
XDUT lsbp lsbn msbp msbn outp outn vcc vcasc vcmb blsb bmsb pam4drv_pam4
Rlp outp vcc 50
Rln outn vcc 50
Vslsbp slsbp 0 PWL(0 0 8n 1.9)
Vslsbn slsbn 0 PWL(0 0 8n 1.9)
Rslsbp slsbp lsbp 50
Rslsbn slsbn lsbn 50
Vsmsbp smsbp 0 PWL(0 0 8n 1.9)
Vsmsbn smsbn 0 PWL(0 0 8n 1.9)
Rsmsbp smsbp msbp 50
Rsmsbn smsbn msbn 50
.include ../dut/dut_pam4.spice
.lib "cornerHBT.lib" hbt_typ
.options gmin=1e-12 reltol=1e-3
.control
tran 0.0233333n 14n uic
wrdata bias.csv v(outp) v(xdut.c1L0) v(xdut.e1L0) v(xdut.tlsb0) v(xdut.c1M0) v(xdut.e1M0) v(xdut.tmsb0) i(Vcc)
.endc
.GLOBAL GND
.end
