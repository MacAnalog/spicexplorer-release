** GENERATED by `analog-db generate` — DO NOT EDIT. Source: abstract/netlist.spice → gf180mcu
* vref_001_vgs (emitted by spicexplorer-circuitgraph)
XM0 vdd vref vref vss nfet_03v3 l=x_dut_xm0_l m=x_dut_xm0_m w=x_dut_xm0_w
XM1 vref vref vss vss nfet_06v0 l=x_dut_xm1_l m=x_dut_xm1_m w=x_dut_xm1_w
.end
