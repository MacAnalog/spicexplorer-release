* TB[drv_001] MSB-path differential S21 (.op/.ac, ngspice-45)
* Emits: msb_gain_lf_db (S21 @ 1 GHz), msb_gain_50g_rel_db (S21 @ 50 GHz - LF, bandwidth proxy).
* Differential AC drive = 1 (0.5/-0.5); S21 is the power-wave 2*Vout/Vsrc into the 50 ohm/side ref.
.param x_dut_nx=3 x_dut_re=2.5 x_dut_cdeg_ff=20 x_dut_rc=50 x_dut_rb=50
.param x_dut_vcasc=3.25 x_dut_vcm_in=1.9 x_dut_itail_ma=16 x_dut_vcc=4
Vcc   vcc   0 DC {x_dut_vcc}
Vcasc vcasc 0 DC {x_dut_vcasc}
Vcmb  vcmb  0 DC {x_dut_vcm_in}
Vblsb blsb  0 DC {x_dut_itail_ma}
Vbmsb bmsb  0 DC {x_dut_itail_ma}
XDUT lsbp lsbn msbp msbn outp outn vcc vcasc vcmb blsb bmsb drv_001_pam4_sige_dac
Rlp outp vcc 50
Rln outn vcc 50
Vslsbp slsbp 0 DC {x_dut_vcm_in}
Vslsbn slsbn 0 DC {x_dut_vcm_in}
Rslsbp slsbp lsbp 50
Rslsbn slsbn lsbn 50
Vsmsbp smsbp 0 DC {x_dut_vcm_in} AC 0.5
Vsmsbn smsbn 0 DC {x_dut_vcm_in} AC -0.5
Rsmsbp smsbp msbp 50
Rsmsbn smsbn msbn 50
.include dut.spice
.lib "cornerHBT.lib" hbt_typ
.options gmin=1e-12 reltol=1e-3
.control
op
ac dec 20 1e8 1e11
let vodiff = v(outp)-v(outn)
let s21db = db(2*vodiff)
meas ac msb_gain_lf_db find s21db at=1e9
meas ac g50 find s21db at=50e9
let msb_gain_50g_rel_db = g50 - msb_gain_lf_db
print msb_gain_lf_db msb_gain_50g_rel_db
.endc
.GLOBAL GND
.end
