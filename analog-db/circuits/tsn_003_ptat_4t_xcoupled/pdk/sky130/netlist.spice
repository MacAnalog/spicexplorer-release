** GENERATED by `analog-db generate` — DO NOT EDIT. Source: abstract/netlist.spice → sky130
* tsn_003_ptat_4t_xcoupled (emitted by spicexplorer-circuitgraph)
XM0 vout na vss vss sky130_fd_pr__nfet_01v8 l=x_dut_xm0_l m=x_dut_xm0_m w=x_dut_xm0_w
XM1 na na vss vss sky130_fd_pr__nfet_01v8 l=x_dut_xm1_l m=x_dut_xm1_m w=x_dut_xm1_w
XM3 vout vout vdd vdd sky130_fd_pr__pfet_01v8 l=x_dut_xm3_l m=x_dut_xm3_m w=x_dut_xm3_w
XM4 na vout vdd vdd sky130_fd_pr__pfet_01v8 l=x_dut_xm4_l m=x_dut_xm4_m w=x_dut_xm4_w
.end
