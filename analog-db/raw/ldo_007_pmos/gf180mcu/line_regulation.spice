** GENERATED by `analog-db export-raw` — DO NOT EDIT.
** circuit=ldo_007_pmos  class=ldo  pdk=gf180mcu  testbench=line_regulation  corner=tt
** Self-contained deck: testbench + bound params + lowered DUT (.subckt ldo_007_pmos).
** PDK corner libs resolve by BARE NAME on the image's ngspice sourcepath — run in a
** PDK-enabled env (the base image / api container), NOT a bare host:
**   docker run --rm -i spicexplorer-spice-base:local \
**     bash -lc 'd=$(mktemp -d) && cat > $d/c.spice && cd $d && ngspice -b c.spice' < raw/ldo_007_pmos/gf180mcu/line_regulation.spice
*----------------------------------------------------------*
** params: 16 free + 0 frozen knobs (sizing.yaml) · 6 tied · 0 ratio-derived (abstract/params.yaml) · 0 testbench params
** AUTHORED TEMPLATE — ldo/line_regulation: DC Vin sweep at fixed load; delta-Vout (volts).
** Sweep the supply above the dropout knee so line_reg reflects the in-regulation range.
** Bindings: DUT PORT_LINE ILOAD VDD_START VDD_STOP VDD_STEP PDK_INCLUDE.
.include design.ngspice
.lib sm141064.ngspice noise_corner
.lib sm141064.ngspice nfet_03v3_t
.lib sm141064.ngspice pfet_03v3_t
.lib sm141064.ngspice fets_mm
.temp 27

Vdd  vdd 0 dc 1.4
Vss  vss 0 dc 0
Iload vout 0 dc 1m

XDUT vdd vout vss ldo_007_pmos

.control
  set filetype=ascii
  dc Vdd 1.4 2.0 0.05
  meas dc vout_max MAX v(vout)
  meas dc vout_min MIN v(vout)
  let line_reg = vout_max - vout_min
  print line_reg
  write
  quit
.endc
.param x_dut_xmp_w=20u
.param x_dut_xmp_m=140
.param x_dut_xmp_l=0.5u
.param x_dut_xm1_w=16u
.param x_dut_xm1_l=0.5u
.param x_dut_xm3_w=25u
.param x_dut_xm3_l=0.5u
.param x_dut_xm6_w=48u
.param x_dut_xm6_l=0.5u
.param r_top=5k
.param r_bot=35k
.param c_ff=60p
.param c_comp=0.05p
.param r_z=1
.param vref_val=1.05
.param i_tail=60u
* ---- GENERATED parameter ties (abstract/params.yaml groups/ratios) ----
* Each tied symbol is defined exactly once, by its line below; rewrite that
* .param to untie just that symbol (untying = shadowing, plan D-3).
.param x_dut_xm2_w = {x_dut_xm1_w}
.param x_dut_xm2_l = {x_dut_xm1_l}
.param x_dut_xm4_w = {x_dut_xm3_w}
.param x_dut_xm4_l = {x_dut_xm3_l}
.param x_dut_xm5_w = {x_dut_xm6_w}
.param x_dut_xm5_l = {x_dut_xm6_l}
.subckt ldo_007_pmos vdd vout vss
CC ncz vout 'c_comp'
CFF vout fb 'c_ff'
IBIAS vdd ebias dc {i_tail}
R1 vout fb 'r_top'
R2 fb vss 'r_bot'
RZ egate ncz 'r_z'
VREF vref vss dc {vref_val}
XM1 noutm fb etail vss nfet_03v3 l=x_dut_xm1_l w=x_dut_xm1_w
XM2 egate vref etail vss nfet_03v3 l=x_dut_xm2_l w=x_dut_xm2_w
XM3 noutm noutm vdd vdd pfet_03v3 l=x_dut_xm3_l w=x_dut_xm3_w
XM4 egate noutm vdd vdd pfet_03v3 l=x_dut_xm4_l w=x_dut_xm4_w
XM5 etail ebias vss vss nfet_03v3 l=x_dut_xm5_l w=x_dut_xm5_w
XM6 ebias ebias vss vss nfet_03v3 l=x_dut_xm6_l w=x_dut_xm6_w
XMP vout egate vdd vdd pfet_03v3 l=x_dut_xmp_l m=x_dut_xmp_m w=x_dut_xmp_w
.ends
.end
