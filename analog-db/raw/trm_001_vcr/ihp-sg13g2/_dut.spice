** GENERATED by `analog-db export-raw` — DO NOT EDIT.
** Standalone lowered DUT subckt for trm_001_vcr on ihp-sg13g2 (sizing .param defaults + .subckt).
** Not a runnable deck on its own — include it under your own testbench:
**   .include _dut.spice
**   XDUT vdd vcode vout vss trm_001_vcr
** Source: pdk/ihp-sg13g2/netlist.spice (run `analog-db generate` to refresh).
*----------------------------------------------------------*
** params: 4 free + 0 frozen knobs (sizing.yaml) · 0 tied · 0 ratio-derived (abstract/params.yaml)
.param x_dut_r0_value=200k
.param x_dut_xm0_w=2.0u
.param x_dut_xm0_l=0.5u
.param x_dut_xm0_m=1
.subckt trm_001_vcr vdd vcode vout vss
R0 vdd vout x_dut_r0_value
XM0 vout vcode vss vss sg13_lv_nmos l=x_dut_xm0_l m=x_dut_xm0_m w=x_dut_xm0_w
.ends
