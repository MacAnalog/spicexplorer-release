** GENERATED by `analog-db export-raw` — DO NOT EDIT.
** Standalone lowered DUT subckt for amp_032_ti_ldo_error_selfbias on sky130 (sizing .param defaults + .subckt).
** Not a runnable deck on its own — include it under your own testbench:
**   .include _dut.spice
**   XDUT vdd vout vinp vinn vss amp_032_ti_ldo_error_selfbias
** Source: pdk/sky130/netlist.spice (run `analog-db generate` to refresh).
*----------------------------------------------------------*
** params: 18 free + 0 frozen knobs (sizing.yaml) · 9 tied · 0 ratio-derived (abstract/params.yaml)
.param x_dut_xmbp_w=41.49398303677232
.param x_dut_xmbp_l=2.329224498945873
.param x_dut_xmb0_w=58.50180313844321
.param x_dut_xmb0_l=1.482196715977639
.param x_dut_xmbc_m=1
.param x_dut_xmbo_m=1
.param x_dut_xm1_w=54.99700606429666
.param x_dut_xm1_l=0.47938582647537475
.param x_dut_xm3_w=87.01219712226481
.param x_dut_xm3_l=3.4338542074883858
.param x_dut_xm4_w=96.52927518861148
.param x_dut_xm4_l=4.243509159874362
.param x_dut_xm6_w=22.347200240809872
.param x_dut_xm6_l=1.08924987055143
.param r_z=30158.889051230384
.param c_comp=1.0277210259907484e-11
.param x_dut_xmbf_w=9.512915640352748
.param r_nd=7561703.647450356
* ---- GENERATED parameter ties (abstract/params.yaml groups/ratios) ----
* Each tied symbol is defined exactly once, by its line below; rewrite that
* .param to untie just that symbol (untying = shadowing, plan D-3).
.param x_dut_xmbc_l = {x_dut_xmb0_l}
.param x_dut_xmbf_l = {x_dut_xmb0_l}
.param x_dut_xmbo_l = {x_dut_xmb0_l}
.param x_dut_xmbc_w = {x_dut_xmb0_w}
.param x_dut_xmbo_w = {x_dut_xmb0_w}
.param x_dut_xm2_w = {x_dut_xm1_w}
.param x_dut_xm2_l = {x_dut_xm1_l}
.param x_dut_xm5_w = {x_dut_xm3_w}
.param x_dut_xm5_l = {x_dut_xm3_l}
.subckt amp_032_ti_ldo_error_selfbias vdd vout vinp vinn vss
CC ncz vout 'c_comp'
RND na nd 'r_nd'
RZ nb ncz 'r_z'
XM1 na vinn tail vss sky130_fd_pr__nfet_01v8 l=x_dut_xm1_l w=x_dut_xm1_w
XM2 nb vinp tail vss sky130_fd_pr__nfet_01v8 l=x_dut_xm2_l w=x_dut_xm2_w
XM3 na nd vdd vdd sky130_fd_pr__pfet_01v8 l=x_dut_xm3_l w=x_dut_xm3_w
XM4 nlev na nd vdd sky130_fd_pr__pfet_01v8 l=x_dut_xm4_l w=x_dut_xm4_w
XM5 nb nd vdd vdd sky130_fd_pr__pfet_01v8 l=x_dut_xm5_l w=x_dut_xm5_w
XM6 vout nb vdd vdd sky130_fd_pr__pfet_01v8 l=x_dut_xm6_l w=x_dut_xm6_w
XMB0 ibias ibias vss vss sky130_fd_pr__nfet_01v8 l=x_dut_xmb0_l w=x_dut_xmb0_w
XMBC tail ibias vss vss sky130_fd_pr__nfet_01v8 l=x_dut_xmbc_l m=x_dut_xmbc_m w=x_dut_xmbc_w
XMBF nlev ibias vss vss sky130_fd_pr__nfet_01v8 l=x_dut_xmbf_l w=x_dut_xmbf_w
XMBO vout ibias vss vss sky130_fd_pr__nfet_01v8 l=x_dut_xmbo_l m=x_dut_xmbo_m w=x_dut_xmbo_w
XMBP ibias ibias vdd vdd sky130_fd_pr__pfet_01v8 l=x_dut_xmbp_l w=x_dut_xmbp_w
.ends
