** GENERATED by `analog-db export-raw` — DO NOT EDIT.
** circuit=amp_023_fer_fd2s  class=amplifier  pdk=gf180mcu  testbench=thd  corner=tt
** Self-contained deck: testbench + bound params + lowered DUT (.subckt amp_023_fer_fd2s).
** PDK corner libs resolve by BARE NAME on the image's ngspice sourcepath — run in a
** PDK-enabled env (the base image / api container), NOT a bare host:
**   docker run --rm -i spicexplorer-spice-base:local \
**     bash -lc 'd=$(mktemp -d) && cat > $d/c.spice && cd $d && ngspice -b c.spice' < raw/amp_023_fer_fd2s/gf180mcu/thd.spice
*----------------------------------------------------------*
** params: 20 free + 30 frozen knobs (sizing.yaml) · 44 tied · 0 ratio-derived (abstract/params.yaml) · 4 testbench params
** AUTHORED TEMPLATE — amplifier/thd_diff: large-signal harmonic distortion of a
** FULLY-DIFFERENTIAL amplifier in the differential unity-feedback (follower) connection.
** A single tone at F0 (differential amplitude ASIG, split +/- ASIG/2 antiphase about VCM)
** drives the closed loop; THD of the DIFFERENTIAL output v(voutp)-v(voutn) is computed
** IN-DECK by the same coherent single-bin DFT (harmonics 2..5, endpoint-duplication
** corrected) that thd.spice carries, so the runner's measure parser picks up thd_pct/thd_db
** directly. This is the structural fix thd.spice's dead-output guard points at: an FD member
** (voutp/voutn, no vout port) run through the single-ended deck leaves node `vout`
** capacitively fed and returns numbers from nothing — measured there: amp_023_fer_fd2s@ihp
** "thd_pct = 5.372 %", amp_027_fan_rrl_ota@ihp "3.537 %", all `status: ok`. This template
** gives those cells a real bench instead.
**
** THE FEEDBACK NETWORK IS tran_step_diff's, NOT A NEW ONE. The closed-loop operating point
** is held exactly the way tran_step_diff holds it: ONE feedback path, vinn <- voutp (a 0 V
** DC source = ideal wire), input common mode set by VCM on the vinp side. At DC this deck's
** two sin sources are 0 V, so the bias network below is tran_step_diff's network verbatim
** and the DUT sits at the SAME operating point its settling bench certifies (that is also
** where TSTART comes from — see the binding: TSTART >> that bench's t_settle).
** The tone is then split per the FD drive convention: +ASIG/2 rides the vinp side about
** VCM, and -ASIG/2 rides IN SERIES with the feedback wire (about voutp). The differential
** error the DUT sees is identical to putting the full ASIG on vinp, but the split HALVES
** the input common-mode wobble the one-wire follower unavoidably produces (vinn follows
** voutp, so the input CM moves with the signal; full-tone-on-vinp wobbles it at ~ASIG,
** the split at ~ASIG/2) — less CM pumping of the DUT's CMFB inside the measured window.
**
** CLOSED-LOOP GAIN IS 2, NOT 1 — READ gain_tone ACCORDINGLY. Only voutp is fed back, so
** the loop divider is vod/2 (feedback factor 1/2): vod = A*(VCM + ASIG*sin - vocm - vod/2)
** -> vod ~ 2*(VCM - vocm) + 2*ASIG*sin for large A. Three consequences, all deliberate:
**   1. gain_tone (a1/a1_in) ideally reads 2.0, and the dead-output threshold is 2/3 — the
**      |A| = 1 physical line for THIS configuration (gain_tone = 2A/(2+A), = 2/3 at A = 1),
**      the exact analogue of thd.spice's 0.5 = A/(1+A) line for the unity buffer.
**   2. The PER-SIDE output swing is ASIG (voutp = vocm' + ASIG*sin, voutn antiphase), i.e.
**      each output node swings exactly as far as the SE bench's vout does at the same ASIG
**      binding — that per-side-swing match is what makes thd_pct comparable across the SE
**      and FD variants. ASIG keeps its SE meaning: the applied differential stimulus peak.
**   3. vod carries a real DC term 2*(VCM - vocm) — the follower drags voutp to VCM while
**      the CMFB holds the output common mode at ITS reference, so voutn takes the offset.
**      It is reported as vod_op and stripped before the DFT (exactly cancelled by the
**      endpoint correction anyway — see thd.spice's measured proof); pick ASIG so
**      |vod_op|/2 + ASIG stays inside the per-side output swing, or the bench measures
**      clipping (which is honest, but not the small-signal-linearity number you wanted).
**
** DFT: byte-for-byte the thd.spice estimator — coherent single-bin DFT on an integer-period
** window WITH the endpoint-duplication correction ((mean(v*c)*np - v[0]*c[0])/nd). The full
** measured justification (window-phase null test: naive thd swings 2.95x / a3 41x with
** opening phase, corrected 1.000x; TSTEP convergence; the a4/a5 ~ 2|vac[0]|/np artifact
** tell) lives in thd.spice's header — it is the audited reference, do not fork the math.
** Requirements carried over unchanged: (TSTOP-TSTART) MUST be a whole number of F0 periods
** (a half-period mismatch is fatal even corrected — measured 63x on the SE bench), TSTART
** need not be phase-aligned but MUST clear the closed-loop settling transient, >= 8 measured
** periods, TSTEP <= 1/(200*F0). One FD-specific note, MEASURED on both pilots: do NOT
** expect the textbook "balanced FD cancels even harmonics" here — a2 DOMINATES thd_pct on
** both (amp_023@ihp a2 = 2.45e-5 vs a3 = 9.69e-7 at ASIG = 0.1; amp_027@ihp 2.54e-3 vs
** 1.83e-4 at 0.05), and it scales exactly as a real second-order term (a2/a1 halves per
** drive halving, 2.001x/1.998x measured; a3/a1 quarters, 4.02x/4.11x). The reason is this
** CONFIGURATION, not a broken DUT: the follower's own DC term vod_op parks voutp and voutn
** at DIFFERENT operating points (consequence 3 above), so branch symmetry — the thing that
** cancels even orders — is broken by the bench's operating point itself. The even
** harmonics are therefore real and belong in thd_pct; just don't read a2 > a3 as a defect.
**
** OUTPUT COMMON-MODE DRIFT (cm_drift_v) — THE TRUST CHECK THIS BENCH ADDS. An FD
** large-signal number taken while the output common mode is still walking is meaningless:
** the operating point (headroom, per-device gm) changes THROUGH the DFT window, so the
** "harmonics" partly measure the walk. The drift is measured from the same linearized
** record: vcm_rec = (voutp+voutn)/2, and cm_drift_v = mean(vcm_rec over the SECOND half of
** the window) - mean(over the FIRST half). Each half is an integer number of F0 periods
** whenever the window holds an EVEN number of periods (bind it so — e.g. 16), which makes
** the halves' means exactly tone-blind (a coherent sinusoid sums to zero over whole periods
** on the uniform post-linearize grid); a smooth settling drift survives as ~half the full
** start-to-end walk. Read it against ASIG: cm_drift_v << ASIG or the record is not
** stationary and thd_pct is not trustworthy — lengthen TSTART, don't explain the number.
** vocm_op (the full-record mean CM) is printed beside it as the achieved CM level.
**
** `write` runs BEFORE `linearize` (linearize swaps the current plot for its interpolated
** scratch copy and would gut the raw to the DFT leftovers — thd.spice's header has the
** measured story); the DFT basis vectors created after it never reach the raw, so no unlet
** is needed. Sentinels are the loud 999 (bad direction for thd_pct's minimize intent), NOT
** NaN (a NaN makes the runner discard the whole analysis). No `>` inside any `let` — the
** control preprocessor strips it as an output redirection and silently truncates the RHS;
** masks use `<=` and 1-mask.
**
** Measures: a1 a2 a3 a4 a5 (differential harmonic amplitudes, V), a1_in (measured
** differential drive), gain_tone (~2 when live), thd_pct, thd_db, vod_op (differential
** output DC term), vocm_op, cm_drift_v. Only thd_pct/thd_db are canonical metrics; every
** diagnostic name is deliberately OUT of raw_project._SPEC_REGISTRY (`vod_op` not
** `vout_dc`, `gain_tone` not `gain_cl`) so none silently becomes an optimizer objective.
** BINDING FORM: ASIG and F0 reach control-language arithmetic below, so they must be plain
** decimals / scientific notation (0.1, 1.0e6) — NOT SPICE suffixes (100m, 1Meg). TSTEP/
** TSTART/TSTOP only reach the `tran` card, so suffixes are fine there.
**
** Assumes a self-biased, differential-in/differential-out DUT port order:
**   .subckt <id> vinp vinn voutp voutn vdd vss
** Required bindings: DUT PORT_LINE VDD VCM CL ASIG F0 TSTEP TSTART TSTOP PDK_INCLUDE.
.include design.ngspice
.lib sm141064.ngspice noise_corner
.lib sm141064.ngspice nfet_03v3_t
.lib sm141064.ngspice pfet_03v3_t
.lib sm141064.ngspice fets_mm
.lib sm141064.ngspice res_typical
.lib sm141064.ngspice mimcap_typical
.lib sm141064.ngspice cap_mim
.temp 27

.param VDD=1.5
.param VCM=0.9
.param CL=10p
.param ASIG=0.1

Vdd  vdd 0 dc {VDD}
Vss  vss 0 dc 0
CLoadp voutp 0 {CL}
CLoadn voutn 0 {CL}
Vcm  vcm 0 dc {VCM}
* Seed the DC solve at the intended output common mode. An FD core whose CM loop has more
* than one equilibrium (a one-sided / behavioral CMFB actuator can wind its output far past
* the rails and sit there) otherwise lands in whichever basin the solver walks into, and the
* answer becomes a function of the bench topology instead of the circuit. MEASURED: a no-op
* on 18 of the 19 open-PDK cells (bit-identical measures) and the difference between a dead
* and a live amp_025@ihp-sg13g2 on the 19th.
.nodeset v(voutp)=0.9 v(voutn)=0.9

* DIFFERENTIAL-ONLY feedback (see header). Each input rides on a VCVS that carries ONLY the
* differential half of the output, referenced to VCM: vfbp = VCM - vod/4, vfbn = VCM + vod/4.
* So vid = ASIG*sin - vod/2 (feedback factor 1/2, closed-loop gain 2 — UNCHANGED) while the
* input common mode is pinned at VCM and carries no signal. The DUT's own CM control — or
* its absence — is then what sets vocm, which is the thing this bench is supposed to report.
Efbp vfbp vcm  voutn voutp 0.25
Efbn vfbn vcm  voutp voutn 0.25
Vinp vinp vfbp sin(0 {ASIG/2}  1.0e6)
Vinn vinn vfbn sin(0 {-ASIG/2} 1.0e6)

XDUT vinp vinn voutp voutn vdd vss amp_023_fer_fd2s

.control
  set filetype=ascii
  tran 2n 20u 4u
  * raw first — see the header; linearize below switches the current plot
  write
  let vd = v(voutp) - v(voutn)
  * the applied differential stimulus, reconstructed from its two halves: (vinp - vfbp) is
  * the +ASIG/2 source EMF, (vinn - vfbn) the -ASIG/2 one; their difference is the full
  * ASIG-peak differential drive — the dead-output guard's reference, measured, so a
  * mis-bound stimulus shows up as a1_in disagreeing with the ASIG binding.
  let vdrv = v(vinp) - v(vfbp) - v(vinn) + v(vfbn)
  * output common mode, for vocm_op + cm_drift_v
  let vcmr = 0.5*(v(voutp) + v(voutn))
  linearize vd vdrv vcmr
  let t = time
* --- endpoint-duplication correction (thd.spice's, verbatim): `linearize` hands back
* --- np = nd+1 points whose last sample repeats the first; mean()*np recovers the sum,
* --- subtracting v[0]*c[0] drops the duplicate, /nd gives the true rectangular-window
* --- average over one whole number of periods.
  let np = length(vd)
  let nd = np - 1
  let vod_op = (mean(vd)*np - vd[0])/nd
  * the DC strip is exactly cancelled by the correction (measured bit-identical on the SE
  * bench); kept because vod_op is reported anyway and `vac` reads clearer
  let vac = vd - vod_op
  let vin_ac = vdrv - mean(vdrv)
  let w = 2*pi*1.0e6
  let c1 = cos(w*t)
  let s1 = sin(w*t)
  let re1 = (mean(vac*c1)*np - vac[0]*c1[0])/nd
  let im1 = (mean(vac*s1)*np - vac[0]*s1[0])/nd
  let a1 = 2*sqrt(re1^2+im1^2)
* --- the SAME bin taken on the measured DRIVE — the dead-output guard's reference ---
  let rei = (mean(vin_ac*c1)*np - vin_ac[0]*c1[0])/nd
  let imi = (mean(vin_ac*s1)*np - vin_ac[0]*s1[0])/nd
  let a1_in = 2*sqrt(rei^2+imi^2)
  let c2 = cos(2*w*t)
  let s2 = sin(2*w*t)
  let re2 = (mean(vac*c2)*np - vac[0]*c2[0])/nd
  let im2 = (mean(vac*s2)*np - vac[0]*s2[0])/nd
  let a2 = 2*sqrt(re2^2+im2^2)
  let c3 = cos(3*w*t)
  let s3 = sin(3*w*t)
  let re3 = (mean(vac*c3)*np - vac[0]*c3[0])/nd
  let im3 = (mean(vac*s3)*np - vac[0]*s3[0])/nd
  let a3 = 2*sqrt(re3^2+im3^2)
  let c4 = cos(4*w*t)
  let s4 = sin(4*w*t)
  let re4 = (mean(vac*c4)*np - vac[0]*c4[0])/nd
  let im4 = (mean(vac*s4)*np - vac[0]*s4[0])/nd
  let a4 = 2*sqrt(re4^2+im4^2)
  let c5 = cos(5*w*t)
  let s5 = sin(5*w*t)
  let re5 = (mean(vac*c5)*np - vac[0]*c5[0])/nd
  let im5 = (mean(vac*s5)*np - vac[0]*s5[0])/nd
  let a5 = 2*sqrt(re5^2+im5^2)
* --- output common-mode drift over the record (see the header): half-window means, each an
* --- integer number of periods when the bound window is an even period count, so the tone
* --- cancels exactly and only the walk survives. Full-record mean = vocm_op.
  let vocm_op = (mean(vcmr)*np - vcmr[0])/nd
  let nh = floor(nd/2)
  let cm_first = mean(vcmr[0, nh-1])
  let cm_last  = mean(vcmr[nd-nh, nd-1])
  let cm_drift_v = cm_last - cm_first
* --- DEAD-OUTPUT GUARD (see the header): a MEASURED gain, not a NaN check. Threshold 2/3 =
* --- the |A| = 1 line for this gain-2 configuration (gain_tone = 2A/(2+A)). Do NOT write
* --- `>` inside a `let` — the control preprocessor strips it as an output redirection and
* --- silently truncates the RHS. Masks use `<=`, inverted with 1 - mask.
  let gain_tone = a1/(a1_in + 1e-18)
  let dead = (gain_tone <= 0.6667)
  let live = 1 - dead
  * the 1e-18 floors keep a dead output (a1 == 0) from emitting inf/NaN, which makes the
  * runner throw away the WHOLE analysis; they sit 12+ decades below any real amplitude
  let thd_raw = 100*sqrt(a2^2+a3^2+a4^2+a5^2)/(a1+1e-18)
  let thd_pct = live*thd_raw + dead*999
  let thd_db = 20*log10(thd_pct/100 + 1e-18)
  print a1 a2 a3 a4 a5 a1_in gain_tone thd_pct thd_db vod_op vocm_op cm_drift_v
  quit
.endc
.param x_dut_xmbd_w=4u
.param x_dut_xmpd1_w=6u
.param x_dut_xmpd2_w=1.5u
.param x_dut_xmnd1_w=0.75u
.param x_dut_xmi1_w=6u
.param x_dut_xmsa_w=6u
.param x_dut_xmca_w=6u
.param x_dut_xmna_w=4u
.param x_dut_xmka_w=3u
.param x_dut_xm2a_w=8u
.param x_dut_xmla_w=6u
.param x_dut_xmepd_w=3u
.param x_dut_xmncd_w=1.5u
.param x_dut_xmbd_l=0.4u
.param x_dut_xmi1_l=0.3u
.param x_dut_xmca_l=0.28u
.param x_dut_rza_value=1500
.param x_dut_cca_value=2e-12
.param x_dut_rca_value=2e5
.param x_dut_cma_value=150e-15
.param x_ibias_val=20e-6
.param x_vcmr_val=0.75
.param x_dut_xmbd_m=1
.param x_dut_xmb1_m=1
.param x_dut_xmpd1_m=1
.param x_dut_xmb2_m=1
.param x_dut_xmpd2_m=1
.param x_dut_xmpm1_m=1
.param x_dut_xmnd1_m=1
.param x_dut_xmt_m=2
.param x_dut_xmi1_m=2
.param x_dut_xmi2_m=2
.param x_dut_xmsa_m=2
.param x_dut_xmsb_m=2
.param x_dut_xmca_m=1
.param x_dut_xmcb_m=1
.param x_dut_xmna_m=1
.param x_dut_xmnb_m=1
.param x_dut_xmka_m=1
.param x_dut_xmkb_m=1
.param x_dut_xm2a_m=4
.param x_dut_xm2b_m=4
.param x_dut_xmla_m=6
.param x_dut_xmlb_m=6
.param x_dut_xmea1_m=1
.param x_dut_xmea2_m=1
.param x_dut_xmepd_m=1
.param x_dut_xmepm_m=2
.param x_dut_xmncd_m=1
.param x_dut_xmeat_m=1
* ---- GENERATED parameter ties (abstract/params.yaml groups/ratios) ----
* Each tied symbol is defined exactly once, by its line below; rewrite that
* .param to untie just that symbol (untying = shadowing, plan D-3).
.param x_dut_xmb1_l = {x_dut_xmbd_l}
.param x_dut_xmpd1_l = {x_dut_xmbd_l}
.param x_dut_xmb2_l = {x_dut_xmbd_l}
.param x_dut_xmpd2_l = {x_dut_xmbd_l}
.param x_dut_xmpm1_l = {x_dut_xmbd_l}
.param x_dut_xmnd1_l = {x_dut_xmbd_l}
.param x_dut_xmt_l = {x_dut_xmbd_l}
.param x_dut_xmsa_l = {x_dut_xmbd_l}
.param x_dut_xmsb_l = {x_dut_xmbd_l}
.param x_dut_xmka_l = {x_dut_xmbd_l}
.param x_dut_xmkb_l = {x_dut_xmbd_l}
.param x_dut_xmla_l = {x_dut_xmbd_l}
.param x_dut_xmlb_l = {x_dut_xmbd_l}
.param x_dut_xmepd_l = {x_dut_xmbd_l}
.param x_dut_xmepm_l = {x_dut_xmbd_l}
.param x_dut_xmncd_l = {x_dut_xmbd_l}
.param x_dut_xmeat_l = {x_dut_xmbd_l}
.param x_dut_xmb1_w = {x_dut_xmbd_w}
.param x_dut_xmb2_w = {x_dut_xmbd_w}
.param x_dut_xmt_w = {x_dut_xmbd_w}
.param x_dut_xmea1_w = {x_dut_xmbd_w}
.param x_dut_xmea2_w = {x_dut_xmbd_w}
.param x_dut_xmeat_w = {x_dut_xmbd_w}
.param x_dut_xmpm1_w = {x_dut_xmpd1_w}
.param x_dut_xmi2_l = {x_dut_xmi1_l}
.param x_dut_xm2a_l = {x_dut_xmi1_l}
.param x_dut_xm2b_l = {x_dut_xmi1_l}
.param x_dut_xmi2_w = {x_dut_xmi1_w}
.param x_dut_xmsb_w = {x_dut_xmsa_w}
.param x_dut_xmcb_l = {x_dut_xmca_l}
.param x_dut_xmna_l = {x_dut_xmca_l}
.param x_dut_xmnb_l = {x_dut_xmca_l}
.param x_dut_xmea1_l = {x_dut_xmca_l}
.param x_dut_xmea2_l = {x_dut_xmca_l}
.param x_dut_xmcb_w = {x_dut_xmca_w}
.param x_dut_xmnb_w = {x_dut_xmna_w}
.param x_dut_xmkb_w = {x_dut_xmka_w}
.param x_dut_xm2b_w = {x_dut_xm2a_w}
.param x_dut_xmlb_w = {x_dut_xmla_w}
.param x_dut_xmepm_w = {x_dut_xmepd_w}
.param x_dut_rzb_value = {x_dut_rza_value}
.param x_dut_ccb_value = {x_dut_cca_value}
.param x_dut_rcb_value = {x_dut_rca_value}
.param x_dut_cmb_value = {x_dut_cma_value}
.subckt amp_023_fer_fd2s vinp vinn voutp voutn vdd vss
CCA za voutp x_dut_cca_value
CCB zb voutn x_dut_ccb_value
CMA voutp vsen x_dut_cma_value
CMB voutn vsen x_dut_cmb_value
IB vdd ibias dc {x_ibias_val}
RCA voutp vsen x_dut_rca_value
RCB voutn vsen x_dut_rcb_value
RZA o1a za x_dut_rza_value
RZB o1b zb x_dut_rzb_value
VCR vcmr vss dc {x_vcmr_val}
XM2A voutp o1a vss vss nfet_03v3 l=x_dut_xm2a_l m=x_dut_xm2a_m w=x_dut_xm2a_w
XM2B voutn o1b vss vss nfet_03v3 l=x_dut_xm2b_l m=x_dut_xm2b_m w=x_dut_xm2b_w
XMB1 vbp ibias vss vss nfet_03v3 l=x_dut_xmb1_l m=x_dut_xmb1_m w=x_dut_xmb1_w
XMB2 vcp ibias vss vss nfet_03v3 l=x_dut_xmb2_l m=x_dut_xmb2_m w=x_dut_xmb2_w
XMBD ibias ibias vss vss nfet_03v3 l=x_dut_xmbd_l m=x_dut_xmbd_m w=x_dut_xmbd_w
XMCA o1a vcp fp vdd pfet_03v3 l=x_dut_xmca_l m=x_dut_xmca_m w=x_dut_xmca_w
XMCB o1b vcp fn vdd pfet_03v3 l=x_dut_xmcb_l m=x_dut_xmcb_m w=x_dut_xmcb_w
XMEA1 ead vcmr eatail vss nfet_03v3 l=x_dut_xmea1_l m=x_dut_xmea1_m w=x_dut_xmea1_w
XMEA2 vcmfb vsen eatail vss nfet_03v3 l=x_dut_xmea2_l m=x_dut_xmea2_m w=x_dut_xmea2_w
XMEAT eatail ibias vss vss nfet_03v3 l=x_dut_xmeat_l m=x_dut_xmeat_m w=x_dut_xmeat_w
XMEPD ead ead vdd vdd pfet_03v3 l=x_dut_xmepd_l m=x_dut_xmepd_m w=x_dut_xmepd_w
XMEPM vcmfb ead vdd vdd pfet_03v3 l=x_dut_xmepm_l m=x_dut_xmepm_m w=x_dut_xmepm_w
XMI1 fp vinp tail vss nfet_03v3 l=x_dut_xmi1_l m=x_dut_xmi1_m w=x_dut_xmi1_w
XMI2 fn vinn tail vss nfet_03v3 l=x_dut_xmi2_l m=x_dut_xmi2_m w=x_dut_xmi2_w
XMKA x1a vcmfb vss vss nfet_03v3 l=x_dut_xmka_l m=x_dut_xmka_m w=x_dut_xmka_w
XMKB x1b vcmfb vss vss nfet_03v3 l=x_dut_xmkb_l m=x_dut_xmkb_m w=x_dut_xmkb_w
XMLA voutp vbp vdd vdd pfet_03v3 l=x_dut_xmla_l m=x_dut_xmla_m w=x_dut_xmla_w
XMLB voutn vbp vdd vdd pfet_03v3 l=x_dut_xmlb_l m=x_dut_xmlb_m w=x_dut_xmlb_w
XMNA o1a vcn x1a vss nfet_03v3 l=x_dut_xmna_l m=x_dut_xmna_m w=x_dut_xmna_w
XMNB o1b vcn x1b vss nfet_03v3 l=x_dut_xmnb_l m=x_dut_xmnb_m w=x_dut_xmnb_w
XMNCD vcmfb vcmfb vss vss nfet_03v3 l=x_dut_xmncd_l m=x_dut_xmncd_m w=x_dut_xmncd_w
XMND1 vcn vcn vss vss nfet_03v3 l=x_dut_xmnd1_l m=x_dut_xmnd1_m w=x_dut_xmnd1_w
XMPD1 vbp vbp vdd vdd pfet_03v3 l=x_dut_xmpd1_l m=x_dut_xmpd1_m w=x_dut_xmpd1_w
XMPD2 vcp vcp vdd vdd pfet_03v3 l=x_dut_xmpd2_l m=x_dut_xmpd2_m w=x_dut_xmpd2_w
XMPM1 vcn vbp vdd vdd pfet_03v3 l=x_dut_xmpm1_l m=x_dut_xmpm1_m w=x_dut_xmpm1_w
XMSA fp vbp vdd vdd pfet_03v3 l=x_dut_xmsa_l m=x_dut_xmsa_m w=x_dut_xmsa_w
XMSB fn vbp vdd vdd pfet_03v3 l=x_dut_xmsb_l m=x_dut_xmsb_m w=x_dut_xmsb_w
XMT tail ibias vss vss nfet_03v3 l=x_dut_xmt_l m=x_dut_xmt_m w=x_dut_xmt_w
.ends
.end
