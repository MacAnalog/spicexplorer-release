** GENERATED by `analog-db export-raw` — DO NOT EDIT.
** circuit=amp_018_telescopic_cascode  class=amplifier  pdk=tsmc-n65  testbench=stb  corner=tt
** Self-contained deck: testbench + bound params + lowered DUT (.subckt amp_018_telescopic_cascode).
** PDK corner libs resolve by BARE NAME on the image's ngspice sourcepath — run in a
** PDK-enabled env (the base image / api container), NOT a bare host:
**   docker run --rm -i spicexplorer-spice-base:local \
**     bash -lc 'd=$(mktemp -d) && cat > $d/c.spice && cd $d && ngspice -b c.spice' < raw/amp_018_telescopic_cascode/tsmc-n65/stb.spice
*----------------------------------------------------------*
** params: 15 free + 10 frozen knobs (sizing.yaml) · 8 tied · 0 ratio-derived (abstract/params.yaml) · 4 testbench params
** AUTHORED TEMPLATE — amplifier/stb: TRUE loop gain, phase margin and gain margin of the
** unity-gain buffer, by Middlebrook voltage injection at the VIPRB loop-break marker.
**
** WHAT CHANGED (2026-07-31) — this template used to run a plain closed-loop `ac` and only
** `write` the raw, on the theory that the platform's Tier-1 registry would compute the loop
** figures from the written raw. `analog-db run` NEVER calls that registry: runner.py parses
** measures out of the ngspice LOG only, so with no measurement statement in the deck every
** stb cell died on "no measures parsed" at every sizing. The analysis YAMLs also declare
** `flags: [spectre_only_payload]`, but NOTHING reads `flags` (verify.py has no reference to
** it), so that declaration never suppressed anything either. ngspice now measures the loop
** itself, so stb yields a real number on both lanes.
**
** VIPRB stays a plain 0 V source in the NETLIST — that is the marker the Spectre emitter maps
** to `iprobe` for `stb stb probe=VIPRB` (spectre-benches.yaml), and a 0 V source with no AC
** spec is an ideal short, invisible to every other analysis. Only this deck's .control turns
** it into a generator, via `alter`, exactly as ldo/ac_loopgain.spice does. The Spectre lane is
** therefore untouched: same netlist bytes, same probe, same calculator route.
**
** MATH (exact, not a small-signal approximation). The marker forces V(vinn) - V(vout) = 1 V AC.
** With G the transfer once around the rest of the loop (vinn -> DUT -> vout):
**     V(vout) = G*V(vinn)  and  V(vinn) = V(vout) + 1
**  => V(vinn) = 1/(1-G),  V(vout) = G/(1-G),  so  T = v(vout)/v(vinn) = G  identically.
** The ONLY assumption is Middlebrook's impedance condition: the source side of the break must
** be low-Z and the load side high-Z. Here the break is (DUT output, driven by the second stage
** + CLoad) -> (MOSFET gate, purely capacitive, loaded by nothing else). That is satisfied by
** many orders of magnitude, so single voltage injection is sufficient — no Tian dual injection.
** Injecting at DC-short keeps the operating point the CLOSED-loop buffer one, which is the
** whole point of stb: it is the bias the loop actually runs at, not an open-loop bias.
**
** PHASE REFERENCE. At DC the loop gain is a REAL number, so its phase is exactly 0 or +/-180.
** We snap the reference to that multiple of 180 rather than normalising to the phase at FSTART
** (the `180 + phc - phc[0]` idiom used by ac_open_loop / ldo/ac_loopgain). FSTART already
** carries some dominant-pole lag, and normalising it away INFLATES the margin by exactly that
** much: on amp_022 @ ihp-sg13g2, FSTART=1k sits 1.03 deg past the DC phase, and the phc[0] form
** returns pm 81.99 where ac_open_loop (which sweeps from 1 Hz) says 80.94. With the snapped
** reference this bench returns 80.96 — 0.02 deg from the independent bench. `phref_dev` is
** emitted so the assumption is auditable: it is the loop lag already present at FSTART.
**
** PHASE-REFERENCE GUARD (2026-07-31) — the snap is `round(tphc[0]/180)`, so it CHANGES BRANCH
** at |phref_dev| = 90 deg, and a branch change shifts every phase-derived measure by exactly
** 180 deg. That was not hypothetical: measured on amp_021_yan_az @ ihp-sg13g2, FSTART=1k gives
** phref_dev = +89.323 and pm_loop = 213.420, while FSTART=100 gives phref_dev = -89.984 and
** pm_loop = 33.420 — the same loop, 180.000 deg apart, both `status: ok`. 213 deg is not even a
** possible phase margin and nothing rejected it.
** `phref_dev` is BY CONSTRUCTION the distance from the snapped reference (|phref_dev| <= 90
** always, since ph0 is the NEAREST multiple of 180), so it is not a heuristic proxy for the
** ambiguity — it IS the distance to it. Requiring |phref_dev| <= 30 therefore leaves 60 deg of
** margin to the branch boundary: while the guard passes, a wrong-branch reference is not
** unlikely, it is arithmetically impossible. When the guard fails the deck does not choose a
** branch at all — `tph` is blanked to the constant 999, which makes every phase-derived measure
** below return (or keep) the 999 sentinel. Blanking the VECTOR, rather than overwriting the
** measures after the fact, is deliberate: it needs no assumption about the order in which
** `meas` echoes and `print` write into the captured log.
** `phref_ok` (1/0) is published so the reason for a 999 is explicit; `phref_dev` says how far.
** loopgain_db is NOT guarded — it is |T| AT FSTART by definition and carries no branch. Its gap
** to the DC value is 20*log10(cos(phref_dev)) for a dominant-single-pole loop (amp_003 @ ihp,
** FSTART=1k: measured 75.889 vs 86.004 = -10.115 dB, predicted -10.108 from phref_dev=-71.817)
** and somewhat more when several poles contribute (amp_001 @ gf180mcu: -0.049 dB measured vs
** -0.024 dB predicted from -6.070 deg). Either way it is bounded by the guard, and at the
** FSTART the consumers now bind every shipped cell reads |phref_dev| <= 6.1e-05 deg, so the
** residual is far below the last printed digit. Corpus-wide worst residual at FSTART=0.01 is
** amp_021_yan_az's 0.020 dB (122.8566 at 0.01 vs 122.8763 at 0.001).
**
** CHOOSING FSTART (measured 2026-07-31, 23 single-ended amps of this corpus, ihp-sg13g2 except
** amp_032/033 @ gf180mcu, stb template, PPD=101, FSTOP=1G). |phref_dev| is a first-order lag
** and scales linearly with FSTART, exactly as a dominant pole predicts:
**       FSTART        1k       100        10         1       0.1      0.01     0.001
**   max |dev|     89.68     89.98     89.16     81.62     34.16      3.88      0.39   (deg)
**   2nd-worst     89.32     86.72     60.18      9.90      1.00      0.10      0.01   (deg)
**   #cells >30       18        12         5         1         1         0         0   (of 23)
** The single stubborn cell is amp_021_yan_az (an auto-zeroed amp whose loop gain is still
** climbing at 0.01 Hz: 122.857 dB at 0.01 vs 122.876 dB at 0.001). FSTART = 0.01 is the first
** value at which EVERY cell clears the 30 deg guard, with >= 26 deg to spare on the worst one
** and <= 0.10 deg on the other 22 — so 0.01 Hz is the class value the bindings now use.
** The corresponding loopgain_db corrections on the worst cells, FSTART 1k -> 0.01:
**   amp_011_peng_iac    64.757 -> 109.590 dB   amp_021_yan_az   46.244 -> 122.857 dB
**   amp_002_alfio_raffc 67.601 -> 103.884 dB   amp_014_ramos_pfc 64.799 -> 102.098 dB
**   amp_003_fan_smc     75.889 ->  86.004 dB (the -10.11 dB gap was 20*log10(cos 71.82 deg))
**
** CROSSING CONVENTION — pm_loop is taken at the LAST (highest-frequency) 0 dB crossing of |T|,
** not the first. Taking the first crossing certifies unstable loops as stable: a loop whose
** |T| dips below 1, is lifted back above 1 by a resonance, then falls again past it, has a
** benign first crossing and a lethal last one. Validated on a synthetic loop with a known
** closed form (A0=60 dB, pole at 100 Hz, Q=20 resonance at 300 kHz): first crossing reports
** pm = +88.7 deg (stable — WRONG), last crossing reports pm = -78.8 deg against an analytic
** -78.8 deg (unstable — right). `pm_loop_first` is emitted alongside; pm_loop_first != pm_loop
** is the flag that |T| crosses 0 dB more than once and the loop needs a Nyquist look.
** gm_loop is taken at the FIRST -180 deg phase crossing, where |T| is largest, i.e. the
** smallest (worst-case) gain margin.
**
** NO-CROSSING / DEGENERATE SIZINGS. Every published measure is pre-seeded by something that
** cannot fail, THEN refined by an interpolating `meas`. A `meas` that finds no crossing leaves
** the seed intact and prints an unparseable error, so the deck never emits a NaN and never
** emits "<name> = failed" (which runner.py would fold back in as NaN — and `run_text` RAISES on
** a NaN, so NaN is not available as a sentinel here in any case).
**
** THE SEED MUST NOT BE A MEASUREMENT (fixed 2026-07-31). pm_loop used to be seeded with
** `minimum(tph*ma + 999*mb)` — the worst in-band phase — which is a perfectly plausible-looking
** angle. On amp_001_5t @ ihp-sg13g2 (CL=50f) |T| never falls below +13.3 dB anywhere from 1 Hz
** to 1 THz, i.e. the loop has NO unity crossing and therefore no phase margin at all; the deck
** nonetheless reported `pm_loop = 101.630` with `status: ok` while ugf_loop = 1e9 (= FSTOP) and
** gm_loop = 999 were both shouting that nothing was found. gm_loop had the same shape of bug
** latent in `0 - maximum(tdb*pl - 999*pn)`. Both are now seeded with the bare 999 sentinel: the
** ONLY way pm_loop / pm_loop_first / gm_loop can carry a number is for their `meas` to have
** actually interpolated a crossing. This is load-dependent, not a dead code path: the SAME cell
** at CL=500f crosses at 12.395 MHz and still reports its real pm_loop = 95.490 deg. Measured
** floor on the CL=50f case: minimum(|T|) = +13.3075 dB over 1 Hz .. 1 THz.
**   |T| > 1 over the whole band -> ugf_loop = FSTOP, pm_loop = -999, gm_loop = -999
**   |T| < 1 over the whole band -> ugf_loop = 0,     pm_loop = -999, gm_loop = -999
**   phase reference unusable     -> phref_ok = 0,    pm_loop = -999, gm_loop = -999
** -999 is the sentinel for "this bench did not measure this margin". It is NEGATIVE on purpose:
** every loop-margin metric carries a MIN spec (pm_loop >= 45/60, gm_loop >= 10, loopgain_db >= N),
** and ppa._spec_verdict is `value < min -> fail`. A POSITIVE 999 sails past every one of those
** bounds and is recorded as a PASS — measured: pm_loop 999 vs {min:45} -> pass, gm_loop 999 vs
** {min:10} -> pass. So the old +999 turned "this loop has no unity crossover" into "this loop
** meets its phase-margin spec". -999 fails every min bound, which is the honest verdict. A loud value, not a
** plausible fabricated one; `phref_ok` separates the two causes. ugf_loop keeps a reduction
** seed because ITS two degenerate values are real information and equally loud: FSTOP means
** |T| > 1 everywhere in the band, 0 means the loop gain never reaches unity at all.
**
** NGSPICE PARSER GOTCHA — do NOT write `>` inside a `let` expression. The control-language
** preprocessor strips it as an output redirection and silently truncates the RHS
** (`let m = (tdb > 0)` becomes the invalid `let m = (tdb`). All masks below are therefore
** built from `<=` and inverted with `1 - mask`.
**
** Bindings: DUT PORT_LINE VDD VCM IBIAS CL FSTART FSTOP PPD PDK_INCLUDE.
.lib tsmc_n65_models.scs tt
.temp 27

.param VDD=1.2
.param VCM=0.8
.param IBIAS=5u
.param CL=10p

Vdd  vdd 0 dc {VDD}
Vss  vss 0 dc 0
Ibias vdd ibias dc {IBIAS}
CLoad vout 0 {CL}

Vinp vinp 0 dc {VCM} ac 1
VIPRB vinn vout dc 0

XDUT vdd vout vinp vinn ibias vss amp_018_telescopic_cascode

.control
  set filetype=ascii
  * break the loop: VIPRB becomes the 1 V AC generator, the forward input goes AC-silent.
  * (Vinp's `ac 1` is left on the netlist line for the Spectre lane; if it stayed live here it
  * would sum into the loop and v(vout)/v(vinn) would not be the loop gain.)
  alter @Vinp[acmag] = 0
  alter @VIPRB[acmag] = 1
  ac dec 101 1e-4 1G

  let tloop = v(vout)/v(vinn)
  let tdb   = db(tloop)
  let ntdb  = 0 - tdb
  let f     = real(frequency)
  let tphc  = cph(tloop)*180/3.14159265
  * snap the DC phase reference to the exact 0/+-180 the loop must have at DC (see header)
  let ph0   = 180*floor(tphc[0]/180 + 0.5)
  let phref_dev = tphc[0] - ph0

  * PHASE-REFERENCE GUARD (see header). |phref_dev| <= 90 by construction, and the snap changes
  * branch at 90, so |phref_dev| IS the distance to the ambiguity. Below 30 deg the branch is
  * unique with 60 deg to spare; at or above it the deck refuses to pick one and blanks the
  * phase vector to the 999 sentinel, which propagates into every phase-derived measure below.
  let phref_ok  = (abs(phref_dev) <= 30)
  let phref_bad = 1 - phref_ok
  let tph = (180 + tphc - ph0)*phref_ok + (-999)*phref_bad

  * mask (no `>` — see the parser gotcha in the header)
  let mb = (tdb <= 0)
  let ma = 1 - mb

  * seeds. ugf_loop's reduction is itself information (FSTOP = |T| > 1 everywhere, 0 = never
  * reaches unity). The margins get the bare sentinel: a seed must never look like a reading.
  let loopgain_db   = tdb[0]
  let ugf_loop      = maximum(f*ma)
  let pm_loop       = -999
  let gm_loop       = -999
  let pm_loop_first = -999

  * interpolated refinements; each silently leaves its seed in place if it finds no crossing
  meas ac loopgain_db FIND tdb  AT=1e-4
  meas ac ugf_loop    WHEN tdb=0 FALL=LAST
  meas ac pm_loop     FIND tph  WHEN tdb=0 FALL=LAST
  meas ac gm_loop     FIND ntdb WHEN tph=0 FALL=1
  meas ac pm_loop_first FIND tph WHEN tdb=0 FALL=1

  print loopgain_db ugf_loop pm_loop gm_loop pm_loop_first phref_dev phref_ok
  write
  quit
.endc
.param x_dut_xm1_w=27.241u
.param x_dut_xm1_l=0.246u
.param x_dut_xm1c_w=48.148u
.param x_dut_xm1c_l=5.274u
.param x_dut_xm3_w=99.145u
.param x_dut_xm3_l=1.391u
.param x_dut_xm3c_w=78.432u
.param x_dut_xm3c_l=4.589u
.param x_dut_xm5_w=170.082u
.param x_dut_xm5_l=0.505u
.param x_dut_xm5_ng=2
.param x_dut_xm6_w=118.161u
.param x_dut_xm6_l=9.666u
.param x_dut_v_bias_1=0.509
.param x_dut_v_bias_2=1.032
.param x_dut_xm1_m=1
.param x_dut_xm2_m=1
.param x_dut_xm1c_m=1
.param x_dut_xm2c_m=1
.param x_dut_xm3_m=1
.param x_dut_xm4_m=1
.param x_dut_xm3c_m=1
.param x_dut_xm4c_m=1
.param x_dut_xm5_m=1
.param x_dut_xm6_m=1
* ---- GENERATED parameter ties (abstract/params.yaml groups/ratios) ----
* Each tied symbol is defined exactly once, by its line below; rewrite that
* .param to untie just that symbol (untying = shadowing, plan D-3).
.param x_dut_xm2_w = {x_dut_xm1_w}
.param x_dut_xm2_l = {x_dut_xm1_l}
.param x_dut_xm2c_w = {x_dut_xm1c_w}
.param x_dut_xm2c_l = {x_dut_xm1c_l}
.param x_dut_xm4_w = {x_dut_xm3_w}
.param x_dut_xm4_l = {x_dut_xm3_l}
.param x_dut_xm4c_w = {x_dut_xm3c_w}
.param x_dut_xm4c_l = {x_dut_xm3c_l}
.subckt amp_018_telescopic_cascode vdd vout vinp vinn ibias vss
V1 vdd gate_pc x_dut_v_bias_2
V2 casc_n tail x_dut_v_bias_1
XM1 d1 vinp tail vss nch_lvt l=x_dut_xm1_l m=x_dut_xm1_m w=x_dut_xm1_w
XM1C gate_p casc_n d1 vss nch_lvt l=x_dut_xm1c_l m=x_dut_xm1c_m w=x_dut_xm1c_w
XM2 d2 vinn tail vss nch_lvt l=x_dut_xm2_l m=x_dut_xm2_m w=x_dut_xm2_w
XM2C vout casc_n d2 vss nch_lvt l=x_dut_xm2c_l m=x_dut_xm2c_m w=x_dut_xm2c_w
XM3 s3 gate_p vdd vdd pch_lvt l=x_dut_xm3_l m=x_dut_xm3_m w=x_dut_xm3_w
XM3C gate_p gate_pc s3 vdd pch_lvt l=x_dut_xm3c_l m=x_dut_xm3c_m w=x_dut_xm3c_w
XM4 s4 gate_p vdd vdd pch_lvt l=x_dut_xm4_l m=x_dut_xm4_m w=x_dut_xm4_w
XM4C vout gate_pc s4 vdd pch_lvt l=x_dut_xm4c_l m=x_dut_xm4c_m w=x_dut_xm4c_w
XM5 tail ibias vss vss nch_lvt l=x_dut_xm5_l m=x_dut_xm5_m nf=x_dut_xm5_ng w=x_dut_xm5_w
XM6 ibias ibias vss vss nch_lvt l=x_dut_xm6_l m=x_dut_xm6_m w=x_dut_xm6_w
.ends
.end
