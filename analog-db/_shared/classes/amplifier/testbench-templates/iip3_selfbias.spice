** AUTHORED TEMPLATE — amplifier/iip3_selfbias (2026-08-01): two-tone third-order intercept in
** the unity buffer for SELF-BIASED DUTs (no ibias port — the TI-LDO error amps amp_032/033).
** Identical to `iip3` except there is no external bias source — derived exactly as
** psrr_vdd_selfbias derives from psrr_vdd (drop `.param IBIAS` and the `Ibias` line), so a
** 5-port [vdd vout vinp vinn vss] DUT does not leave a current source driving a dangling
** `ibias` node (which makes the DC solve singular). The unity-buffer DC op point is the same
** one ac_closed_loop_selfbias / linearity_selfbias already prove out for these DUTs, so
** biasing is safe. EVERYTHING measurement-side is grafted from iip3.spice UNCHANGED — that
** header carries the full audited story and is the reference for any future edit here; the
** load-bearing invariants it establishes (do not relax ANY of them):
**   * BIN PLACEMENT: F1/F2 MUST be integer multiples of F0 = gcd(F1,F2) so the tones AND both
**     IM3 products (2F1-F2, 2F2-F1) AND both IM5 products (3F1-2F2, 3F2-2F1) land on exact
**     bins — zero scalloping/leakage in the rectangular-window DFT.
**   * COHERENCE + SETTLING: BOTH TSTART and (TSTOP-TSTART) must be integer numbers of BEAT
**     periods 1/F0; TSTEP <= 1/(200*F2). The startup transient leaks into every bin otherwise
**     and buries the uV-scale IM3 products.
**   * ENDPOINT-DUPLICATION CORRECTION: `linearize` returns np = nd+1 points whose last sample
**     repeats the first; every bin is (mean(vac*c)*np - vac[0]*c[0])/nd. The naive mean() bias
**     WAS this deck's whole noise floor (measured: 2.3e-7 V, only 11 dB under the real IM3;
**     corrected 1.6e-11 V). a_floor (bin 5*F0 — lowest-order product there is NINTH order) is
**     the trust check: a_im3 must sit well above it or the tones/window are wrong.
**   * DRIVE: default ASIG = 6.25 mV per tone — the geometric centre of the measured valid
**     window (compression bounds it above at ~14 mV, the deck's own floor below at ~2.5 mV;
**     the old 50 mV read up to 1.40 dB optimistic). iip3_comp_db estimates the residual
**     |IIP3 error| from the IM5/IM3 ratio — an ESTIMATE, not a bound; usable one-sided only
**     at the shipped drive.
**   * `write` BEFORE `linearize` (linearize swaps the current plot and would gut the raw).
**   * DEAD-OUTPUT GUARD: MEASURED worst-side tone gain off the drive bins (a_drv), threshold
**     0.5 = the |A| = 1 line of gain_tone = A/(1+A). On a fail iip3_dbv = -999 and
**     im3_dbc = +999 — both bad-direction sentinels, NOT NaN (a NaN makes the runner discard
**     the whole analysis). It is a SCREEN, not a proof.
**   * No `>` inside a `let` — the .control preprocessor strips it as an output redirection
**     and silently truncates the RHS; masks use `<=` and 1 - mask.
**   * BINDING FORM: ASIG, F0, F1, F2 reach control-language ARITHMETIC — plain decimals /
**     scientific notation only (0.00625, 0.9e6), NEVER SPICE suffixes (6.25m, 900k).
**     TSTEP/TSTART/TSTOP only reach the `tran` card, so suffixes are fine there.
**   * Measure names match the ibias sibling EXACTLY (a_f1, a_f2, a_drv, gain_tone,
**     gain_tone_db, a_im3l/h, a_im5l/h, a_floor, im3_dbc, iip3_dbv, im5_im3_db, iip3_comp_db)
**     so datasheet wiring stays uniform across template variants; none is in
**     raw_project._SPEC_REGISTRY (in particular the buffer gain is `gain_tone`, NOT the
**     registry's `gain_cl`).
** Bindings: DUT PORT_LINE VDD VCM CL ASIG F0 F1 F2 TSTEP TSTART TSTOP PDK_INCLUDE.
${PDK_INCLUDE}

.param VDD=${VDD}
.param VCM=${VCM}
.param CL=${CL}
.param ASIG=${ASIG}

Vdd  vdd 0 dc {VDD}
Vss  vss 0 dc 0
CLoad vout 0 {CL}

* unity buffer; two series-stacked tones — the lower source carries the VCM offset
Vton vinp mid sin(0 {ASIG} ${F1})
Vtwo mid  0   sin({VCM} {ASIG} ${F2})
Vfb  vinn vout dc 0

${PORT_LINE} ${DUT}

.control
  set filetype=ascii
  tran ${TSTEP} ${TSTOP} ${TSTART}
  * raw first — `linearize` below switches the current plot to its interpolated scratch
  * copy, so a trailing `write` guts the raw to the DFT leftovers instead of the full
  * node set (thd.spice's header has the measured story)
  write
  let vo = v(vout)
  let vi = v(vinp)
  linearize vo vi
  let t = time
  let vac = vo - mean(vo)
  let vin_ac = vi - mean(vi)
  let np = length(vac)
  let nd = np - 1
* --- coherent single-bin DFT: amplitude at f is 2*|(1/N) sum vac*e^-jwt| over the N
* --- NON-redundant samples. `linearize` returns N+1 points spanning exactly 20 beat
* --- periods, so its last sample REPEATS its first; leaving it in biases every bin by
* --- |vac[0]|/N — measured, that bias WAS this deck's whole noise floor (it fell exactly
* --- as 1/N under both TSTEP and window scaling). mean()*np recovers the sum; the
* --- vac[0]*c[0] term drops the duplicate, making the window exactly rectangular.
  let c_f1 = cos(2*pi*${F1}*t)
  let s_f1 = sin(2*pi*${F1}*t)
  let re_f1 = (mean(vac*c_f1)*np - vac[0]*c_f1[0])/nd
  let im_f1 = (mean(vac*s_f1)*np - vac[0]*s_f1[0])/nd
  let a_f1  = 2*sqrt(re_f1^2+im_f1^2)
* --- the SAME bin taken on the DRIVE v(vinp) — the reference for the dead-output guard ---
  let rd_f1 = (mean(vin_ac*c_f1)*np - vin_ac[0]*c_f1[0])/nd
  let id_f1 = (mean(vin_ac*s_f1)*np - vin_ac[0]*s_f1[0])/nd
  let a_dr1 = 2*sqrt(rd_f1^2+id_f1^2)
  let c_f2 = cos(2*pi*${F2}*t)
  let s_f2 = sin(2*pi*${F2}*t)
  let re_f2 = (mean(vac*c_f2)*np - vac[0]*c_f2[0])/nd
  let im_f2 = (mean(vac*s_f2)*np - vac[0]*s_f2[0])/nd
  let a_f2  = 2*sqrt(re_f2^2+im_f2^2)
  let rd_f2 = (mean(vin_ac*c_f2)*np - vin_ac[0]*c_f2[0])/nd
  let id_f2 = (mean(vin_ac*s_f2)*np - vin_ac[0]*s_f2[0])/nd
  let a_dr2 = 2*sqrt(rd_f2^2+id_f2^2)
  let c_3l = cos(2*pi*(2*${F1}-${F2})*t)
  let s_3l = sin(2*pi*(2*${F1}-${F2})*t)
  let re_3l = (mean(vac*c_3l)*np - vac[0]*c_3l[0])/nd
  let im_3l = (mean(vac*s_3l)*np - vac[0]*s_3l[0])/nd
  let a_im3l = 2*sqrt(re_3l^2+im_3l^2)
  let c_3h = cos(2*pi*(2*${F2}-${F1})*t)
  let s_3h = sin(2*pi*(2*${F2}-${F1})*t)
  let re_3h = (mean(vac*c_3h)*np - vac[0]*c_3h[0])/nd
  let im_3h = (mean(vac*s_3h)*np - vac[0]*s_3h[0])/nd
  let a_im3h = 2*sqrt(re_3h^2+im_3h^2)
* --- 5th-order products at 3F1-2F2 and 3F2-2F1 — the COMPRESSION INDICATOR (see the
* --- iip3.spice header). They ride the same coherent grid as everything else, so they cost
* --- two bin pairs and no extra simulation.
  let c_5l = cos(2*pi*(3*${F1}-2*${F2})*t)
  let s_5l = sin(2*pi*(3*${F1}-2*${F2})*t)
  let re_5l = (mean(vac*c_5l)*np - vac[0]*c_5l[0])/nd
  let im_5l = (mean(vac*s_5l)*np - vac[0]*s_5l[0])/nd
  let a_im5l = 2*sqrt(re_5l^2+im_5l^2)
  let c_5h = cos(2*pi*(3*${F2}-2*${F1})*t)
  let s_5h = sin(2*pi*(3*${F2}-2*${F1})*t)
  let re_5h = (mean(vac*c_5h)*np - vac[0]*c_5h[0])/nd
  let im_5h = (mean(vac*s_5h)*np - vac[0]*s_5h[0])/nd
  let a_im5h = 2*sqrt(re_5h^2+im_5h^2)
  let c_fl = cos(2*pi*5*${F0}*t)
  let s_fl = sin(2*pi*5*${F0}*t)
  let re_fl = (mean(vac*c_fl)*np - vac[0]*c_fl[0])/nd
  let im_fl = (mean(vac*s_fl)*np - vac[0]*s_fl[0])/nd
  let a_floor = 2*sqrt(re_fl^2+im_fl^2)
* --- worst-side IM3/IM5 over the weaker tone; min/max of two scalars without branching ---
  let a_fund = 0.5*(a_f1+a_f2 - abs(a_f1-a_f2))
  let a_im3  = 0.5*(a_im3l+a_im3h + abs(a_im3l-a_im3h))
  let a_im5  = 0.5*(a_im5l+a_im5h + abs(a_im5l-a_im5h))
  let a_drv  = 0.5*(a_dr1+a_dr2 - abs(a_dr1-a_dr2))
* --- floors keep log10() finite when a bin lands on zero (a NaN aborts the run) ---
  let a_fund_g = a_fund + 1e-15
  let a_im3_g  = a_im3 + 1e-15
* --- DEAD-OUTPUT GUARD (see the header): a MEASURED gain, not a NaN check. Do NOT write
* --- `>` inside a `let` — the control preprocessor strips it as an output redirection and
* --- silently truncates the RHS. Masks use `<=`, inverted with 1 - mask.
  let gain_tone = a_fund/(a_drv + 1e-18)
  let gain_tone_db = 20*log10(gain_tone + 1e-18)
  let dead = (gain_tone <= 0.5)
  let live = 1 - dead
* input-referred: OIP3 = 20log10(a_fund) - im3_dbc/2, and the measured buffer gain is
* a_fund/ASIG, so IIP3 = OIP3 - 20log10(a_fund/ASIG) = 20log10(ASIG) - im3_dbc/2.
* ASIG (the BINDING, not a_drv) is the reference on purpose: the Spectre lane's
* calculator.yaml iip3_dbv passes the same `AMPL: $ASIG`, so both lanes stay identical.
* a_drv is printed beside it — if it disagrees with ASIG, the stimulus is mis-bound.
  let im3_raw  = 20*log10(a_im3_g/a_fund_g)
  let iip3_raw = 20*log10(${ASIG}) - im3_raw/2
  let im3_dbc  = live*im3_raw  + dead*999
  let iip3_dbv = live*iip3_raw - dead*999
* --- COMPRESSION INDICATOR (see the header): |IIP3 error| ~ 21.7 * a_im5/a_im3 dB.
  let im5_im3_db  = 20*log10((a_im5 + 1e-18)/a_im3_g)
  let iip3_comp_db = live*21.71*a_im5/a_im3_g
  print a_f1 a_f2 a_drv gain_tone gain_tone_db a_im3l a_im3h a_im5l a_im5h a_floor
  print im3_dbc iip3_dbv im5_im3_db iip3_comp_db
  quit
.endc
.end
