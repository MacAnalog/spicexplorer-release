** GENERATED by `analog-db export-raw` — DO NOT EDIT.
** circuit=cmfb_001_ideal_rsense_servo  class=cmfb  pdk=tsmc-n65  testbench=ac_servo  corner=tt
** Self-contained deck: testbench + bound params + lowered DUT (.subckt cmfb_001_ideal_rsense_servo).
** PDK corner libs resolve by BARE NAME on the image's ngspice sourcepath — run in a
** PDK-enabled env (the base image / api container), NOT a bare host:
**   docker run --rm -i spicexplorer-spice-base:local \
**     bash -lc 'd=$(mktemp -d) && cat > $d/c.spice && cd $d && ngspice -b c.spice' < raw/cmfb_001_ideal_rsense_servo/tsmc-n65/ac_servo.spice
*----------------------------------------------------------*
** params: 6 free + 0 frozen knobs (sizing.yaml) · 1 tied · 0 ratio-derived (abstract/params.yaml) · 3 testbench params
** AUTHORED TEMPLATE — cmfb/ac_servo (servo path transfer). Moved from support/
** 2026-07-20 when CMFB circuits got their own class (sup_002 -> cmfb_001); extended
** with ugf_servo_hz. History: plan_hierarchical_composition P3.
** CMFB-servo transfer: both sense inputs driven together (common-mode) with an AC unit
** about VCM; the servo's control output (vcmfb) transfer gives the CM-loop path gain,
** bandwidth, and unity-gain frequency into the bound control-node load CL (the actuator
** gate proxy). The DC bias point is the ZERO-ERROR point (sensed == vref), i.e. the
** small-signal is taken about vcmfb_nat (see dc_cmfb_transfer).
**   gain_servo_db  low-frequency servo path gain, db(v(vcmfb)) at FSTART
**   bw_servo_hz    -3 dB rolloff into CL
**   ugf_servo_hz   |servo transfer| = 0 dB crossing (absent when gain < 0 dB —
**                  harmless meas failure; keep it in `produces:` only for members
**                  with above-unity servo gain)
** Assumes the CMFB-servo port order:
**   .subckt <id> vinp vinn vcmfb vref vdd vss
** Required bindings: DUT PORT_LINE VDD VCM CL FSTART FSTOP PPD PDK_INCLUDE.
.lib tsmc_n65_models.scs tt
.temp 27

.param VDD=1.2
.param VCM=0.6
.param CL=50f

Vdd  vdd 0 dc {VDD}
Vss  vss 0 dc 0
Vref vref 0 dc {VCM}
Vcm  vcm 0 dc {VCM} ac 1
* common-mode drive: both inputs follow the same AC source
Vinp vinp vcm dc 0
Vinn vinn vcm dc 0
CLoad vcmfb 0 {CL}

XDUT vinp vinn vcmfb vref vdd vss cmfb_001_ideal_rsense_servo

.control
  set filetype=ascii
  ac dec 61 10 1G
  let gdb = db(v(vcmfb))
  meas ac gain_servo_db FIND gdb AT=10
  let g3 = gain_servo_db - 3
  meas ac bw_servo_hz WHEN gdb=g3 FALL=1
  meas ac ugf_servo_hz WHEN gdb=0 FALL=1
  write
  quit
.endc
.param gm_val=100u
.param rout_val=10Meg
.param cout_val=100f
.param rin_val=1e12
.param cin_val=10f
.param x_dut_rmp_value=1Meg
* ---- GENERATED parameter ties (abstract/params.yaml groups/ratios) ----
* Each tied symbol is defined exactly once, by its line below; rewrite that
* .param to untie just that symbol (untying = shadowing, plan D-3).
.param x_dut_rmn_value = {x_dut_rmp_value}
.subckt cmfb_001_ideal_rsense_servo vinp vinn vcmfb vref vdd vss
CIN_SERVO cm_sense vref 'cin_val'
COUT_SERVO vss vcmfb 'cout_val'
GM_SERVO vss vcmfb vref cm_sense {gm_val}
RIN_SERVO cm_sense vref 'rin_val'
RMN vinn cm_sense 'x_dut_rmn_value'
RMP cm_sense vinp 'x_dut_rmp_value'
ROUT_SERVO vss vcmfb 'rout_val'
.ends
.end
