** GENERATED by `analog-db export-raw` — DO NOT EDIT.
** circuit=amp_011_peng_iac  class=amplifier  pdk=tsmc-n65  testbench=thd  corner=tt
** Self-contained deck: testbench + bound params + lowered DUT (.subckt amp_011_peng_iac).
** PDK corner libs resolve by BARE NAME on the image's ngspice sourcepath — run in a
** PDK-enabled env (the base image / api container), NOT a bare host:
**   docker run --rm -i spicexplorer-spice-base:local \
**     bash -lc 'd=$(mktemp -d) && cat > $d/c.spice && cd $d && ngspice -b c.spice' < raw/amp_011_peng_iac/tsmc-n65/thd.spice
*----------------------------------------------------------*
** params: 31 free + 0 frozen knobs (sizing.yaml) · 52 tied · 23 ratio-derived (abstract/params.yaml) · 4 testbench params
** AUTHORED TEMPLATE — amplifier/thd_selfbias (2026-08-01): large-signal harmonic distortion in
** the unity buffer for SELF-BIASED DUTs (no ibias port — the TI-LDO error amps amp_032/033).
** Identical to `thd` except there is no external bias source — derived exactly as
** psrr_vdd_selfbias derives from psrr_vdd (drop `.param IBIAS` and the `Ibias` line), so a
** 5-port [vdd vout vinp vinn vss] DUT does not leave a current source driving a dangling
** `ibias` node (which makes the DC solve singular). The unity-buffer DC op point is the same
** one ac_closed_loop_selfbias / linearity_selfbias already prove out for these DUTs, so
** biasing is safe. EVERYTHING measurement-side is grafted from thd.spice UNCHANGED — that
** header carries the full audited story and is the reference for any future edit here; the
** load-bearing invariants it establishes (do not relax ANY of them):
**   * COHERENT WINDOW: (TSTOP-TSTART) MUST be an integer number of F0 periods — a half-period
**     mismatch inflates thd_pct up to 63x (measured). TSTART discards the startup transient
**     and need not land on a period boundary. >= 8 measured periods, TSTEP <= 1/(200*F0).
**   * ENDPOINT-DUPLICATION CORRECTION: `linearize` returns np = nd+1 points whose last sample
**     repeats the first; every bin is therefore taken as
**         re_k = (mean(vac*c_k)*np - vac[0]*c_k[0])/nd
**     Without it the window phase alone swings thd 2.95x and a3 41x (measured on amp_022@ihp).
**     a4/a5 are the tell-tale: if either creeps up to 2*|vac[0]|/np the correction is broken.
**   * `write` BEFORE `linearize`: linearize swaps the current plot for its interpolated
**     scratch copy, so a trailing write guts the raw from every circuit node to the DFT
**     leftovers and breaks the platform {meas: thd_pct} cross-check on the raw.
**   * DEAD-OUTPUT GUARD: a MEASURED tone gain (a1 over the same bin taken on the drive
**     v(vinp)), threshold 0.5 = the |A| = 1 line of gain_tone = A/(1+A). On a fail thd_pct
**     becomes the loud 999 sentinel — bad-direction for a minimize metric, and NOT NaN (a NaN
**     makes the runner discard the whole analysis). It is a SCREEN, not a proof.
**   * No `>` inside a `let` — the .control preprocessor strips it as an output redirection
**     and silently truncates the RHS; masks use `<=` and 1 - mask.
**   * Measure names match the ibias sibling EXACTLY (thd_pct, thd_db, a1..a5, a1_in,
**     gain_tone, vout_op) so datasheet wiring stays uniform across template variants; none is
**     in raw_project._SPEC_REGISTRY (deliberately: `vout_op` not `vout_dc`, `gain_tone` not
**     `gain_cl` — the alternatives ARE registry names and would silently add objectives).
** Bindings: DUT PORT_LINE VDD VCM CL ASIG F0 TSTEP TSTART TSTOP PDK_INCLUDE.
.lib tsmc_n65_models.scs tt
.temp 27

.param VDD=1.8
.param VCM=240m
.param CL=10p
.param ASIG=0.1

Vdd  vdd 0 dc {VDD}
Vss  vss 0 dc 0
CLoad vout 0 {CL}

* unity buffer; the sine offset VCM doubles as the DC operating point
Vinp vinp 0 sin({VCM} {ASIG} 1.0e4)
Vfb  vinn vout dc 0

XDUT vss vdd vinn vinp vout amp_011_peng_iac

.control
  set filetype=ascii
  tran 200n 2m 400u
  * raw first — see the header; linearize below switches the current plot
  write
  let vo = v(vout)
  let vi = v(vinp)
  linearize vo vi
  let t = time
* --- endpoint-duplication correction (see the header): `linearize` hands back np = nd+1
* --- points whose last sample repeats the first, so mean() averages one sample too many.
* --- mean()*np recovers the sum, subtracting vac[0]*c_k[0] drops the duplicate, /nd gives
* --- the true rectangular-window average over one whole number of periods.
  let np = length(vo)
  let nd = np - 1
  let vout_op = (mean(vo)*np - vo[0])/nd
  * the pedestal subtraction is exactly cancelled by the correction above (measured
  * bit-identical); kept because vout_op is reported anyway and `vac` reads clearer
  let vac = vo - vout_op
  let vin_ac = vi - mean(vi)
  let w = 2*pi*1.0e4
  let c1 = cos(w*t)
  let s1 = sin(w*t)
  let re1 = (mean(vac*c1)*np - vac[0]*c1[0])/nd
  let im1 = (mean(vac*s1)*np - vac[0]*s1[0])/nd
  let a1 = 2*sqrt(re1^2+im1^2)
* --- the SAME bin taken on the DRIVE v(vinp) — the reference for the dead-output guard ---
  let rei = (mean(vin_ac*c1)*np - vin_ac[0]*c1[0])/nd
  let imi = (mean(vin_ac*s1)*np - vin_ac[0]*s1[0])/nd
  let a1_in = 2*sqrt(rei^2+imi^2)
  let c2 = cos(2*w*t)
  let s2 = sin(2*w*t)
  let re2 = (mean(vac*c2)*np - vac[0]*c2[0])/nd
  let im2 = (mean(vac*s2)*np - vac[0]*s2[0])/nd
  let a2 = 2*sqrt(re2^2+im2^2)
  let c3 = cos(3*w*t)
  let s3 = sin(3*w*t)
  let re3 = (mean(vac*c3)*np - vac[0]*c3[0])/nd
  let im3 = (mean(vac*s3)*np - vac[0]*s3[0])/nd
  let a3 = 2*sqrt(re3^2+im3^2)
  let c4 = cos(4*w*t)
  let s4 = sin(4*w*t)
  let re4 = (mean(vac*c4)*np - vac[0]*c4[0])/nd
  let im4 = (mean(vac*s4)*np - vac[0]*s4[0])/nd
  let a4 = 2*sqrt(re4^2+im4^2)
  let c5 = cos(5*w*t)
  let s5 = sin(5*w*t)
  let re5 = (mean(vac*c5)*np - vac[0]*c5[0])/nd
  let im5 = (mean(vac*s5)*np - vac[0]*s5[0])/nd
  let a5 = 2*sqrt(re5^2+im5^2)
* --- DEAD-OUTPUT GUARD (see the header): a MEASURED gain, not a NaN check. Do NOT write
* --- `>` inside a `let` — the control preprocessor strips it as an output redirection and
* --- silently truncates the RHS. Masks use `<=`, inverted with 1 - mask.
  let gain_tone = a1/(a1_in + 1e-18)
  let dead = (gain_tone <= 0.5)
  let live = 1 - dead
  * the 1e-18 floors keep a dead output (a1 == 0) from emitting inf/NaN, which makes the runner
  * throw away the WHOLE analysis; they sit 12+ decades below any real amplitude
  let thd_raw = 100*sqrt(a2^2+a3^2+a4^2+a5^2)/(a1+1e-18)
  let thd_pct = live*thd_raw + dead*999
  let thd_db = 20*log10(thd_pct/100 + 1e-18)
  print a1 a2 a3 a4 a5 a1_in gain_tone thd_pct thd_db vout_op
  quit
.endc
.param CAPACITOR_0=0.5p
.param CAPACITOR_1=1.1p
.param CURRENT_0_BIAS=1.25u
.param x_dut_xm7_l=1u
.param x_dut_xm65_m=4
.param x_dut_xm7_w=1u
.param x_dut_xm10_l=0.35u
.param x_dut_xm10_m=24
.param x_dut_xm10_w=1u
.param x_dut_xm11_l=0.35u
.param x_dut_xm11_m=9
.param x_dut_xm11_w=1u
.param x_dut_xm19_l=0.35u
.param x_dut_xm14_m=2
.param x_dut_xm19_w=1u
.param x_dut_xm23_l=0.35u
.param x_dut_xm23_m=3
.param x_dut_xm23_w=1u
.param x_dut_xm66_l=1u
.param x_dut_xm66_m=16
.param x_dut_xm66_w=1u
.param x_dut_xm68_l=0.35u
.param x_dut_xm68_m=3
.param x_dut_xm68_w=1u
.param x_dut_xm70_l=0.35u
.param x_dut_xm70_m=3
.param x_dut_xm70_w=1u
.param x_dut_xm9_l=0.35u
.param x_dut_xm9_m=3
.param x_dut_xm9_w=1u
.param RESISTOR_0=750k
* ---- GENERATED parameter ties (abstract/params.yaml groups/ratios) ----
* Each tied symbol is defined exactly once, by its line below; rewrite that
* .param to untie just that symbol (untying = shadowing, plan D-3).
.param x_dut_xm57_w = {x_dut_xm7_w}
.param x_dut_xm65_w = {x_dut_xm7_w}
.param x_dut_xm6_w = {x_dut_xm7_w}
.param x_dut_xm5_w = {x_dut_xm7_w}
.param x_dut_xm4_w = {x_dut_xm7_w}
.param x_dut_xm62_w = {x_dut_xm7_w}
.param x_dut_xm3_w = {x_dut_xm7_w}
.param x_dut_xm61_w = {x_dut_xm7_w}
.param x_dut_xm2_w = {x_dut_xm7_w}
.param x_dut_xm58_w = {x_dut_xm7_w}
.param x_dut_xm1_w = {x_dut_xm7_w}
.param x_dut_xm0_w = {x_dut_xm7_w}
.param x_dut_xm57_l = {x_dut_xm7_l}
.param x_dut_xm65_l = {x_dut_xm7_l}
.param x_dut_xm6_l = {x_dut_xm7_l}
.param x_dut_xm5_l = {x_dut_xm7_l}
.param x_dut_xm4_l = {x_dut_xm7_l}
.param x_dut_xm62_l = {x_dut_xm7_l}
.param x_dut_xm3_l = {x_dut_xm7_l}
.param x_dut_xm61_l = {x_dut_xm7_l}
.param x_dut_xm2_l = {x_dut_xm7_l}
.param x_dut_xm58_l = {x_dut_xm7_l}
.param x_dut_xm1_l = {x_dut_xm7_l}
.param x_dut_xm0_l = {x_dut_xm7_l}
.param x_dut_xm8_w = {x_dut_xm9_w}
.param x_dut_xm8_l = {x_dut_xm9_l}
.param x_dut_xm8_m = {x_dut_xm9_m}
.param x_dut_xm69_w = {x_dut_xm70_w}
.param x_dut_xm69_l = {x_dut_xm70_l}
.param x_dut_xm69_m = {x_dut_xm70_m}
.param x_dut_xm15_w = {x_dut_xm19_w}
.param x_dut_xm20_w = {x_dut_xm19_w}
.param x_dut_xm16_w = {x_dut_xm19_w}
.param x_dut_xm17_w = {x_dut_xm19_w}
.param x_dut_xm67_w = {x_dut_xm19_w}
.param x_dut_xm14_w = {x_dut_xm19_w}
.param x_dut_xm12_w = {x_dut_xm19_w}
.param x_dut_xm18_w = {x_dut_xm19_w}
.param x_dut_xm13_w = {x_dut_xm19_w}
.param x_dut_xm64_w = {x_dut_xm19_w}
.param x_dut_xm63_w = {x_dut_xm19_w}
.param x_dut_xm15_l = {x_dut_xm19_l}
.param x_dut_xm20_l = {x_dut_xm19_l}
.param x_dut_xm16_l = {x_dut_xm19_l}
.param x_dut_xm17_l = {x_dut_xm19_l}
.param x_dut_xm67_l = {x_dut_xm19_l}
.param x_dut_xm14_l = {x_dut_xm19_l}
.param x_dut_xm12_l = {x_dut_xm19_l}
.param x_dut_xm18_l = {x_dut_xm19_l}
.param x_dut_xm13_l = {x_dut_xm19_l}
.param x_dut_xm64_l = {x_dut_xm19_l}
.param x_dut_xm63_l = {x_dut_xm19_l}
.param x_dut_xm7_m = {x_dut_xm65_m*16}
.param x_dut_xm57_m = {x_dut_xm65_m*4}
.param x_dut_xm6_m = {x_dut_xm65_m*4}
.param x_dut_xm5_m = {x_dut_xm65_m*4}
.param x_dut_xm4_m = {x_dut_xm65_m*8}
.param x_dut_xm62_m = {x_dut_xm65_m*4}
.param x_dut_xm3_m = {x_dut_xm65_m*4}
.param x_dut_xm61_m = {x_dut_xm65_m*4}
.param x_dut_xm2_m = {x_dut_xm65_m*4}
.param x_dut_xm58_m = {x_dut_xm65_m*4}
.param x_dut_xm1_m = {x_dut_xm65_m*4}
.param x_dut_xm0_m = {x_dut_xm65_m*4}
.param x_dut_xm19_m = {x_dut_xm14_m*8}
.param x_dut_xm15_m = {x_dut_xm14_m*8}
.param x_dut_xm20_m = {x_dut_xm14_m*8}
.param x_dut_xm16_m = {x_dut_xm14_m*8}
.param x_dut_xm17_m = {x_dut_xm14_m*4}
.param x_dut_xm67_m = {x_dut_xm14_m*32}
.param x_dut_xm12_m = {x_dut_xm14_m*4}
.param x_dut_xm18_m = {x_dut_xm14_m*4}
.param x_dut_xm13_m = {x_dut_xm14_m*4}
.param x_dut_xm64_m = {x_dut_xm14_m*4}
.param x_dut_xm63_m = {x_dut_xm14_m*4}
.subckt amp_011_peng_iac vss vdd vinn vinp vout
C0 VOUTP VOUT 'CAPACITOR_0'
C1 net10 net4 'CAPACITOR_1'
I0 VB1 vss 'CURRENT_0_BIAS'
R0 net4 vss 'RESISTOR_0'
XM0 net2 VB1 vdd vdd pch_lvt l=x_dut_xm0_l m=x_dut_xm0_m w=x_dut_xm0_w
XM1 net3 VB1 vdd vdd pch_lvt l=x_dut_xm1_l m=x_dut_xm1_m w=x_dut_xm1_w
XM10 net043 VOUTP vdd vdd pch_lvt l=x_dut_xm10_l m=x_dut_xm10_m w=x_dut_xm10_w
XM11 VOUT VOUTP vdd vdd pch_lvt l=x_dut_xm11_l m=x_dut_xm11_m w=x_dut_xm11_w
XM12 VB4 VB3 net54 vss nch_lvt l=x_dut_xm12_l m=x_dut_xm12_m w=x_dut_xm12_w
XM13 net7 VB3 net56 vss nch_lvt l=x_dut_xm13_l m=x_dut_xm13_m w=x_dut_xm13_w
XM14 VB3 VB3 vss vss nch_lvt l=x_dut_xm14_l m=x_dut_xm14_m w=x_dut_xm14_w
XM15 VOUTN VB3 DM_2 vss nch_lvt l=x_dut_xm15_l m=x_dut_xm15_m w=x_dut_xm15_w
XM16 VOUTP VB3 net063 vss nch_lvt l=x_dut_xm16_l m=x_dut_xm16_m w=x_dut_xm16_w
XM17 net54 VB4 vss vss nch_lvt l=x_dut_xm17_l m=x_dut_xm17_m w=x_dut_xm17_w
XM18 net56 VB4 vss vss nch_lvt l=x_dut_xm18_l m=x_dut_xm18_m w=x_dut_xm18_w
XM19 DM_2 VB4 vss vss nch_lvt l=x_dut_xm19_l m=x_dut_xm19_m w=x_dut_xm19_w
XM2 net6 VB1 vdd vdd pch_lvt l=x_dut_xm2_l m=x_dut_xm2_m w=x_dut_xm2_w
XM20 net063 VB4 vss vss nch_lvt l=x_dut_xm20_l m=x_dut_xm20_m w=x_dut_xm20_w
XM23 VOUT net10 vss vss nch_lvt l=x_dut_xm23_l m=x_dut_xm23_m w=x_dut_xm23_w
XM3 net8 VB1 vdd vdd pch_lvt l=x_dut_xm3_l m=x_dut_xm3_m w=x_dut_xm3_w
XM4 net31 VB1 vdd vdd pch_lvt l=x_dut_xm4_l m=x_dut_xm4_m w=x_dut_xm4_w
XM5 VOUTN VOUTN vdd vdd pch_lvt l=x_dut_xm5_l m=x_dut_xm5_m w=x_dut_xm5_w
XM57 VB1 VB2 net2 vdd pch_lvt l=x_dut_xm57_l m=x_dut_xm57_m w=x_dut_xm57_w
XM58 VB4 VB2 net3 vdd pch_lvt l=x_dut_xm58_l m=x_dut_xm58_m w=x_dut_xm58_w
XM6 VOUTP VOUTN vdd vdd pch_lvt l=x_dut_xm6_l m=x_dut_xm6_m w=x_dut_xm6_w
XM61 net7 VB2 net6 vdd pch_lvt l=x_dut_xm61_l m=x_dut_xm61_m w=x_dut_xm61_w
XM62 VB3 VB2 net8 vdd pch_lvt l=x_dut_xm62_l m=x_dut_xm62_m w=x_dut_xm62_w
XM63 VB2 VB3 net9 vss nch_lvt l=x_dut_xm63_l m=x_dut_xm63_m w=x_dut_xm63_w
XM64 net9 VB4 vss vss nch_lvt l=x_dut_xm64_l m=x_dut_xm64_m w=x_dut_xm64_w
XM65 VB2 VB2 vdd vdd pch_lvt l=x_dut_xm65_l m=x_dut_xm65_m w=x_dut_xm65_w
XM66 net10 VB2 net049 vdd pch_lvt l=x_dut_xm66_l m=x_dut_xm66_m w=x_dut_xm66_w
XM67 net043 VB3 net1 vss nch_lvt l=x_dut_xm67_l m=x_dut_xm67_m w=x_dut_xm67_w
XM68 net1 VB4 vss vss nch_lvt l=x_dut_xm68_l m=x_dut_xm68_m w=x_dut_xm68_w
XM69 net10 net043 vss vss nch_lvt l=x_dut_xm69_l m=x_dut_xm69_m w=x_dut_xm69_w
XM7 net049 VB1 vdd vdd pch_lvt l=x_dut_xm7_l m=x_dut_xm7_m w=x_dut_xm7_w
XM70 net1 net043 vss vss nch_lvt l=x_dut_xm70_l m=x_dut_xm70_m w=x_dut_xm70_w
XM8 DM_2 VINN net31 net31 pch_lvt l=x_dut_xm8_l m=x_dut_xm8_m w=x_dut_xm8_w
XM9 net063 VINP net31 net31 pch_lvt l=x_dut_xm9_l m=x_dut_xm9_m w=x_dut_xm9_w
.ends
.end
