** GENERATED by `analog-db export-raw` — DO NOT EDIT.
** circuit=ldo_001_analoggym_basic  class=ldo  pdk=gf180mcu  testbench=dropout  corner=tt
** Self-contained deck: testbench + bound params + lowered DUT (.subckt ldo_001_analoggym_basic).
** PDK corner libs resolve by BARE NAME on the image's ngspice sourcepath — run in a
** PDK-enabled env (the base image / api container), NOT a bare host:
**   docker run --rm -i spicexplorer-spice-base:local \
**     bash -lc 'd=$(mktemp -d) && cat > $d/c.spice && cd $d && ngspice -b c.spice' < raw/ldo_001_analoggym_basic/gf180mcu/dropout.spice
*----------------------------------------------------------*
** params: 23 free + 0 frozen knobs (sizing.yaml) · 38 tied · 16 ratio-derived (abstract/params.yaml) · 0 testbench params
** AUTHORED TEMPLATE — ldo/dropout: the smallest (Vin - Vout) at which the regulator still
** REGULATES, under heavy load. Vin is swept upward and dropout is read at the first point where
** the output is genuinely in regulation.
**
** REWRITTEN 2026-07-21. The previous form was
**     meas dc vin_at WHEN v(vout)=1.568 RISE=1
**     let v_dropout = vin_at - 1.568
** i.e. purely "when does vout first rise past a threshold". That cannot tell REGULATION from a
** DEAD PASS DEVICE, and it fails in the worst possible direction — optimistically. When the loop
** is not working the pass transistor sits fully on, so vout simply follows vin; vout then crosses
** VOUT_THRESH at vin ~ VOUT_THRESH and the bench reports a dropout of ~0. A completely broken
** regulator scores a PERFECT dropout number.
**
** That is not hypothetical: it green-lit a real candidate here. A resistor-biased variant of
** ldo_005_buffered_ref reported dropout 0.090 V (against 0.490 V for the working design) while
** actually RAILING below ~3.1 V — vout was 2.59 V at vin 2.6 V. Only line_reg (1.185 V) caught it.
** This is the same class of defect as the amplifier ICMR bench measuring rail coincidence instead
** of tracking, and it takes the same cure: an ACTIVITY criterion alongside the level test.
**
** In regulation now requires BOTH:
**   * the output is at its target:      |vout - VOUT_NOM| <= VREG_TOL
**   * the output is not following vin:  |dvout/dvin| <= REG_SLOPE_MAX
** A regulating LDO has dvout/dvin ~ line-regulation slope (1e-3 or less); a railed one has ~1, so
** the slope test separates them cleanly no matter where the level test happens to land.
**
** Bindings: DUT PORT_LINE ILOAD VDD_START VDD_STOP VDD_STEP VOUT_NOM VREG_TOL REG_SLOPE_MAX
**           PDK_INCLUDE.
** VOUT_NOM defaults to the datasheet's default_conditions.vout typical value; VREG_TOL and
** REG_SLOPE_MAX have defaults in assemble.py, so existing circuits need no edits. The legacy
** VOUT_THRESH binding is no longer used — a threshold alone is exactly what was wrong.
.include design.ngspice
.lib sm141064.ngspice noise_corner
.lib sm141064.ngspice nfet_03v3_t
.lib sm141064.ngspice pfet_03v3_t
.lib sm141064.ngspice fets_mm
.lib sm141064.ngspice res_typical
.lib sm141064.ngspice mimcap_typical
.lib sm141064.ngspice cap_mim
.temp 27

Vdd  vdd 0 dc 1.0
Vss  vss 0 dc 0
Iload vout 0 dc 5m

XDUT vdd vout vss ldo_001_analoggym_basic

.control
  set filetype=ascii
  dc Vdd 1.0 2.0 0.01
  let vo    = v(vout)
  let vsw   = v(vdd)
  let dvo   = deriv(vo)
  let dvi   = deriv(vsw)
  let slope = dvo / dvi
  let inreg = (abs(vo - 1.6) <= 0.05) & (abs(slope) <= 0.1)
  let npts  = length(inreg)
  let k     = 0
  let found = 0
  let vin_at = 0
  let vout_at = 0
  while k < npts
    if found < 0.5
      if inreg[k] > 0.5
        let vin_at  = vsw[k]
        let vout_at = vo[k]
        let found   = 1
      end
    end
    let k = k + 1
  end
  * NaN rather than a fabricated number when the sweep never reaches regulation — an honest
  * "this circuit does not regulate anywhere in the swept range".
  if found < 0.5
    * 0*log(0) — NOT 0/0: ngspice-45 hard-errors on 0/0 ("argument out of range for
    * divide"), so the vector never exists and the runner reports sim_error instead of
    * the intended honest NaN (found live on ldo_004's committed sizing, 2026-07-24).
    let v_dropout = 0*log(0)
  else
    let v_dropout = vin_at - vout_at
  end
  print vin_at vout_at v_dropout
  write
  quit
.endc
.param x_dut_xm0_w=5u
.param x_dut_xm0_l=1u
.param x_dut_xm0_m=3
.param x_dut_xm8_w=5u
.param x_dut_xm8_l=0.5u
.param x_dut_xm8_m=4
.param x_dut_xm10_w=8u
.param x_dut_xm10_l=0.28u
.param x_dut_xm10_m=80
.param x_dut_xm11_w=9u
.param x_dut_xm11_l=0.28u
.param x_dut_xm11_m=928
.param x_dut_xm14_w=1.5u
.param x_dut_xm14_l=1u
.param x_dut_xm14_m=10
.param x_dut_xm22_w=6u
.param x_dut_xm22_l=0.28u
.param x_dut_xm22_m=1000
.param r_top=300k
.param r_bot=100k
.param c_comp=6.8p
.param vref_val=0.4
.param i_bias=8u
* ---- GENERATED parameter ties (abstract/params.yaml groups/ratios) ----
* Each tied symbol is defined exactly once, by its line below; rewrite that
* .param to untie just that symbol (untying = shadowing, plan D-3).
.param x_dut_xm1_w = {x_dut_xm0_w}
.param x_dut_xm2_w = {x_dut_xm0_w}
.param x_dut_xm3_w = {x_dut_xm0_w}
.param x_dut_xm4_w = {x_dut_xm0_w}
.param x_dut_xm7_w = {x_dut_xm0_w}
.param x_dut_xm24_w = {x_dut_xm0_w}
.param x_dut_xm5_w = {x_dut_xm0_w}
.param x_dut_xm6_w = {x_dut_xm0_w}
.param x_dut_xm1_l = {x_dut_xm0_l}
.param x_dut_xm2_l = {x_dut_xm0_l}
.param x_dut_xm3_l = {x_dut_xm0_l}
.param x_dut_xm4_l = {x_dut_xm0_l}
.param x_dut_xm7_l = {x_dut_xm0_l}
.param x_dut_xm24_l = {x_dut_xm0_l}
.param x_dut_xm5_l = {x_dut_xm0_l}
.param x_dut_xm6_l = {x_dut_xm0_l}
.param x_dut_xm9_w = {x_dut_xm8_w}
.param x_dut_xm9_l = {x_dut_xm8_l}
.param x_dut_xm9_m = {x_dut_xm8_m}
.param x_dut_xm12_w = {x_dut_xm14_w}
.param x_dut_xm13_w = {x_dut_xm14_w}
.param x_dut_xm15_w = {x_dut_xm14_w}
.param x_dut_xm16_w = {x_dut_xm14_w}
.param x_dut_xm17_w = {x_dut_xm14_w}
.param x_dut_xm18_w = {x_dut_xm14_w}
.param x_dut_xm19_w = {x_dut_xm14_w}
.param x_dut_xm20_w = {x_dut_xm14_w}
.param x_dut_xm12_l = {x_dut_xm14_l}
.param x_dut_xm13_l = {x_dut_xm14_l}
.param x_dut_xm15_l = {x_dut_xm14_l}
.param x_dut_xm16_l = {x_dut_xm14_l}
.param x_dut_xm17_l = {x_dut_xm14_l}
.param x_dut_xm18_l = {x_dut_xm14_l}
.param x_dut_xm19_l = {x_dut_xm14_l}
.param x_dut_xm20_l = {x_dut_xm14_l}
.param x_dut_xm21_w = {x_dut_xm22_w}
.param x_dut_xm21_l = {x_dut_xm22_l}
.param x_dut_xm21_m = {x_dut_xm22_m}
.param x_dut_xm1_m = {x_dut_xm0_m*1}
.param x_dut_xm2_m = {x_dut_xm0_m*1}
.param x_dut_xm3_m = {x_dut_xm0_m*1}
.param x_dut_xm4_m = {x_dut_xm0_m*2}
.param x_dut_xm7_m = {x_dut_xm0_m*1}
.param x_dut_xm24_m = {x_dut_xm0_m*1}
.param x_dut_xm5_m = {x_dut_xm0_m*1}
.param x_dut_xm6_m = {x_dut_xm0_m*1}
.param x_dut_xm12_m = {x_dut_xm14_m*4}
.param x_dut_xm13_m = {x_dut_xm14_m*4}
.param x_dut_xm15_m = {x_dut_xm14_m*4}
.param x_dut_xm16_m = {x_dut_xm14_m*4}
.param x_dut_xm17_m = {x_dut_xm14_m*4}
.param x_dut_xm18_m = {x_dut_xm14_m*4}
.param x_dut_xm19_m = {x_dut_xm14_m*8}
.param x_dut_xm20_m = {x_dut_xm14_m*8}
.subckt ldo_001_analoggym_basic vdd vout vss
C0 net106 vout 'c_comp'
IBIAS ib vss dc {i_bias}
R1 lp_brk vfb 'r_top'
R2 vfb vss 'r_bot'
VLP lp_brk vout dc 0
VREF vref vss dc {vref_val}
XM0 ib ib vdd vdd pfet_03v3 l=x_dut_xm0_l m=x_dut_xm0_m w=x_dut_xm0_w
XM1 vb4 ib vdd vdd pfet_03v3 l=x_dut_xm1_l m=x_dut_xm1_m w=x_dut_xm1_w
XM10 net12 net10 net1 net1 pfet_03v3 l=x_dut_xm10_l m=x_dut_xm10_m w=x_dut_xm10_w
XM11 vout net1 vdd vdd pfet_03v3 l=x_dut_xm11_l m=x_dut_xm11_m w=x_dut_xm11_w
XM12 vb4 vb3 net28 vss nfet_03v3 l=x_dut_xm12_l m=x_dut_xm12_m w=x_dut_xm12_w
XM13 dm_1 vb3 net31 vss nfet_03v3 l=x_dut_xm13_l m=x_dut_xm13_m w=x_dut_xm13_w
XM14 vb3 vb3 vss vss nfet_03v3 l=x_dut_xm14_l m=x_dut_xm14_m w=x_dut_xm14_w
XM15 voutn vb3 dm_2 vss nfet_03v3 l=x_dut_xm15_l m=x_dut_xm15_m w=x_dut_xm15_w
XM16 net10 vb3 net106 vss nfet_03v3 l=x_dut_xm16_l m=x_dut_xm16_m w=x_dut_xm16_w
XM17 net28 vb4 vss vss nfet_03v3 l=x_dut_xm17_l m=x_dut_xm17_m w=x_dut_xm17_w
XM18 net31 vb4 vss vss nfet_03v3 l=x_dut_xm18_l m=x_dut_xm18_m w=x_dut_xm18_w
XM19 dm_2 vb4 vss vss nfet_03v3 l=x_dut_xm19_l m=x_dut_xm19_m w=x_dut_xm19_w
XM2 dm_1 ib vdd vdd pfet_03v3 l=x_dut_xm2_l m=x_dut_xm2_m w=x_dut_xm2_w
XM20 net106 vb4 vss vss nfet_03v3 l=x_dut_xm20_l m=x_dut_xm20_m w=x_dut_xm20_w
XM21 net12 net7 vss vss nfet_03v3 l=x_dut_xm21_l m=x_dut_xm21_m w=x_dut_xm21_w
XM22 net7 net7 vss vss nfet_03v3 l=x_dut_xm22_l m=x_dut_xm22_m w=x_dut_xm22_w
XM24 net1 ib vdd vdd pfet_03v3 l=x_dut_xm24_l m=x_dut_xm24_m w=x_dut_xm24_w
XM3 vb3 ib vdd vdd pfet_03v3 l=x_dut_xm3_l m=x_dut_xm3_m w=x_dut_xm3_w
XM4 net20 ib vdd vdd pfet_03v3 l=x_dut_xm4_l m=x_dut_xm4_m w=x_dut_xm4_w
XM5 voutn voutn vdd vdd pfet_03v3 l=x_dut_xm5_l m=x_dut_xm5_m w=x_dut_xm5_w
XM6 net10 voutn vdd vdd pfet_03v3 l=x_dut_xm6_l m=x_dut_xm6_m w=x_dut_xm6_w
XM7 net7 ib vdd vdd pfet_03v3 l=x_dut_xm7_l m=x_dut_xm7_m w=x_dut_xm7_w
XM8 dm_2 vfb net20 net20 pfet_03v3 l=x_dut_xm8_l m=x_dut_xm8_m w=x_dut_xm8_w
XM9 net106 vref net20 net20 pfet_03v3 l=x_dut_xm9_l m=x_dut_xm9_m w=x_dut_xm9_w
.ends
.end
