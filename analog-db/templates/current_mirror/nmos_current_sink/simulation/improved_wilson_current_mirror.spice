** sch_path: improved_wilson_current_mirror.sch
**.subckt improved_wilson_current_mirror VSS iin iout
*.iopin VSS
*.iopin iin
*.iopin iout
XM1 net2 net1 VSS VSS sg13_lv_nmos w=0.15u l=0.13u ng=1 m=1
XM2 net1 net1 VSS VSS sg13_lv_nmos w=0.15u l=0.13u ng=1 m=1
XM3 iout iin net1 VSS sg13_lv_nmos w=0.15u l=0.13u ng=1 m=1
XM4 iin iin net2 VSS sg13_lv_nmos w=0.15u l=0.13u ng=1 m=1
**.ends
.end
