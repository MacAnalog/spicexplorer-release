** GENERATED by `analog-db export-raw` — DO NOT EDIT.
** circuit=amp_025_hsu_classab_ota  class=amplifier  pdk=ihp-sg13g2  testbench=ac_open_loop  corner=tt
** Self-contained deck: testbench + bound params + lowered DUT (.subckt amp_025_hsu_classab_ota).
** PDK corner libs resolve by BARE NAME on the image's ngspice sourcepath — run in a
** PDK-enabled env (the base image / api container), NOT a bare host:
**   docker run --rm -i spicexplorer-spice-base:local \
**     bash -lc 'd=$(mktemp -d) && cat > $d/c.spice && cd $d && ngspice -b c.spice' < raw/amp_025_hsu_classab_ota/ihp-sg13g2/ac_open_loop.spice
*----------------------------------------------------------*
** params: 37 free + 13 frozen knobs (sizing.yaml) · 40 tied · 0 ratio-derived (abstract/params.yaml) · 3 testbench params
** AUTHORED TEMPLATE — amplifier/ac_open_loop_diff (fully-differential open-loop AC).
** Open-loop DIFFERENTIAL gain/phase of a self-biased FD OTA (internal current reference,
** no external ibias port; e.g. amp_020_two_stage_miller_cmfb). Differential input driven directly
** — no AnalogGym-style bias-wrap needed: unlike a single-ended amp with no output
** feedback of any kind, a genuinely SYMMETRIC differential topology driven by MATCHED
** (vinp=vinn=VCM) inputs gives a well-defined output OFFSET regardless of open-loop gain
** — both branches move together, not apart, so there is nothing for the gain to amplify
** into a rail. (The output COMMON MODE still has to be centered by sizing — see
** pdk/<pdk>/sizing.yaml — but that's a device-sizing concern, not a testbench one.)
**
** Required bindings: DUT (subckt name), PORT_LINE (instance port order = circuit.yaml
**   ports: vinp vinn voutp voutn vdd vss), VDD VCM CL, FSTART FSTOP PPD,
**   PDK_INCLUDE (.lib/.include lines for the bound PDK+corner).
*----------------------------------------------------------*
.lib cornerMOSlv.lib mos_tt
.temp 27

.param VDD=1.2
.param VCM=0.6
.param CL=10p

Vdd  vdd 0 dc {VDD}
Vss  vss 0 dc 0
CLoadp voutp 0 {CL}
CLoadn voutn 0 {CL}

* DUT instance (port order = circuit.yaml ports)
XDUT vinp vinn voutp voutn vdd vss amp_025_hsu_classab_ota

* --- input drive (AC open loop, differential) ---
Vcm  vcm 0 dc {VCM}
Vinp vinp vcm dc 0 ac 0.5
Vinn vinn vcm dc 0 ac -0.5

.control
  set filetype=ascii
  ac dec 101 10 1G
  let vodm = v(voutp) - v(voutn)
  * db()/cph() must be precomputed as their own vectors before use in .meas FIND/WHEN —
  * ngspice's vdb()/cph() shorthand only resolves against real circuit nodes, not a
  * `let`-derived vector like vodm, so a bare `FIND db(vodm)` fails to resolve.
  let dbvodm = db(vodm)
  meas ac dcgain  FIND dbvodm  AT=10
  meas ac ugf     WHEN dbvodm=0 FALL=1
  * cph() = continuous (unwrapped) phase — vp() wraps at +/-180 and corrupts PM for
  * multi-pole phase trajectories; normalize to the DC phase so PM = 180 - total phase lag.
  let phc = cph(vodm)*180/3.14159265
  let ph = 180 + phc - phc[0]
  meas ac pm      FIND ph WHEN dbvodm=0 FALL=1
  write
  quit
.endc
.param x_dut_xm1_w=20u
.param x_dut_xm1_l=1u
.param x_dut_xm2_w=20u
.param x_dut_xm2_l=0.5u
.param x_dut_xm4_w=4u
.param x_dut_xm4_l=0.5u
.param x_dut_xm6_w=8u
.param x_dut_xm7_w=5u
.param x_dut_xm7_l=0.3u
.param x_dut_xm10_w=10u
.param x_dut_xm10_l=0.3u
.param x_dut_xm12_w=10u
.param x_dut_xm12_l=0.5u
.param x_dut_xm14_w=3u
.param x_dut_xm14_l=0.5u
.param x_dut_xm15_w=16u
.param x_dut_xm15_l=0.5u
.param x_dut_xm16_w=5u
.param x_dut_xm16_l=0.3u
.param x_dut_xm17_w=16u
.param x_dut_xm17_l=0.5u
.param x_dut_xm18_w=20u
.param x_dut_xm18_l=0.3u
.param x_dut_xm19_w=2u
.param x_dut_xm19_l=0.5u
.param x_dut_c1_value=1p
.param x_dut_r1_value=100k
.param x_dut_rmp_value=1Meg
.param gm_val=100u
.param rout_val=10Meg
.param rin_val=1.0e12
.param cout_val=10p
.param cin_val=10f
.param vb1=0.55
.param vb2=0.45
.param vb3=0.75
.param vcmfb_ref=0.6
.param x_dut_xm1_m=1
.param x_dut_xm2_m=1
.param x_dut_xm4_m=1
.param x_dut_xm6_m=1
.param x_dut_xm7_m=1
.param x_dut_xm10_m=1
.param x_dut_xm12_m=1
.param x_dut_xm14_m=1
.param x_dut_xm15_m=1
.param x_dut_xm16_m=1
.param x_dut_xm17_m=1
.param x_dut_xm18_m=1
.param x_dut_xm19_m=1
* ---- GENERATED parameter ties (abstract/params.yaml groups/ratios) ----
* Each tied symbol is defined exactly once, by its line below; rewrite that
* .param to untie just that symbol (untying = shadowing, plan D-3).
.param x_dut_xm3_w = {x_dut_xm2_w}
.param x_dut_xm3_l = {x_dut_xm2_l}
.param x_dut_xm3_m = {x_dut_xm2_m}
.param x_dut_xm5_w = {x_dut_xm4_w}
.param x_dut_xm5_l = {x_dut_xm4_l}
.param x_dut_xm5_m = {x_dut_xm4_m}
.param x_dut_xm8_l = {x_dut_xm4_l}
.param x_dut_xm6_l = {x_dut_xm5_l}
.param x_dut_xm8_w = {x_dut_xm6_w}
.param x_dut_xm8_m = {x_dut_xm6_m}
.param x_dut_xm9_w = {x_dut_xm7_w}
.param x_dut_xm9_l = {x_dut_xm7_l}
.param x_dut_xm9_m = {x_dut_xm7_m}
.param x_dut_xm11_w = {x_dut_xm10_w}
.param x_dut_xm11_l = {x_dut_xm10_l}
.param x_dut_xm11_m = {x_dut_xm10_m}
.param x_dut_xm13_w = {x_dut_xm12_w}
.param x_dut_xm13_l = {x_dut_xm12_l}
.param x_dut_xm13_m = {x_dut_xm12_m}
.param x_dut_xm20_w = {x_dut_xm14_w}
.param x_dut_xm20_l = {x_dut_xm14_l}
.param x_dut_xm20_m = {x_dut_xm14_m}
.param x_dut_xm21_w = {x_dut_xm15_w}
.param x_dut_xm21_l = {x_dut_xm15_l}
.param x_dut_xm21_m = {x_dut_xm15_m}
.param x_dut_xm22_w = {x_dut_xm16_w}
.param x_dut_xm22_l = {x_dut_xm16_l}
.param x_dut_xm22_m = {x_dut_xm16_m}
.param x_dut_xm23_w = {x_dut_xm17_w}
.param x_dut_xm23_l = {x_dut_xm17_l}
.param x_dut_xm23_m = {x_dut_xm17_m}
.param x_dut_xm24_w = {x_dut_xm18_w}
.param x_dut_xm24_l = {x_dut_xm18_l}
.param x_dut_xm24_m = {x_dut_xm18_m}
.param x_dut_xm25_w = {x_dut_xm19_w}
.param x_dut_xm25_l = {x_dut_xm19_l}
.param x_dut_xm25_m = {x_dut_xm19_m}
.param x_dut_c2_value = {x_dut_c1_value}
.param x_dut_r2_value = {x_dut_r1_value}
.param x_dut_rmn_value = {x_dut_rmp_value}
.subckt amp_025_hsu_classab_ota vinp vinn voutp voutn vdd vss
C1 abm_p zc_p 'x_dut_c1_value'
C2 abm_n zc_n 'x_dut_c2_value'
CIN cm_det vcmfb_ref 'cin_val'
COUT vss vcmfb 'cout_val'
GM vss vcmfb vcmfb_ref cm_det {gm_val}
R1 zc_p drv_p 'x_dut_r1_value'
R2 drv_n zc_n 'x_dut_r2_value'
RIN cm_det vcmfb_ref 'rin_val'
RMN voutn cm_det 'x_dut_rmn_value'
RMP cm_det voutp 'x_dut_rmp_value'
ROUT vss vcmfb 'rout_val'
VB1 vb1 vss dc {vb1}
VB2 vb2 vss dc {vb2}
VB3 vb3 vss dc {vb3}
VCMFB_REF vcmfb_ref vss dc {vcmfb_ref}
XM1 tail vb1 vdd vdd sg13_lv_pmos l=x_dut_xm1_l m=x_dut_xm1_m w=x_dut_xm1_w
XM10 drv_n vb2 psrc_n vdd sg13_lv_pmos l=x_dut_xm10_l m=x_dut_xm10_m w=x_dut_xm10_w
XM11 drv_p vb2 psrc_p vdd sg13_lv_pmos l=x_dut_xm11_l m=x_dut_xm11_m w=x_dut_xm11_w
XM12 psrc_n vcmfb vdd vdd sg13_lv_pmos l=x_dut_xm12_l m=x_dut_xm12_m w=x_dut_xm12_w
XM13 psrc_p vcmfb vdd vdd sg13_lv_pmos l=x_dut_xm13_l m=x_dut_xm13_m w=x_dut_xm13_w
XM14 gnf_p vb1 vdd vdd sg13_lv_pmos l=x_dut_xm14_l m=x_dut_xm14_m w=x_dut_xm14_w
XM15 gnf_p gnf_p abm_p vss sg13_lv_nmos l=x_dut_xm15_l m=x_dut_xm15_m w=x_dut_xm15_w
XM16 vdd gnf_p voutp vss sg13_lv_nmos l=x_dut_xm16_l m=x_dut_xm16_m w=x_dut_xm16_w
XM17 gpf_p gpf_p abm_p vdd sg13_lv_pmos l=x_dut_xm17_l m=x_dut_xm17_m w=x_dut_xm17_w
XM18 vss gpf_p voutp vdd sg13_lv_pmos l=x_dut_xm18_l m=x_dut_xm18_m w=x_dut_xm18_w
XM19 gpf_p drv_p vss vss sg13_lv_nmos l=x_dut_xm19_l m=x_dut_xm19_m w=x_dut_xm19_w
XM2 mir_p vinn tail vdd sg13_lv_pmos l=x_dut_xm2_l m=x_dut_xm2_m w=x_dut_xm2_w
XM20 gnf_n vb1 vdd vdd sg13_lv_pmos l=x_dut_xm20_l m=x_dut_xm20_m w=x_dut_xm20_w
XM21 gnf_n gnf_n abm_n vss sg13_lv_nmos l=x_dut_xm21_l m=x_dut_xm21_m w=x_dut_xm21_w
XM22 vdd gnf_n voutn vss sg13_lv_nmos l=x_dut_xm22_l m=x_dut_xm22_m w=x_dut_xm22_w
XM23 gpf_n gpf_n abm_n vdd sg13_lv_pmos l=x_dut_xm23_l m=x_dut_xm23_m w=x_dut_xm23_w
XM24 vss gpf_n voutn vdd sg13_lv_pmos l=x_dut_xm24_l m=x_dut_xm24_m w=x_dut_xm24_w
XM25 gpf_n drv_n vss vss sg13_lv_nmos l=x_dut_xm25_l m=x_dut_xm25_m w=x_dut_xm25_w
XM3 mir_n vinp tail vdd sg13_lv_pmos l=x_dut_xm3_l m=x_dut_xm3_m w=x_dut_xm3_w
XM4 mir_p mir_p vss vss sg13_lv_nmos l=x_dut_xm4_l m=x_dut_xm4_m w=x_dut_xm4_w
XM5 mir_n mir_n vss vss sg13_lv_nmos l=x_dut_xm5_l m=x_dut_xm5_m w=x_dut_xm5_w
XM6 csrc_n mir_n vss vss sg13_lv_nmos l=x_dut_xm6_l m=x_dut_xm6_m w=x_dut_xm6_w
XM7 drv_n vb3 csrc_n vss sg13_lv_nmos l=x_dut_xm7_l m=x_dut_xm7_m w=x_dut_xm7_w
XM8 csrc_p mir_p vss vss sg13_lv_nmos l=x_dut_xm8_l m=x_dut_xm8_m w=x_dut_xm8_w
XM9 drv_p vb3 csrc_p vss sg13_lv_nmos l=x_dut_xm9_l m=x_dut_xm9_m w=x_dut_xm9_w
.ends
.end
