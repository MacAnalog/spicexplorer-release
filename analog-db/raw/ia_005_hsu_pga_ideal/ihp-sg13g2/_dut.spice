** GENERATED by `analog-db export-raw` — DO NOT EDIT.
** Standalone lowered DUT subckt for ia_005_hsu_pga_ideal on ihp-sg13g2 (sizing .param defaults + .subckt).
** Not a runnable deck on its own — include it under your own testbench:
**   .include _dut.spice
**   XDUT vinp vinn voutp voutn VDD VSS VCM V_D0 V_D0_NOT V_D1 V_D1_NOT V_D2 V_D2_NOT ia_005_hsu_pga_ideal
** Source: pdk/ihp-sg13g2/netlist.spice (run `analog-db generate` to refresh).
*----------------------------------------------------------*
** params: 13 free + 7 frozen knobs (sizing.yaml) · 80 tied · 0 ratio-derived (abstract/params.yaml)
.param Cu=1p
.param x_dut_cf1_value=1p
.param x_dut_xma1_w=0.15u
.param x_dut_xma1_l=0.13u
.param x_dut_xma2_w=0.15u
.param x_dut_xma2_l=0.13u
.param x_dut_xm1_w=0.15u
.param x_dut_xm1_l=0.13u
.param gm_val=100u
.param rout_val=10Meg
.param rin_val=1e12
.param cout_val=100f
.param cin_val=10f
.param x_dut_xma1_m=1
.param x_dut_xma2_m=1
.param x_dut_xm1_m=1
.param x_dut_ca1_m=1
.param x_dut_ca2_m=1
.param x_dut_ca3_m=2
.param x_dut_ca4_m=4
* ---- GENERATED parameter ties (abstract/params.yaml groups/ratios) ----
* Each tied symbol is defined exactly once, by its line below; rewrite that
* .param to untie just that symbol (untying = shadowing, plan D-3).
.param x_dut_xma3_w = {x_dut_xma1_w}
.param x_dut_xma5_w = {x_dut_xma1_w}
.param x_dut_xma7_w = {x_dut_xma1_w}
.param x_dut_xma9_w = {x_dut_xma1_w}
.param x_dut_xma11_w = {x_dut_xma1_w}
.param x_dut_xmb1_w = {x_dut_xma1_w}
.param x_dut_xmb3_w = {x_dut_xma1_w}
.param x_dut_xmb5_w = {x_dut_xma1_w}
.param x_dut_xmb7_w = {x_dut_xma1_w}
.param x_dut_xmb9_w = {x_dut_xma1_w}
.param x_dut_xmb11_w = {x_dut_xma1_w}
.param x_dut_xma3_l = {x_dut_xma1_l}
.param x_dut_xma5_l = {x_dut_xma1_l}
.param x_dut_xma7_l = {x_dut_xma1_l}
.param x_dut_xma9_l = {x_dut_xma1_l}
.param x_dut_xma11_l = {x_dut_xma1_l}
.param x_dut_xmb1_l = {x_dut_xma1_l}
.param x_dut_xmb3_l = {x_dut_xma1_l}
.param x_dut_xmb5_l = {x_dut_xma1_l}
.param x_dut_xmb7_l = {x_dut_xma1_l}
.param x_dut_xmb9_l = {x_dut_xma1_l}
.param x_dut_xmb11_l = {x_dut_xma1_l}
.param x_dut_xma3_m = {x_dut_xma1_m}
.param x_dut_xma5_m = {x_dut_xma1_m}
.param x_dut_xma7_m = {x_dut_xma1_m}
.param x_dut_xma9_m = {x_dut_xma1_m}
.param x_dut_xma11_m = {x_dut_xma1_m}
.param x_dut_xmb1_m = {x_dut_xma1_m}
.param x_dut_xmb3_m = {x_dut_xma1_m}
.param x_dut_xmb5_m = {x_dut_xma1_m}
.param x_dut_xmb7_m = {x_dut_xma1_m}
.param x_dut_xmb9_m = {x_dut_xma1_m}
.param x_dut_xmb11_m = {x_dut_xma1_m}
.param x_dut_xma4_w = {x_dut_xma2_w}
.param x_dut_xma6_w = {x_dut_xma2_w}
.param x_dut_xma8_w = {x_dut_xma2_w}
.param x_dut_xma10_w = {x_dut_xma2_w}
.param x_dut_xma12_w = {x_dut_xma2_w}
.param x_dut_xmb2_w = {x_dut_xma2_w}
.param x_dut_xmb4_w = {x_dut_xma2_w}
.param x_dut_xmb6_w = {x_dut_xma2_w}
.param x_dut_xmb8_w = {x_dut_xma2_w}
.param x_dut_xmb10_w = {x_dut_xma2_w}
.param x_dut_xmb12_w = {x_dut_xma2_w}
.param x_dut_xma4_l = {x_dut_xma2_l}
.param x_dut_xma6_l = {x_dut_xma2_l}
.param x_dut_xma8_l = {x_dut_xma2_l}
.param x_dut_xma10_l = {x_dut_xma2_l}
.param x_dut_xma12_l = {x_dut_xma2_l}
.param x_dut_xmb2_l = {x_dut_xma2_l}
.param x_dut_xmb4_l = {x_dut_xma2_l}
.param x_dut_xmb6_l = {x_dut_xma2_l}
.param x_dut_xmb8_l = {x_dut_xma2_l}
.param x_dut_xmb10_l = {x_dut_xma2_l}
.param x_dut_xmb12_l = {x_dut_xma2_l}
.param x_dut_xma4_m = {x_dut_xma2_m}
.param x_dut_xma6_m = {x_dut_xma2_m}
.param x_dut_xma8_m = {x_dut_xma2_m}
.param x_dut_xma10_m = {x_dut_xma2_m}
.param x_dut_xma12_m = {x_dut_xma2_m}
.param x_dut_xmb2_m = {x_dut_xma2_m}
.param x_dut_xmb4_m = {x_dut_xma2_m}
.param x_dut_xmb6_m = {x_dut_xma2_m}
.param x_dut_xmb8_m = {x_dut_xma2_m}
.param x_dut_xmb10_m = {x_dut_xma2_m}
.param x_dut_xmb12_m = {x_dut_xma2_m}
.param x_dut_xm2_w = {x_dut_xm1_w}
.param x_dut_xm3_w = {x_dut_xm1_w}
.param x_dut_xm4_w = {x_dut_xm1_w}
.param x_dut_xm2_l = {x_dut_xm1_l}
.param x_dut_xm3_l = {x_dut_xm1_l}
.param x_dut_xm4_l = {x_dut_xm1_l}
.param x_dut_xm2_m = {x_dut_xm1_m}
.param x_dut_xm3_m = {x_dut_xm1_m}
.param x_dut_xm4_m = {x_dut_xm1_m}
.param x_dut_cf2_value = {x_dut_cf1_value}
.param x_dut_cb1_m = {x_dut_ca1_m}
.param x_dut_cb2_m = {x_dut_ca2_m}
.param x_dut_cb3_m = {x_dut_ca3_m}
.param x_dut_cb4_m = {x_dut_ca4_m}
.subckt ia_005_hsu_pga_ideal vinp vinn voutp voutn VDD VSS VCM V_D0 V_D0_NOT V_D1 V_D1_NOT V_D2 V_D2_NOT
CA1 sum_p vinp 'Cu' m=x_dut_ca1_m
CA2 sum_p bota0 'Cu' m=x_dut_ca2_m
CA3 sum_p bota1 'Cu' m=x_dut_ca3_m
CA4 sum_p bota2 'Cu' m=x_dut_ca4_m
CB1 sum_n vinn 'Cu' m=x_dut_cb1_m
CB2 sum_n botb0 'Cu' m=x_dut_cb2_m
CB3 sum_n botb1 'Cu' m=x_dut_cb3_m
CB4 sum_n botb2 'Cu' m=x_dut_cb4_m
CF1 voutp sum_p 'x_dut_cf1_value'
CF2 voutn sum_n 'x_dut_cf2_value'
CIN sum_p sum_n 'cin_val'
COUT voutp voutn 'cout_val'
GM voutp voutn sum_p sum_n {gm_val}
RIN sum_p sum_n 'rin_val'
ROUT voutp voutn 'rout_val'
XM1 sum_p sum_p pr_mid_p pr_mid_p sg13_lv_pmos l=x_dut_xm1_l m=x_dut_xm1_m w=x_dut_xm1_w
XM2 voutp voutp pr_mid_p pr_mid_p sg13_lv_pmos l=x_dut_xm2_l m=x_dut_xm2_m w=x_dut_xm2_w
XM3 voutn voutn pr_mid_n pr_mid_n sg13_lv_pmos l=x_dut_xm3_l m=x_dut_xm3_m w=x_dut_xm3_w
XM4 sum_n sum_n pr_mid_n pr_mid_n sg13_lv_pmos l=x_dut_xm4_l m=x_dut_xm4_m w=x_dut_xm4_w
XMA1 vinp V_D0 bota0 VSS sg13_lv_nmos l=x_dut_xma1_l m=x_dut_xma1_m w=x_dut_xma1_w
XMA10 bota2 V_D2_NOT vinp VDD sg13_lv_pmos l=x_dut_xma10_l m=x_dut_xma10_m w=x_dut_xma10_w
XMA11 VCM V_D2_NOT bota2 VSS sg13_lv_nmos l=x_dut_xma11_l m=x_dut_xma11_m w=x_dut_xma11_w
XMA12 bota2 V_D2 VCM VDD sg13_lv_pmos l=x_dut_xma12_l m=x_dut_xma12_m w=x_dut_xma12_w
XMA2 bota0 V_D0_NOT vinp VDD sg13_lv_pmos l=x_dut_xma2_l m=x_dut_xma2_m w=x_dut_xma2_w
XMA3 VCM V_D0_NOT bota0 VSS sg13_lv_nmos l=x_dut_xma3_l m=x_dut_xma3_m w=x_dut_xma3_w
XMA4 bota0 V_D0 VCM VDD sg13_lv_pmos l=x_dut_xma4_l m=x_dut_xma4_m w=x_dut_xma4_w
XMA5 vinp V_D1 bota1 VSS sg13_lv_nmos l=x_dut_xma5_l m=x_dut_xma5_m w=x_dut_xma5_w
XMA6 bota1 V_D1_NOT vinp VDD sg13_lv_pmos l=x_dut_xma6_l m=x_dut_xma6_m w=x_dut_xma6_w
XMA7 VCM V_D1_NOT bota1 VSS sg13_lv_nmos l=x_dut_xma7_l m=x_dut_xma7_m w=x_dut_xma7_w
XMA8 bota1 V_D1 VCM VDD sg13_lv_pmos l=x_dut_xma8_l m=x_dut_xma8_m w=x_dut_xma8_w
XMA9 vinp V_D2 bota2 VSS sg13_lv_nmos l=x_dut_xma9_l m=x_dut_xma9_m w=x_dut_xma9_w
XMB1 vinn V_D0 botb0 VSS sg13_lv_nmos l=x_dut_xmb1_l m=x_dut_xmb1_m w=x_dut_xmb1_w
XMB10 botb2 V_D2_NOT vinn VDD sg13_lv_pmos l=x_dut_xmb10_l m=x_dut_xmb10_m w=x_dut_xmb10_w
XMB11 VCM V_D2_NOT botb2 VSS sg13_lv_nmos l=x_dut_xmb11_l m=x_dut_xmb11_m w=x_dut_xmb11_w
XMB12 botb2 V_D2 VCM VDD sg13_lv_pmos l=x_dut_xmb12_l m=x_dut_xmb12_m w=x_dut_xmb12_w
XMB2 botb0 V_D0_NOT vinn VDD sg13_lv_pmos l=x_dut_xmb2_l m=x_dut_xmb2_m w=x_dut_xmb2_w
XMB3 VCM V_D0_NOT botb0 VSS sg13_lv_nmos l=x_dut_xmb3_l m=x_dut_xmb3_m w=x_dut_xmb3_w
XMB4 botb0 V_D0 VCM VDD sg13_lv_pmos l=x_dut_xmb4_l m=x_dut_xmb4_m w=x_dut_xmb4_w
XMB5 vinn V_D1 botb1 VSS sg13_lv_nmos l=x_dut_xmb5_l m=x_dut_xmb5_m w=x_dut_xmb5_w
XMB6 botb1 V_D1_NOT vinn VDD sg13_lv_pmos l=x_dut_xmb6_l m=x_dut_xmb6_m w=x_dut_xmb6_w
XMB7 VCM V_D1_NOT botb1 VSS sg13_lv_nmos l=x_dut_xmb7_l m=x_dut_xmb7_m w=x_dut_xmb7_w
XMB8 botb1 V_D1 VCM VDD sg13_lv_pmos l=x_dut_xmb8_l m=x_dut_xmb8_m w=x_dut_xmb8_w
XMB9 vinn V_D2 botb2 VSS sg13_lv_nmos l=x_dut_xmb9_l m=x_dut_xmb9_m w=x_dut_xmb9_w
.ends
