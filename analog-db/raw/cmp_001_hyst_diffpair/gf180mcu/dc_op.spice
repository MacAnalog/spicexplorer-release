** GENERATED by `analog-db export-raw` — DO NOT EDIT.
** circuit=cmp_001_hyst_diffpair  class=comparator  pdk=gf180mcu  testbench=dc_op  corner=tt
** Self-contained deck: testbench + bound params + lowered DUT (.subckt cmp_001_hyst_diffpair).
** PDK corner libs resolve by BARE NAME on the image's ngspice sourcepath — run in a
** PDK-enabled env (the base image / api container), NOT a bare host:
**   docker run --rm -i spicexplorer-spice-base:local \
**     bash -lc 'd=$(mktemp -d) && cat > $d/c.spice && cd $d && ngspice -b c.spice' < raw/cmp_001_hyst_diffpair/gf180mcu/dc_op.spice
*----------------------------------------------------------*
** params: 10 free + 12 frozen knobs (sizing.yaml) · 17 tied · 0 ratio-derived (abstract/params.yaml) · 3 testbench params
** AUTHORED TEMPLATE — comparator/dc_op: DC operating point + supply current (continuous-time).
** The inverting input sits at VCM, the non-inverting input at VCM + VOD (a decided-high
** overdrive), so the reported v_out is the HIGH output level and i_supply the decided-state
** static draw.
** Port convention: vdd vout vinp vinn vss (self-contained DUT, no bias port).
** Bindings: DUT PORT_LINE VDD VCM VOD PDK_INCLUDE.
.include design.ngspice
.lib sm141064.ngspice noise_corner
.lib sm141064.ngspice nfet_03v3_t
.lib sm141064.ngspice pfet_03v3_t
.lib sm141064.ngspice fets_mm
.lib sm141064.ngspice res_typical
.lib sm141064.ngspice mimcap_typical
.lib sm141064.ngspice cap_mim
.temp 27

.param VDD=1.5
.param VCM=0.75
.param VOD=0.2

Vdd  vdd 0 dc {VDD}
Vss  vss 0 dc 0
Vinn vinn 0 dc {VCM}
Vinp vinp 0 dc {VCM+VOD}

XDUT vdd vout vinp vinn vss cmp_001_hyst_diffpair

.control
  set filetype=ascii
  op
  let i_supply = abs(i(Vdd))
  let v_out = v(vout)
  print i_supply v_out
  write
  quit
.endc
.param x_dut_xmip_w=10u
.param x_dut_xmip_l=0.3u
.param x_dut_xmpld_w=10u
.param x_dut_xmpld_l=0.3u
.param x_dut_xmhn_w=1u
.param x_dut_xmb1p_w=5u
.param x_dut_xmb1n_w=2u
.param x_dut_xmb1p_l=0.28u
.param x_rtail=6000
.param x_dut_rhn_value=3e5
.param x_dut_xmip_m=2
.param x_dut_xmin_m=2
.param x_dut_xmpld_m=4
.param x_dut_xmplm_m=4
.param x_dut_xmhn_m=1
.param x_dut_xmhp_m=1
.param x_dut_xmb1p_m=1
.param x_dut_xmb1n_m=1
.param x_dut_xmb2p_m=2
.param x_dut_xmb2n_m=2
.param x_dut_xmb3p_m=4
.param x_dut_xmb3n_m=4
* ---- GENERATED parameter ties (abstract/params.yaml groups/ratios) ----
* Each tied symbol is defined exactly once, by its line below; rewrite that
* .param to untie just that symbol (untying = shadowing, plan D-3).
.param x_dut_xmin_l = {x_dut_xmip_l}
.param x_dut_xmhn_l = {x_dut_xmip_l}
.param x_dut_xmhp_l = {x_dut_xmip_l}
.param x_dut_xmin_w = {x_dut_xmip_w}
.param x_dut_xmplm_w = {x_dut_xmpld_w}
.param x_dut_xmplm_l = {x_dut_xmpld_l}
.param x_dut_xmhp_w = {x_dut_xmhn_w}
.param x_dut_xmb1n_l = {x_dut_xmb1p_l}
.param x_dut_xmb2p_l = {x_dut_xmb1p_l}
.param x_dut_xmb2n_l = {x_dut_xmb1p_l}
.param x_dut_xmb3p_l = {x_dut_xmb1p_l}
.param x_dut_xmb3n_l = {x_dut_xmb1p_l}
.param x_dut_xmb2p_w = {x_dut_xmb1p_w}
.param x_dut_xmb3p_w = {x_dut_xmb1p_w}
.param x_dut_xmb2n_w = {x_dut_xmb1n_w}
.param x_dut_xmb3n_w = {x_dut_xmb1n_w}
.param x_dut_rhp_value = {x_dut_rhn_value}
.subckt cmp_001_hyst_diffpair vdd vout vinp vinn vss
RHN n1 hn x_dut_rhn_value
RHP n1 hp x_dut_rhp_value
RT tail vss x_rtail
XMB1N b1 n1 vss vss nfet_03v3 l=x_dut_xmb1n_l m=x_dut_xmb1n_m w=x_dut_xmb1n_w
XMB1P b1 n1 vdd vdd pfet_03v3 l=x_dut_xmb1p_l m=x_dut_xmb1p_m w=x_dut_xmb1p_w
XMB2N b2 b1 vss vss nfet_03v3 l=x_dut_xmb2n_l m=x_dut_xmb2n_m w=x_dut_xmb2n_w
XMB2P b2 b1 vdd vdd pfet_03v3 l=x_dut_xmb2p_l m=x_dut_xmb2p_m w=x_dut_xmb2p_w
XMB3N vout b2 vss vss nfet_03v3 l=x_dut_xmb3n_l m=x_dut_xmb3n_m w=x_dut_xmb3n_w
XMB3P vout b2 vdd vdd pfet_03v3 l=x_dut_xmb3p_l m=x_dut_xmb3p_m w=x_dut_xmb3p_w
XMHN hn vout vss vss nfet_03v3 l=x_dut_xmhn_l m=x_dut_xmhn_m w=x_dut_xmhn_w
XMHP hp vout vdd vdd pfet_03v3 l=x_dut_xmhp_l m=x_dut_xmhp_m w=x_dut_xmhp_w
XMIN n2 vinn tail vss nfet_03v3 l=x_dut_xmin_l m=x_dut_xmin_m w=x_dut_xmin_w
XMIP n1 vinp tail vss nfet_03v3 l=x_dut_xmip_l m=x_dut_xmip_m w=x_dut_xmip_w
XMPLD n2 n2 vdd vdd pfet_03v3 l=x_dut_xmpld_l m=x_dut_xmpld_m w=x_dut_xmpld_w
XMPLM n1 n2 vdd vdd pfet_03v3 l=x_dut_xmplm_l m=x_dut_xmplm_m w=x_dut_xmplm_w
.ends
.end
