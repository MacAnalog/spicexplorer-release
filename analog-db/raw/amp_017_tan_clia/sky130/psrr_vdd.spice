** GENERATED by `analog-db export-raw` — DO NOT EDIT.
** circuit=amp_017_tan_clia  class=amplifier  pdk=sky130  testbench=psrr_vdd  corner=tt
** Self-contained deck: testbench + bound params + lowered DUT (.subckt amp_017_tan_clia).
** PDK corner libs resolve by BARE NAME on the image's ngspice sourcepath — run in a
** PDK-enabled env (the base image / api container), NOT a bare host:
**   docker run --rm -i spicexplorer-spice-base:local \
**     bash -lc 'd=$(mktemp -d) && cat > $d/c.spice && cd $d && ngspice -b c.spice' < raw/amp_017_tan_clia/sky130/psrr_vdd.spice
*----------------------------------------------------------*
** params: 28 free + 0 frozen knobs (sizing.yaml) · 36 tied · 15 ratio-derived (abstract/params.yaml) · 3 testbench params
** AUTHORED TEMPLATE — amplifier/psrr_vdd_selfbias (plan D-4/D-5): positive-supply rejection
** for self-biased DUTs (no ibias port — the AnalogGym amplifiers). Identical to psrr_vdd
** except there is no external bias source. The DUT is closed in a unity-gain buffer (vinn
** shorted to vout, vinp held at VCM with NO ac) and the supply Vdd carries a 1 V AC ripple;
** with the signal input quiet, every AC volt at vout is supply feed-through, so
** PSRR+ = −20·log10|vout/vdd| = −vdb(vout). Reported at FSTART (the DC-band floor).
** The unity-buffer DC op point is the same one the ac_open_loop_biaswrap bench already
** proves out for these DUTs (Lfb shorts vout→vinn at DC), so biasing is safe.
** Bindings: DUT PORT_LINE VDD VCM CL FSTART FSTOP PPD PDK_INCLUDE.
.lib sky130.lib.spice tt
.temp 27

.param VDD=1.8
.param VCM=300m
.param CL=10p

Vdd  vdd 0 dc {VDD} ac 1     ; 1 V supply-ripple stimulus
Vss  vss 0 dc 0
CLoad vout 0 {CL}

Vinp vinp 0 dc {VCM}         ; signal input held quiet (no ac) — isolate the supply path
Vfb  vinn vout dc 0          ; unity-gain buffer: vinn shorted to vout

XDUT vss vdd vinn vinp vout amp_017_tan_clia

.control
  set filetype=ascii
  ac dec 101 1k 1G
  let psrr = -vdb(vout)
  meas ac psrr_vdd_db FIND psrr AT=1k
  write
  quit
.endc
.param CAPACITOR_0=5e-12
.param CAPACITOR_1=1e-12
.param CURRENT_0_BIAS=6.3e-07
.param x_dut_xm73_l=1
.param x_dut_xm73_m=2400
.param x_dut_xm73_w=1
.param x_dut_xm61_l=1
.param x_dut_xm14_m=1
.param x_dut_xm61_w=0.42
.param x_dut_xm5_l=1
.param x_dut_xm5_m=117
.param x_dut_xm5_w=1
.param x_dut_xm68_l=0.5
.param x_dut_xm68_m=6
.param x_dut_xm68_w=1
.param x_dut_xm69_l=0.9
.param x_dut_xm69_m=3
.param x_dut_xm69_w=1
.param x_dut_xm70_l=0.48
.param x_dut_xm70_m=2
.param x_dut_xm70_w=1
.param x_dut_xm71_l=1
.param x_dut_xm71_m=1
.param x_dut_xm71_w=0.42
.param x_dut_xm9_l=1
.param x_dut_xm9_m=100
.param x_dut_xm9_w=1
.param RESISTOR_0=1000
* ---- GENERATED parameter ties (abstract/params.yaml groups/ratios) ----
* Each tied symbol is defined exactly once, by its line below; rewrite that
* .param to untie just that symbol (untying = shadowing, plan D-3).
.param x_dut_xm2_w = {x_dut_xm73_w}
.param x_dut_xm4_w = {x_dut_xm73_w}
.param x_dut_xm3_w = {x_dut_xm73_w}
.param x_dut_xm1_w = {x_dut_xm73_w}
.param x_dut_xm0_w = {x_dut_xm73_w}
.param x_dut_xm2_l = {x_dut_xm73_l}
.param x_dut_xm4_l = {x_dut_xm73_l}
.param x_dut_xm3_l = {x_dut_xm73_l}
.param x_dut_xm1_l = {x_dut_xm73_l}
.param x_dut_xm0_l = {x_dut_xm73_l}
.param x_dut_xm6_w = {x_dut_xm5_w}
.param x_dut_xm6_l = {x_dut_xm5_l}
.param x_dut_xm6_m = {x_dut_xm5_m}
.param x_dut_xm8_w = {x_dut_xm9_w}
.param x_dut_xm8_l = {x_dut_xm9_l}
.param x_dut_xm8_m = {x_dut_xm9_m}
.param x_dut_xm72_w = {x_dut_xm71_w}
.param x_dut_xm72_l = {x_dut_xm71_l}
.param x_dut_xm19_w = {x_dut_xm61_w}
.param x_dut_xm15_w = {x_dut_xm61_w}
.param x_dut_xm20_w = {x_dut_xm61_w}
.param x_dut_xm16_w = {x_dut_xm61_w}
.param x_dut_xm18_w = {x_dut_xm61_w}
.param x_dut_xm12_w = {x_dut_xm61_w}
.param x_dut_xm13_w = {x_dut_xm61_w}
.param x_dut_xm17_w = {x_dut_xm61_w}
.param x_dut_xm14_w = {x_dut_xm61_w}
.param x_dut_xm19_l = {x_dut_xm61_l}
.param x_dut_xm15_l = {x_dut_xm61_l}
.param x_dut_xm20_l = {x_dut_xm61_l}
.param x_dut_xm16_l = {x_dut_xm61_l}
.param x_dut_xm18_l = {x_dut_xm61_l}
.param x_dut_xm12_l = {x_dut_xm61_l}
.param x_dut_xm13_l = {x_dut_xm61_l}
.param x_dut_xm17_l = {x_dut_xm61_l}
.param x_dut_xm14_l = {x_dut_xm61_l}
.param x_dut_xm2_m = {x_dut_xm73_m*1/3}
.param x_dut_xm4_m = {x_dut_xm73_m*2/3}
.param x_dut_xm3_m = {x_dut_xm73_m*1/3}
.param x_dut_xm1_m = {x_dut_xm73_m*1/3}
.param x_dut_xm0_m = {x_dut_xm73_m*1/3}
.param x_dut_xm72_m = {x_dut_xm71_m*3}
.param x_dut_xm61_m = {x_dut_xm14_m*6}
.param x_dut_xm19_m = {x_dut_xm14_m*12}
.param x_dut_xm15_m = {x_dut_xm14_m*8}
.param x_dut_xm20_m = {x_dut_xm14_m*12}
.param x_dut_xm16_m = {x_dut_xm14_m*8}
.param x_dut_xm18_m = {x_dut_xm14_m*4}
.param x_dut_xm12_m = {x_dut_xm14_m*4}
.param x_dut_xm13_m = {x_dut_xm14_m*4}
.param x_dut_xm17_m = {x_dut_xm14_m*4}
.subckt amp_017_tan_clia vss vdd vinn vinp vout
C0 net2 vss 'CAPACITOR_0'
C1 net8 VOUT 'CAPACITOR_1'
I0 net1 vss 'CURRENT_0_BIAS'
R0 net5 net2 'RESISTOR_0'
XM0 net1 net1 vdd vdd sky130_fd_pr__pfet_01v8 l=x_dut_xm0_l m=x_dut_xm0_m w=x_dut_xm0_w
XM1 VB4 net1 vdd vdd sky130_fd_pr__pfet_01v8 l=x_dut_xm1_l m=x_dut_xm1_m w=x_dut_xm1_w
XM12 VB4 VB3 net6 vss sky130_fd_pr__nfet_01v8 l=x_dut_xm12_l m=x_dut_xm12_m w=x_dut_xm12_w
XM13 DM_1 VB3 net7 vss sky130_fd_pr__nfet_01v8 l=x_dut_xm13_l m=x_dut_xm13_m w=x_dut_xm13_w
XM14 VB3 VB3 vss vss sky130_fd_pr__nfet_01v8 l=x_dut_xm14_l m=x_dut_xm14_m w=x_dut_xm14_w
XM15 VOUTN VB3 DM_2 vss sky130_fd_pr__nfet_01v8 l=x_dut_xm15_l m=x_dut_xm15_m w=x_dut_xm15_w
XM16 net050 VB3 net8 vss sky130_fd_pr__nfet_01v8 l=x_dut_xm16_l m=x_dut_xm16_m w=x_dut_xm16_w
XM17 net6 VB4 vss vss sky130_fd_pr__nfet_01v8 l=x_dut_xm17_l m=x_dut_xm17_m w=x_dut_xm17_w
XM18 net7 VB4 vss vss sky130_fd_pr__nfet_01v8 l=x_dut_xm18_l m=x_dut_xm18_m w=x_dut_xm18_w
XM19 DM_2 VB4 vss vss sky130_fd_pr__nfet_01v8 l=x_dut_xm19_l m=x_dut_xm19_m w=x_dut_xm19_w
XM2 DM_1 DM_1 vdd vdd sky130_fd_pr__pfet_01v8 l=x_dut_xm2_l m=x_dut_xm2_m w=x_dut_xm2_w
XM20 net8 VB4 vss vss sky130_fd_pr__nfet_01v8 l=x_dut_xm20_l m=x_dut_xm20_m w=x_dut_xm20_w
XM3 VB3 net1 vdd vdd sky130_fd_pr__pfet_01v8 l=x_dut_xm3_l m=x_dut_xm3_m w=x_dut_xm3_w
XM4 net31 net1 vdd vdd sky130_fd_pr__pfet_01v8 l=x_dut_xm4_l m=x_dut_xm4_m w=x_dut_xm4_w
XM5 VOUTN VOUTN vdd vdd sky130_fd_pr__pfet_01v8 l=x_dut_xm5_l m=x_dut_xm5_m w=x_dut_xm5_w
XM6 net050 VOUTN vdd vdd sky130_fd_pr__pfet_01v8 l=x_dut_xm6_l m=x_dut_xm6_m w=x_dut_xm6_w
XM61 net3 VB4 vss vss sky130_fd_pr__nfet_01v8 l=x_dut_xm61_l m=x_dut_xm61_m w=x_dut_xm61_w
XM68 VOUT net050 vdd vdd sky130_fd_pr__pfet_01v8 l=x_dut_xm68_l m=x_dut_xm68_m w=x_dut_xm68_w
XM69 VOUT net5 vss vss sky130_fd_pr__nfet_01v8 l=x_dut_xm69_l m=x_dut_xm69_m w=x_dut_xm69_w
XM70 net3 net050 vdd vdd sky130_fd_pr__pfet_01v8 l=x_dut_xm70_l m=x_dut_xm70_m w=x_dut_xm70_w
XM71 net3 net3 vss vss sky130_fd_pr__nfet_01v8 l=x_dut_xm71_l m=x_dut_xm71_m w=x_dut_xm71_w
XM72 net5 net3 vss vss sky130_fd_pr__nfet_01v8 l=x_dut_xm72_l m=x_dut_xm72_m w=x_dut_xm72_w
XM73 net5 DM_1 vdd vdd sky130_fd_pr__pfet_01v8 l=x_dut_xm73_l m=x_dut_xm73_m w=x_dut_xm73_w
XM8 DM_2 VINN net31 net31 sky130_fd_pr__pfet_01v8 l=x_dut_xm8_l m=x_dut_xm8_m w=x_dut_xm8_w
XM9 net8 VINP net31 net31 sky130_fd_pr__pfet_01v8 l=x_dut_xm9_l m=x_dut_xm9_m w=x_dut_xm9_w
.ends
.end
