** GENERATED by `analog-db generate` — DO NOT EDIT. Source: abstract/netlist.spice → gf180mcu
* ldo_005_buffered_ref (emitted by spicexplorer-circuitgraph)
CC ncz vout 'c_comp'
C_LPF v_lpf_out vss 'c_lpf'
IBIAS_ERR vdd ebias_err dc {i_tail_err}
IBIAS_REF vdd ebias_ref dc {i_tail_ref}
R1 v_ref_out v_ref_fb 'r_ref_top'
R2 v_ref_fb vss 'r_ref_bot'
R3 vout vss 'r_bleed'
RZ egate ncz 'r_z'
R_LPF v_ref_out v_lpf_out 'r_lpf'
VREF vref vss dc {vref_val}
XM1 rd1 vref retail vss nfet_03v3 l=x_dut_xm1_l w=x_dut_xm1_w
XM10 egate noutm vdd vdd pfet_03v3 l=x_dut_xm10_l w=x_dut_xm10_w
XM11 etail ebias_err vss vss nfet_03v3 l=x_dut_xm11_l w=x_dut_xm11_w
XM12 ebias_err ebias_err vss vss nfet_03v3 l=x_dut_xm12_l w=x_dut_xm12_w
XM2 v_ref_out v_ref_fb retail vss nfet_03v3 l=x_dut_xm2_l w=x_dut_xm2_w
XM3 rd1 rd1 vdd vdd pfet_03v3 l=x_dut_xm3_l w=x_dut_xm3_w
XM4 v_ref_out rd1 vdd vdd pfet_03v3 l=x_dut_xm4_l w=x_dut_xm4_w
XM5 retail ebias_ref vss vss nfet_03v3 l=x_dut_xm5_l w=x_dut_xm5_w
XM6 ebias_ref ebias_ref vss vss nfet_03v3 l=x_dut_xm6_l w=x_dut_xm6_w
XM7 noutm vout etail vss nfet_03v3 l=x_dut_xm7_l w=x_dut_xm7_w
XM8 egate v_lpf_out etail vss nfet_03v3 l=x_dut_xm8_l w=x_dut_xm8_w
XM9 noutm noutm vdd vdd pfet_03v3 l=x_dut_xm9_l w=x_dut_xm9_w
XMP vout egate vdd vdd pfet_03v3 l=x_dut_xmp_l m=x_dut_xmp_m w=x_dut_xmp_w
.end
