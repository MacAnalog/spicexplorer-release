** Example of simple 5-transistor OTA AC analysis testbench
*----------------------------------------------------------*
* Testbench
*----------------------------------------------------------*
**.subckt ota-5t_tb-ac
Vdd v_dd GND VDD
xota v_dd v_out v_in v_out net1 v_ena v_ss ota-5t
Vss v_ss GND 0
C1 v_out v_ss CL m=1
Vin v_in v_ss dc VCM ac 1
I0 v_dd net1 IBIAS
Venable v_ena v_ss VDD
.save v(v_in)
.save v(v_out)
.save v(v_ena)
*----------------------------------------------------------*
* Technology Library
*----------------------------------------------------------*
.lib cornerMOSlv.lib mos_tt

.temp 27

*----------------------------------------------------------*
* Control Block
*----------------------------------------------------------*
.control
    echo ==================================
    echo start of Control
    echo ==================================
    set filetype=ascii
    set wr_singlescale
    option numdgt = 3
    option sparse

    * save all

    * echo
    * echo (A) start of OP
    * echo ----------------------------------
    * * --- Initial Operating Point ---
    * op
    * write
    * set appendwrite

    * echo
    * echo (B) start of AC Sim
    * echo ----------------------------------

    * --- AC Analysis ---
    echo (1) Running the AC simulation
    ac dec 101 1k 100MEG
    * plot 20*log10(v_out)

    echo (2) measuring performance metrics
    meas ac dcgain MAX vmag(v_out) FROM=10 TO=10k
    let f3db = dcgain/sqrt(2)
    meas ac fbw WHEN vmag(v_out)=f3db FALL=1
    let gainerror=(dcgain-1)/1
    print dcgain
    print fbw
    print gainerror

    echo
    echo SAVING SIMULATION RESULTS IN THE RAW FILE
    remzerovec
    write

    echo ----------------------------------
    echo END of AC sim
    echo  ----------------------------------
    * noise v(v_out) Vin dec 101 1k 100MEG
    * print onoise_total

    echo ==================================
    echo END of Control
    echo ==================================
    quit
    * ^ This is needed for spicelib (uncommented)
.endc

* (xschem .save include stripped — local unit fixture, see fixtures/README.md)

*----------------------------------------------------------*
* Parameter Definitions
*----------------------------------------------------------*

.param CL=50f
.param VDD=1.5
.param VCM=0.8
.param IBIAS=20u

.param x_dut_nfet_input_w=0.5u
.param x_dut_nfet_input_l=5.0u

.param x_dut_nfet_mirror_w=2.0u
.param x_dut_nfet_mirror_l=5.0u

.param x_dut_pfet_load_w=1.5u
.param x_dut_pfet_load_l=5.0u

.param x_dut_nfet_mirror_ref_w=2.0u
.param x_dut_nfet_mirror_ref_l=5.0u

**** end user architecture code
**.ends

*----------------------------------------------------------*

* Subcircuit Definition
*----------------------------------------------------------*
* expanding   symbol:  ota-5t.sym # of pins=7
** sym_path: ota-5t.sym
** sch_path: ota-5t.sch
.subckt ota-5t vdd vout vinp vinn ibias_20u d_ena vss
*.ipin ibias_20u
*.iopin vdd
*.iopin vss
*.ipin vinp
*.ipin vinn
*.opin vout
*.ipin d_ena
XM5 tail gate_n vss vss sg13_lv_nmos w=x_dut_nfet_mirror_w l=x_dut_nfet_mirror_l ng=1 m=1
XM4 vout gate_p vdd vdd sg13_lv_pmos w=x_dut_pfet_load_w l=x_dut_pfet_load_l ng=1 m=1
XM1 gate_p vinp tail vss sg13_lv_nmos w=x_dut_nfet_input_w l=x_dut_nfet_input_l ng=1 m=1
XM2 vout vinn tail vss sg13_lv_nmos w=x_dut_nfet_input_w l=x_dut_nfet_input_l ng=1 m=1
XM3 gate_p gate_p vdd vdd sg13_lv_pmos w=x_dut_pfet_load_w l=x_dut_pfet_load_l ng=1 m=1
XM6 ibias_20u gate_n vss vss sg13_lv_nmos w=x_dut_nfet_mirror_ref_l l=x_dut_nfet_mirror_ref_w ng=1 m=1
XM9 gate_n ena_n vss vss sg13_lv_nmos w=0.5u l=0.13u ng=1 m=1
XM11 gate_p ena vdd vdd sg13_lv_pmos w=1.5u l=0.13u ng=1 m=1
XM7 ena ena_n vss vss sg13_lv_nmos w=0.5u l=0.13u ng=1 m=1
XM8 ena ena_n vdd vdd sg13_lv_pmos w=1.5u l=0.13u ng=1 m=1
XM10 ibias_20u ena gate_n vss sg13_lv_nmos w=0.5u l=0.13u ng=1 m=1
XM12 ena_n d_ena vss vss sg13_lv_nmos w=0.5u l=0.13u ng=1 m=1
XM13 ena_n d_ena vdd vdd sg13_lv_pmos w=1.5u l=0.13u ng=1 m=1
.ends

.GLOBAL GND
.end
