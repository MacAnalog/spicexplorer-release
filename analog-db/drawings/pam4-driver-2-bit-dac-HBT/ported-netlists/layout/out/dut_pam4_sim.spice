* pre-layout sim netlist for pam4drv_pam4_lay — same devices as the LVS reference, on the PDK models
* (rsil / cap_cmim / npn13G2 subckts; tails + sub are ports)
.subckt pam4drv_pam4_lay lsbp lsbn msbp msbn outp outn vcc vcasc vcmb tmsb0 tlsb0 tmsb1 sub
XQ1M0 c1M0 msbp e1M0 sub npn13G2 Nx=3
XQ2M0 c2M0 msbn e2M0 sub npn13G2 Nx=3
XQ3M0 outp vcasc c1M0 sub npn13G2 Nx=3
XQ4M0 outn vcasc c2M0 sub npn13G2 Nx=3
XQ1L0 c1L0 lsbp e1L0 sub npn13G2 Nx=3
XQ2L0 c2L0 lsbn e2L0 sub npn13G2 Nx=3
XQ3L0 outp vcasc c1L0 sub npn13G2 Nx=3
XQ4L0 outn vcasc c2L0 sub npn13G2 Nx=3
XQ1M1 c1M1 msbp e1M1 sub npn13G2 Nx=3
XQ2M1 c2M1 msbn e2M1 sub npn13G2 Nx=3
XQ3M1 outp vcasc c1M1 sub npn13G2 Nx=3
XQ4M1 outn vcasc c2M1 sub npn13G2 Nx=3
XRRE1M0 e1M0 tmsb0 sub rsil w=4.5u l=0.77u m=1
XRRE2M0 e2M0 tmsb0 sub rsil w=4.5u l=0.77u m=1
XRRE1L0 e1L0 tlsb0 sub rsil w=4.5u l=0.77u m=1
XRRE2L0 e2L0 tlsb0 sub rsil w=4.5u l=0.77u m=1
XRRE1M1 e1M1 tmsb1 sub rsil w=4.5u l=0.77u m=1
XRRE2M1 e2M1 tmsb1 sub rsil w=4.5u l=0.77u m=1
XRRblsbp lsbp vcmb sub rsil w=0.5u l=2.14u m=1
XRRblsbn lsbn vcmb sub rsil w=0.5u l=2.14u m=1
XRRbmsbp msbp vcmb sub rsil w=0.5u l=2.14u m=1
XRRbmsbn msbn vcmb sub rsil w=0.5u l=2.14u m=1
XRRcp outp vcc sub rsil w=1.4u l=8.71u m=1
XRRcn outn vcc sub rsil w=1.4u l=8.71u m=1
XCdegM0 e2M0 e1M0 cap_cmim w=3.21u l=3.21u
XCdegL0 e2L0 e1L0 cap_cmim w=3.21u l=3.21u
XCdegM1 e2M1 e1M1 cap_cmim w=3.21u l=3.21u
.ends
