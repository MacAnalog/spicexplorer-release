** GENERATED by `analog-db export-raw` — DO NOT EDIT.
** circuit=amp_021_yan_az  class=amplifier  pdk=sky130  testbench=psrr_vdd  corner=tt
** Self-contained deck: testbench + bound params + lowered DUT (.subckt amp_021_yan_az).
** PDK corner libs resolve by BARE NAME on the image's ngspice sourcepath — run in a
** PDK-enabled env (the base image / api container), NOT a bare host:
**   docker run --rm -i spicexplorer-spice-base:local \
**     bash -lc 'd=$(mktemp -d) && cat > $d/c.spice && cd $d && ngspice -b c.spice' < raw/amp_021_yan_az/sky130/psrr_vdd.spice
*----------------------------------------------------------*
** params: 36 free + 0 frozen knobs (sizing.yaml) · 27 tied · 6 ratio-derived (abstract/params.yaml) · 3 testbench params
** AUTHORED TEMPLATE — amplifier/psrr_vdd_selfbias (plan D-4/D-5): positive-supply rejection
** for self-biased DUTs (no ibias port — the AnalogGym amplifiers). Identical to psrr_vdd
** except there is no external bias source. The DUT is closed in a unity-gain buffer (vinn
** shorted to vout, vinp held at VCM with NO ac) and the supply Vdd carries a 1 V AC ripple;
** with the signal input quiet, every AC volt at vout is supply feed-through, so
** PSRR+ = −20·log10|vout/vdd| = −vdb(vout). Reported at FSTART (the DC-band floor).
** The unity-buffer DC op point is the same one the ac_open_loop_biaswrap bench already
** proves out for these DUTs (Lfb shorts vout→vinn at DC), so biasing is safe.
** Bindings: DUT PORT_LINE VDD VCM CL FSTART FSTOP PPD PDK_INCLUDE.
.lib sky130.lib.spice tt
.temp 27

.param VDD=1.8
.param VCM=300m
.param CL=10p

Vdd  vdd 0 dc {VDD} ac 1     ; 1 V supply-ripple stimulus
Vss  vss 0 dc 0
CLoad vout 0 {CL}

Vinp vinp 0 dc {VCM}         ; signal input held quiet (no ac) — isolate the supply path
Vfb  vinn vout dc 0          ; unity-gain buffer: vinn shorted to vout

XDUT vss vdd vinn vinp vout amp_021_yan_az

.control
  set filetype=ascii
  ac dec 101 1k 1G
  let psrr = -vdb(vout)
  meas ac psrr_vdd_db FIND psrr AT=1k
  write
  quit
.endc
.param CAPACITOR_0=3.45888e-12
.param CAPACITOR_1=3.05077e-12
.param CURRENT_1_BIAS=1.34338e-05
.param x_dut_xm67_l=1.28048
.param x_dut_xm67_m=4
.param x_dut_xm67_w=0.812585
.param x_dut_xm11_l=0.419916
.param x_dut_xm11_m=4
.param x_dut_xm11_w=1.30344
.param x_dut_xm13_l=2.71927
.param x_dut_xm13_m=4
.param x_dut_xm13_w=1.84336
.param x_dut_xm14_l=1.90073
.param x_dut_xm14_m=4
.param x_dut_xm14_w=2.72096
.param x_dut_xm16_l=0.389321
.param x_dut_xm16_m=4
.param x_dut_xm16_w=2.25303
.param x_dut_xm18_l=1.66626
.param x_dut_xm18_m=4
.param x_dut_xm18_w=1.04925
.param x_dut_xm19_l=0.828047
.param x_dut_xm19_m=4
.param x_dut_xm19_w=0.746562
.param x_dut_xm22_l=0.778286
.param x_dut_xm22_m=4
.param x_dut_xm22_w=2.3741
.param x_dut_xm23_l=0.47607
.param x_dut_xm23_m=4
.param x_dut_xm23_w=1.20732
.param x_dut_xm10_l=0.524625
.param x_dut_xm10_m=4
.param x_dut_xm10_w=0.826477
.param RESISTOR_0=269735
.param RESISTOR_1=31632.8
.param RESISTOR_2=223442
* ---- GENERATED parameter ties (abstract/params.yaml groups/ratios) ----
* Each tied symbol is defined exactly once, by its line below; rewrite that
* .param to untie just that symbol (untying = shadowing, plan D-3).
.param x_dut_xm3_w = {x_dut_xm67_w}
.param x_dut_xm5_w = {x_dut_xm67_w}
.param x_dut_xm4_w = {x_dut_xm67_w}
.param x_dut_xm2_w = {x_dut_xm67_w}
.param x_dut_xm1_w = {x_dut_xm67_w}
.param x_dut_xm0_w = {x_dut_xm67_w}
.param x_dut_xm3_l = {x_dut_xm67_l}
.param x_dut_xm5_l = {x_dut_xm67_l}
.param x_dut_xm4_l = {x_dut_xm67_l}
.param x_dut_xm2_l = {x_dut_xm67_l}
.param x_dut_xm1_l = {x_dut_xm67_l}
.param x_dut_xm0_l = {x_dut_xm67_l}
.param x_dut_xm9_w = {x_dut_xm10_w}
.param x_dut_xm9_l = {x_dut_xm10_l}
.param x_dut_xm9_m = {x_dut_xm10_m}
.param x_dut_xm17_w = {x_dut_xm16_w}
.param x_dut_xm17_l = {x_dut_xm16_l}
.param x_dut_xm17_m = {x_dut_xm16_m}
.param x_dut_xm20_w = {x_dut_xm19_w}
.param x_dut_xm21_w = {x_dut_xm19_w}
.param x_dut_xm20_l = {x_dut_xm19_l}
.param x_dut_xm21_l = {x_dut_xm19_l}
.param x_dut_xm20_m = {x_dut_xm19_m}
.param x_dut_xm21_m = {x_dut_xm19_m}
.param x_dut_xm15_w = {x_dut_xm14_w}
.param x_dut_xm15_l = {x_dut_xm14_l}
.param x_dut_xm15_m = {x_dut_xm14_m}
.param x_dut_xm3_m = {x_dut_xm67_m*4}
.param x_dut_xm5_m = {x_dut_xm67_m*1}
.param x_dut_xm4_m = {x_dut_xm67_m*1}
.param x_dut_xm2_m = {x_dut_xm67_m*2}
.param x_dut_xm1_m = {x_dut_xm67_m*1}
.param x_dut_xm0_m = {x_dut_xm67_m*1}
.subckt amp_021_yan_az vss vdd vinn vinp vout
C0 net063 VOUT 'CAPACITOR_1'
C1 net051 vss 'CAPACITOR_0'
I0 VB1 vss 'CURRENT_1_BIAS'
R0 net078 net077 'RESISTOR_1'
R1 net078 net082 'RESISTOR_2'
R2 net094 net051 'RESISTOR_0'
XM0 VB1 VB1 vdd vdd sky130_fd_pr__pfet_01v8 l=x_dut_xm0_l m=x_dut_xm0_m w=x_dut_xm0_w
XM1 VB4 VB1 vdd vdd sky130_fd_pr__pfet_01v8 l=x_dut_xm1_l m=x_dut_xm1_m w=x_dut_xm1_w
XM10 net063 VINP net019 net019 sky130_fd_pr__pfet_01v8 l=x_dut_xm10_l m=x_dut_xm10_m w=x_dut_xm10_w
XM11 net094 net050 vdd vdd sky130_fd_pr__pfet_01v8 l=x_dut_xm11_l m=x_dut_xm11_m w=x_dut_xm11_w
XM13 VOUT net050 vdd vdd sky130_fd_pr__pfet_01v8 l=x_dut_xm13_l m=x_dut_xm13_m w=x_dut_xm13_w
XM14 VOUTN net077 DM_2 vss sky130_fd_pr__nfet_01v8 l=x_dut_xm14_l m=x_dut_xm14_m w=x_dut_xm14_w
XM15 net050 net082 net063 vss sky130_fd_pr__nfet_01v8 l=x_dut_xm15_l m=x_dut_xm15_m w=x_dut_xm15_w
XM16 net077 DM_2 vss vss sky130_fd_pr__nfet_01v8 l=x_dut_xm16_l m=x_dut_xm16_m w=x_dut_xm16_w
XM17 net082 net063 vss vss sky130_fd_pr__nfet_01v8 l=x_dut_xm17_l m=x_dut_xm17_m w=x_dut_xm17_w
XM18 VOUT net057 vss vss sky130_fd_pr__nfet_01v8 l=x_dut_xm18_l m=x_dut_xm18_m w=x_dut_xm18_w
XM19 VB4 VB4 vss vss sky130_fd_pr__nfet_01v8 l=x_dut_xm19_l m=x_dut_xm19_m w=x_dut_xm19_w
XM2 net019 VB1 vdd vdd sky130_fd_pr__pfet_01v8 l=x_dut_xm2_l m=x_dut_xm2_m w=x_dut_xm2_w
XM20 DM_2 VB4 vss vss sky130_fd_pr__nfet_01v8 l=x_dut_xm20_l m=x_dut_xm20_m w=x_dut_xm20_w
XM21 net063 VB4 vss vss sky130_fd_pr__nfet_01v8 l=x_dut_xm21_l m=x_dut_xm21_m w=x_dut_xm21_w
XM22 net094 net051 vss vss sky130_fd_pr__nfet_01v8 l=x_dut_xm22_l m=x_dut_xm22_m w=x_dut_xm22_w
XM23 net057 net094 vss vss sky130_fd_pr__nfet_01v8 l=x_dut_xm23_l m=x_dut_xm23_m w=x_dut_xm23_w
XM3 net078 VB1 vdd vdd sky130_fd_pr__pfet_01v8 l=x_dut_xm3_l m=x_dut_xm3_m w=x_dut_xm3_w
XM4 VOUTN VOUTN vdd vdd sky130_fd_pr__pfet_01v8 l=x_dut_xm4_l m=x_dut_xm4_m w=x_dut_xm4_w
XM5 net050 VOUTN vdd vdd sky130_fd_pr__pfet_01v8 l=x_dut_xm5_l m=x_dut_xm5_m w=x_dut_xm5_w
XM67 net057 VOUTN vdd vdd sky130_fd_pr__pfet_01v8 l=x_dut_xm67_l m=x_dut_xm67_m w=x_dut_xm67_w
XM9 DM_2 VINN net019 net019 sky130_fd_pr__pfet_01v8 l=x_dut_xm9_l m=x_dut_xm9_m w=x_dut_xm9_w
.ends
.end
