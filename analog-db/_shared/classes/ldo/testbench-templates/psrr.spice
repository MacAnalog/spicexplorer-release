** AUTHORED TEMPLATE — ldo/psrr: AC supply rejection (Vdd -> Vout), closed loop.
** Inject AC=1 on the supply; psrr_vdd_db = -vdb(vout) (output rejection in dB). The feedback loop
** stays naturally closed (vout feeds the internal divider), so no loop-break trick is needed.
** Bindings: DUT PORT_LINE VDD ILOAD COUT PPD FSTART FSTOP FMEAS PDK_INCLUDE.
${PDK_INCLUDE}

.param VDD=${VDD}

Vdd  vdd 0 dc {VDD} ac 1
Vss  vss 0 dc 0
Iload vout 0 dc ${ILOAD}
CLoad vout 0 ${COUT}

${PORT_LINE} ${DUT}

.control
  set filetype=ascii
  ac dec ${PPD} ${FSTART} ${FSTOP}
  meas ac vout_db FIND vdb(vout) AT=${FMEAS}
  let psrr_vdd_db = 0 - vout_db
  print psrr_vdd_db
  write
  quit
.endc
.end
