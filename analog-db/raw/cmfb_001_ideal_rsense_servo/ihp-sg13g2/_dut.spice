** GENERATED by `analog-db export-raw` — DO NOT EDIT.
** Standalone lowered DUT subckt for cmfb_001_ideal_rsense_servo on ihp-sg13g2 (sizing .param defaults + .subckt).
** Not a runnable deck on its own — include it under your own testbench:
**   .include _dut.spice
**   XDUT vinp vinn vcmfb vref vdd vss cmfb_001_ideal_rsense_servo
** Source: pdk/ihp-sg13g2/netlist.spice (run `analog-db generate` to refresh).
*----------------------------------------------------------*
** params: 6 free + 0 frozen knobs (sizing.yaml) · 1 tied · 0 ratio-derived (abstract/params.yaml)
.param gm_val=100u
.param rout_val=10Meg
.param cout_val=100f
.param rin_val=1e12
.param cin_val=10f
.param x_dut_rmp_value=1Meg
* ---- GENERATED parameter ties (abstract/params.yaml groups/ratios) ----
* Each tied symbol is defined exactly once, by its line below; rewrite that
* .param to untie just that symbol (untying = shadowing, plan D-3).
.param x_dut_rmn_value = {x_dut_rmp_value}
.subckt cmfb_001_ideal_rsense_servo vinp vinn vcmfb vref vdd vss
CIN_SERVO cm_sense vref 'cin_val'
COUT_SERVO vss vcmfb 'cout_val'
GM_SERVO vss vcmfb vref cm_sense {gm_val}
RIN_SERVO cm_sense vref 'rin_val'
RMN vinn cm_sense 'x_dut_rmn_value'
RMP cm_sense vinp 'x_dut_rmp_value'
ROUT_SERVO vss vcmfb 'rout_val'
.ends
