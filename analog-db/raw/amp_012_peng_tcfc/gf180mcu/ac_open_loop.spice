** GENERATED by `analog-db export-raw` — DO NOT EDIT.
** circuit=amp_012_peng_tcfc  class=amplifier  pdk=gf180mcu  testbench=ac_open_loop  corner=tt
** Self-contained deck: testbench + bound params + lowered DUT (.subckt amp_012_peng_tcfc).
** PDK corner libs resolve by BARE NAME on the image's ngspice sourcepath — run in a
** PDK-enabled env (the base image / api container), NOT a bare host:
**   docker run --rm -i spicexplorer-spice-base:local \
**     bash -lc 'd=$(mktemp -d) && cat > $d/c.spice && cd $d && ngspice -b c.spice' < raw/amp_012_peng_tcfc/gf180mcu/ac_open_loop.spice
*----------------------------------------------------------*
** params: 24 free + 0 frozen knobs (sizing.yaml) · 52 tied · 23 ratio-derived (abstract/params.yaml) · 3 testbench params
** AUTHORED TEMPLATE — amplifier/ac_open_loop_biaswrap (plan D-4; the AnalogGym bias-wrap).
** Open-loop gain measured in closed-loop bias (analoggym-amplifiers skill §5): a 1 TH inductor
** DC-shorts the output back to the inverting input — setting the high-gain operating point —
** while a 1 TF cap AC-opens that feedback and injects the AC input. This is the only way a
** high-gain 3-stage amp biases stably while still exposing its open-loop AC response.
**
** Assumes the AnalogGym canonical DUT port order (self-biased; NO ibias port):
**   .subckt <id> vss vdd vinn vinp vout
** Bindings: DUT VDD VCM CL FSTART FSTOP PPD PDK_INCLUDE.
** FIXED 2026-07-20: this template used to hardcode `X1 0 vdd opout_dc opin opout amp_012_peng_tcfc`,
** which silently assumed the AnalogGym port order [vss vdd vinn vinp vout] and MIS-WIRED any
** DUT declaring a different order (e.g. the amplifier-class [vdd vout vinp vinn vss] swaps
** vdd<->vss). It now uses XDUT vss vdd vinn vinp vout with canonical node names, exactly like the
** *_biaswrap_ibias sibling. For the AnalogGym DUTs this is a no-op: their vss port binds to
** node `vss`, which `Vss vss 0 dc 0` ties to ground just as the old direct-to-0 wiring did.
.include design.ngspice
.lib sm141064.ngspice noise_corner
.lib sm141064.ngspice nfet_03v3_t
.lib sm141064.ngspice pfet_03v3_t
.lib sm141064.ngspice fets_mm
.temp 27

.param VDD=1.8
.param VCM=240m
.param CL=10p

Vdd  vdd 0 dc {VDD}
Vss  vss 0 dc 0
Vcm  vinp 0 dc {VCM}          ; common-mode bias on the non-inverting input
Vac  sigin 0 dc 0 ac 1        ; AC stimulus
Lfb  vout vinn 1T        ; 1 TH: DC short (bias), AC open
Cin  vinn sigin 1T        ; 1 TF: DC open, AC inject into the inverting node
CLoad vout 0 {CL}

XDUT vss vdd vinn vinp vout amp_012_peng_tcfc
.control
  set filetype=ascii
  ac dec 50 1e-4 1G
  meas ac dcgain FIND vdb(vout) AT=1e-4
  meas ac ugf    WHEN vdb(vout)=0 FALL=1
  let phc = cph(vout)*180/3.14159265
  let ph  = 180 + phc - phc[0]
  meas ac pm     FIND ph WHEN vdb(vout)=0 FALL=1
  * STABILITY GUARDS (2026-08-18, tcas-2026 E-041). `pm` above is a Bode margin and a Bode margin
  * assumes the open loop has no right-half-plane poles. Multistage amps with internal
  * compensation loops (Peng IAC / TCFC and kin) can lose that at a random sizing: the small-
  * signal response then shows phase LEAD instead of lag, `pm` reads 140-585 deg, and the sizing
  * oscillates rail-to-rail in the closed-loop step bench (301/301 such "feasible" sizings did).
  * Finer PPD does not change it (checked at 50/200/1000): the unwrap is right, the premise is
  * wrong. Two additive readings so a reader (or an optimizer spec) can see it without a tran:
  *   pm_min  worst phase distance to -180 deg anywhere |A| > 0 dB (equals pm when the phase is
  *           monotone; <= 0 when the phase touches -180 while the gain is still above unity)
  *   gm      gain margin at the first -180 deg crossing, -999 when the phase never gets there
  * `pm` itself is unchanged. Neither guard replaces the closed-loop step: a sizing with RHP
  * poles can pass both (pm 178, pm_min 22, gm +72 measured on one) and still oscillate. The
  * settling bench (tran_step) is the stability verdict; keep it scored.
  * (masks use `<=` and `1 - mask` only -- see the `>` parser gotcha in stb.spice.)
  let gdb    = vdb(vout)
  let mb     = (gdb <= 0)
  let ma     = 1 - mb
  let pm_min = minimum(ph*ma + 999*mb)
  * |A| never above 0 dB -> no band to take a minimum over -> the NEGATIVE sentinel, so a
  * min-bound spec fails instead of sailing past (stb.spice, 'THE SEED MUST NOT BE A MEASUREMENT')
  let mok    = (pm_min <= 998)
  let pm_min = pm_min*mok + (-999)*(1 - mok)
  let ngdb   = 0 - gdb
  let gm     = -999
  meas ac gm FIND ngdb WHEN ph=0 CROSS=1
  print pm_min gm
  write
  quit
.endc
.param CAPACITOR_0=16p
.param CAPACITOR_1=18p
.param CURRENT_0_BIAS=4.70305e-06
.param x_dut_xm66_l=6.81188e-07
.param x_dut_xm65_m=4
.param x_dut_xm66_w=3.80001e-05
.param x_dut_xm10_l=2.24312e-06
.param x_dut_xm10_m=4
.param x_dut_xm10_w=8.98146e-05
.param x_dut_xm11_l=3.06845e-06
.param x_dut_xm11_m=4
.param x_dut_xm11_w=5.00628e-05
.param x_dut_xm19_l=3.37983e-06
.param x_dut_xm14_m=4
.param x_dut_xm19_w=6.31788e-06
.param x_dut_xm23_l=5.20019e-06
.param x_dut_xm23_m=4
.param x_dut_xm23_w=5.0503e-05
.param x_dut_xm70_l=2.46112e-06
.param x_dut_xm70_m=4
.param x_dut_xm70_w=8.35413e-05
.param x_dut_xm9_l=1.45168e-06
.param x_dut_xm9_m=4
.param x_dut_xm9_w=4.54661e-05
* ---- GENERATED parameter ties (abstract/params.yaml groups/ratios) ----
* Each tied symbol is defined exactly once, by its line below; rewrite that
* .param to untie just that symbol (untying = shadowing, plan D-3).
.param x_dut_xm7_w = {x_dut_xm66_w}
.param x_dut_xm57_w = {x_dut_xm66_w}
.param x_dut_xm65_w = {x_dut_xm66_w}
.param x_dut_xm6_w = {x_dut_xm66_w}
.param x_dut_xm5_w = {x_dut_xm66_w}
.param x_dut_xm4_w = {x_dut_xm66_w}
.param x_dut_xm62_w = {x_dut_xm66_w}
.param x_dut_xm3_w = {x_dut_xm66_w}
.param x_dut_xm61_w = {x_dut_xm66_w}
.param x_dut_xm2_w = {x_dut_xm66_w}
.param x_dut_xm58_w = {x_dut_xm66_w}
.param x_dut_xm1_w = {x_dut_xm66_w}
.param x_dut_xm0_w = {x_dut_xm66_w}
.param x_dut_xm7_l = {x_dut_xm66_l}
.param x_dut_xm57_l = {x_dut_xm66_l}
.param x_dut_xm65_l = {x_dut_xm66_l}
.param x_dut_xm6_l = {x_dut_xm66_l}
.param x_dut_xm5_l = {x_dut_xm66_l}
.param x_dut_xm4_l = {x_dut_xm66_l}
.param x_dut_xm62_l = {x_dut_xm66_l}
.param x_dut_xm3_l = {x_dut_xm66_l}
.param x_dut_xm61_l = {x_dut_xm66_l}
.param x_dut_xm2_l = {x_dut_xm66_l}
.param x_dut_xm58_l = {x_dut_xm66_l}
.param x_dut_xm1_l = {x_dut_xm66_l}
.param x_dut_xm0_l = {x_dut_xm66_l}
.param x_dut_xm8_w = {x_dut_xm9_w}
.param x_dut_xm8_l = {x_dut_xm9_l}
.param x_dut_xm8_m = {x_dut_xm9_m}
.param x_dut_xm69_w = {x_dut_xm70_w}
.param x_dut_xm69_l = {x_dut_xm70_l}
.param x_dut_xm69_m = {x_dut_xm70_m}
.param x_dut_xm15_w = {x_dut_xm19_w}
.param x_dut_xm20_w = {x_dut_xm19_w}
.param x_dut_xm16_w = {x_dut_xm19_w}
.param x_dut_xm17_w = {x_dut_xm19_w}
.param x_dut_xm14_w = {x_dut_xm19_w}
.param x_dut_xm12_w = {x_dut_xm19_w}
.param x_dut_xm18_w = {x_dut_xm19_w}
.param x_dut_xm13_w = {x_dut_xm19_w}
.param x_dut_xm64_w = {x_dut_xm19_w}
.param x_dut_xm63_w = {x_dut_xm19_w}
.param x_dut_xm15_l = {x_dut_xm19_l}
.param x_dut_xm20_l = {x_dut_xm19_l}
.param x_dut_xm16_l = {x_dut_xm19_l}
.param x_dut_xm17_l = {x_dut_xm19_l}
.param x_dut_xm14_l = {x_dut_xm19_l}
.param x_dut_xm12_l = {x_dut_xm19_l}
.param x_dut_xm18_l = {x_dut_xm19_l}
.param x_dut_xm13_l = {x_dut_xm19_l}
.param x_dut_xm64_l = {x_dut_xm19_l}
.param x_dut_xm63_l = {x_dut_xm19_l}
.param x_dut_xm66_m = {x_dut_xm65_m*48}
.param x_dut_xm7_m = {x_dut_xm65_m*48}
.param x_dut_xm57_m = {x_dut_xm65_m*4}
.param x_dut_xm6_m = {x_dut_xm65_m*4}
.param x_dut_xm5_m = {x_dut_xm65_m*4}
.param x_dut_xm4_m = {x_dut_xm65_m*8}
.param x_dut_xm62_m = {x_dut_xm65_m*4}
.param x_dut_xm3_m = {x_dut_xm65_m*4}
.param x_dut_xm61_m = {x_dut_xm65_m*4}
.param x_dut_xm2_m = {x_dut_xm65_m*4}
.param x_dut_xm58_m = {x_dut_xm65_m*4}
.param x_dut_xm1_m = {x_dut_xm65_m*4}
.param x_dut_xm0_m = {x_dut_xm65_m*4}
.param x_dut_xm19_m = {x_dut_xm14_m*8}
.param x_dut_xm15_m = {x_dut_xm14_m*8}
.param x_dut_xm20_m = {x_dut_xm14_m*8}
.param x_dut_xm16_m = {x_dut_xm14_m*8}
.param x_dut_xm17_m = {x_dut_xm14_m*4}
.param x_dut_xm12_m = {x_dut_xm14_m*4}
.param x_dut_xm18_m = {x_dut_xm14_m*4}
.param x_dut_xm13_m = {x_dut_xm14_m*4}
.param x_dut_xm64_m = {x_dut_xm14_m*4}
.param x_dut_xm63_m = {x_dut_xm14_m*4}
.subckt amp_012_peng_tcfc vss vdd vinn vinp vout
C0 VOUTP VOUT 'CAPACITOR_0'
C1 net049 VOUT 'CAPACITOR_1'
I0 VB1 vss 'CURRENT_0_BIAS'
XM0 net2 VB1 vdd vdd pfet_03v3 l=x_dut_xm0_l m=x_dut_xm0_m w=x_dut_xm0_w
XM1 net3 VB1 vdd vdd pfet_03v3 l=x_dut_xm1_l m=x_dut_xm1_m w=x_dut_xm1_w
XM10 net043 VOUTP vdd vdd pfet_03v3 l=x_dut_xm10_l m=x_dut_xm10_m w=x_dut_xm10_w
XM11 VOUT VOUTP vdd vdd pfet_03v3 l=x_dut_xm11_l m=x_dut_xm11_m w=x_dut_xm11_w
XM12 VB4 VB3 net54 vss nfet_03v3 l=x_dut_xm12_l m=x_dut_xm12_m w=x_dut_xm12_w
XM13 net7 VB3 net56 vss nfet_03v3 l=x_dut_xm13_l m=x_dut_xm13_m w=x_dut_xm13_w
XM14 VB3 VB3 vss vss nfet_03v3 l=x_dut_xm14_l m=x_dut_xm14_m w=x_dut_xm14_w
XM15 VOUTN VB3 DM_2 vss nfet_03v3 l=x_dut_xm15_l m=x_dut_xm15_m w=x_dut_xm15_w
XM16 VOUTP VB3 net063 vss nfet_03v3 l=x_dut_xm16_l m=x_dut_xm16_m w=x_dut_xm16_w
XM17 net54 VB4 vss vss nfet_03v3 l=x_dut_xm17_l m=x_dut_xm17_m w=x_dut_xm17_w
XM18 net56 VB4 vss vss nfet_03v3 l=x_dut_xm18_l m=x_dut_xm18_m w=x_dut_xm18_w
XM19 DM_2 VB4 vss vss nfet_03v3 l=x_dut_xm19_l m=x_dut_xm19_m w=x_dut_xm19_w
XM2 net6 VB1 vdd vdd pfet_03v3 l=x_dut_xm2_l m=x_dut_xm2_m w=x_dut_xm2_w
XM20 net063 VB4 vss vss nfet_03v3 l=x_dut_xm20_l m=x_dut_xm20_m w=x_dut_xm20_w
XM23 VOUT net10 vss vss nfet_03v3 l=x_dut_xm23_l m=x_dut_xm23_m w=x_dut_xm23_w
XM3 net8 VB1 vdd vdd pfet_03v3 l=x_dut_xm3_l m=x_dut_xm3_m w=x_dut_xm3_w
XM4 net31 VB1 vdd vdd pfet_03v3 l=x_dut_xm4_l m=x_dut_xm4_m w=x_dut_xm4_w
XM5 VOUTN VOUTN vdd vdd pfet_03v3 l=x_dut_xm5_l m=x_dut_xm5_m w=x_dut_xm5_w
XM57 VB1 VB2 net2 vdd pfet_03v3 l=x_dut_xm57_l m=x_dut_xm57_m w=x_dut_xm57_w
XM58 VB4 VB2 net3 vdd pfet_03v3 l=x_dut_xm58_l m=x_dut_xm58_m w=x_dut_xm58_w
XM6 VOUTP VOUTN vdd vdd pfet_03v3 l=x_dut_xm6_l m=x_dut_xm6_m w=x_dut_xm6_w
XM61 net7 VB2 net6 vdd pfet_03v3 l=x_dut_xm61_l m=x_dut_xm61_m w=x_dut_xm61_w
XM62 VB3 VB2 net8 vdd pfet_03v3 l=x_dut_xm62_l m=x_dut_xm62_m w=x_dut_xm62_w
XM63 VB2 VB3 net9 vss nfet_03v3 l=x_dut_xm63_l m=x_dut_xm63_m w=x_dut_xm63_w
XM64 net9 VB4 vss vss nfet_03v3 l=x_dut_xm64_l m=x_dut_xm64_m w=x_dut_xm64_w
XM65 VB2 VB2 vdd vdd pfet_03v3 l=x_dut_xm65_l m=x_dut_xm65_m w=x_dut_xm65_w
XM66 net10 VB2 net049 vdd pfet_03v3 l=x_dut_xm66_l m=x_dut_xm66_m w=x_dut_xm66_w
XM69 net10 net043 vss vss nfet_03v3 l=x_dut_xm69_l m=x_dut_xm69_m w=x_dut_xm69_w
XM7 net049 VB1 vdd vdd pfet_03v3 l=x_dut_xm7_l m=x_dut_xm7_m w=x_dut_xm7_w
XM70 net043 net043 vss vss nfet_03v3 l=x_dut_xm70_l m=x_dut_xm70_m w=x_dut_xm70_w
XM8 DM_2 VINN net31 net31 pfet_03v3 l=x_dut_xm8_l m=x_dut_xm8_m w=x_dut_xm8_w
XM9 net063 VINP net31 net31 pfet_03v3 l=x_dut_xm9_l m=x_dut_xm9_m w=x_dut_xm9_w
.ends
.end
