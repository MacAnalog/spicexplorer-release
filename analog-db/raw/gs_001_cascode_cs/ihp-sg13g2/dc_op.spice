** GENERATED by `analog-db export-raw` — DO NOT EDIT.
** circuit=gs_001_cascode_cs  class=gain_stage  pdk=ihp-sg13g2  testbench=dc_op  corner=tt
** Self-contained deck: testbench + bound params + lowered DUT (.subckt gs_001_cascode_cs).
** PDK corner libs resolve by BARE NAME on the image's ngspice sourcepath — run in a
** PDK-enabled env (the base image / api container), NOT a bare host:
**   docker run --rm -i spicexplorer-spice-base:local \
**     bash -lc 'd=$(mktemp -d) && cat > $d/c.spice && cd $d && ngspice -b c.spice' < raw/gs_001_cascode_cs/ihp-sg13g2/dc_op.spice
*----------------------------------------------------------*
** params: 10 free + 9 frozen knobs (sizing.yaml) · 8 tied · 0 ratio-derived (abstract/params.yaml) · 2 testbench params
** AUTHORED TEMPLATE — gain_stage/dc_op: self-biased DC operating point + supply current.
** An inverting gain stage has a narrow high-gain input window that moves with PDK/corner, so a
** fixed input bias is useless: a 1 TH feedback inductor DC-shorts vout back to vin instead
** (the amplifier-class bias-wrap trick), self-biasing the stage at its trip point vin = vout.
** Reports that trip voltage (v_trip) and the supply current at the ACTIVE operating point.
** Class port convention: vdd vout vin ibias vss; `ibias` is SINK-referenced (the DUT holds a
** PMOS-side diode at ibias, the bench pulls IBIAS out of it to vss).
** Bindings: DUT PORT_LINE VDD IBIAS PDK_INCLUDE.
.lib cornerMOSlv.lib mos_tt
.temp 27

.param VDD=1.5
.param IBIAS=20u

Vdd  vdd 0 dc {VDD}
Vss  vss 0 dc 0
Ibias ibias vss dc {IBIAS}
Lfb  vout vin 1T              ; 1 TH: DC short — self-bias at the trip point

XDUT vdd vout vin ibias vss gs_001_cascode_cs

.control
  set filetype=ascii
  op
  let i_supply = abs(i(Vdd))
  let v_trip = v(vout)
  print i_supply v_trip
  write
  quit
.endc
.param x_dut_xmpb1_w=16u
.param x_dut_xmpb1_l=0.5u
.param x_dut_xmpnr_w=0.5u
.param x_dut_xmnb2_w=6u
.param x_dut_xmnb2_l=0.3u
.param x_dut_xmpld_w=10u
.param x_dut_xmpld_l=0.5u
.param x_dut_xmnca_w=4u
.param x_dut_xmnin_w=4u
.param x_dut_xmnca_l=0.3u
.param x_dut_xmpb1_m=1
.param x_dut_xmpb2_m=1
.param x_dut_xmpnr_m=1
.param x_dut_xmnb2_m=1
.param x_dut_xmnb1_m=1
.param x_dut_xmpld_m=1
.param x_dut_xmpca_m=1
.param x_dut_xmnca_m=1
.param x_dut_xmnin_m=1
* ---- GENERATED parameter ties (abstract/params.yaml groups/ratios) ----
* Each tied symbol is defined exactly once, by its line below; rewrite that
* .param to untie just that symbol (untying = shadowing, plan D-3).
.param x_dut_xmpb2_l = {x_dut_xmpb1_l}
.param x_dut_xmpnr_l = {x_dut_xmpb1_l}
.param x_dut_xmpb2_w = {x_dut_xmpb1_w}
.param x_dut_xmnb1_w = {x_dut_xmnb2_w}
.param x_dut_xmnb1_l = {x_dut_xmnb2_l}
.param x_dut_xmpca_w = {x_dut_xmpld_w}
.param x_dut_xmpca_l = {x_dut_xmpld_l}
.param x_dut_xmnin_l = {x_dut_xmnca_l}
.subckt gs_001_cascode_cs vdd vout vin ibias vss
XMNB1 nbias1 nbias1 vss vss sg13_lv_nmos l=x_dut_xmnb1_l m=x_dut_xmnb1_m w=x_dut_xmnb1_w
XMNB2 nbias2 nbias2 nbias1 vss sg13_lv_nmos l=x_dut_xmnb2_l m=x_dut_xmnb2_m w=x_dut_xmnb2_w
XMNCA vout nbias2 nint vss sg13_lv_nmos l=x_dut_xmnca_l m=x_dut_xmnca_m w=x_dut_xmnca_w
XMNIN nint vin vss vss sg13_lv_nmos l=x_dut_xmnin_l m=x_dut_xmnin_m w=x_dut_xmnin_w
XMPB1 pbias1 pbias1 vdd vdd sg13_lv_pmos l=x_dut_xmpb1_l m=x_dut_xmpb1_m w=x_dut_xmpb1_w
XMPB2 ibias ibias pbias1 vdd sg13_lv_pmos l=x_dut_xmpb2_l m=x_dut_xmpb2_m w=x_dut_xmpb2_w
XMPCA vout ibias pint vdd sg13_lv_pmos l=x_dut_xmpca_l m=x_dut_xmpca_m w=x_dut_xmpca_w
XMPLD pint pbias1 vdd vdd sg13_lv_pmos l=x_dut_xmpld_l m=x_dut_xmpld_m w=x_dut_xmpld_w
XMPNR nbias2 ibias vdd vdd sg13_lv_pmos l=x_dut_xmpnr_l m=x_dut_xmpnr_m w=x_dut_xmpnr_w
.ends
.end
