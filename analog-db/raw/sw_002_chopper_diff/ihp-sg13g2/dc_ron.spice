** GENERATED by `analog-db export-raw` — DO NOT EDIT.
** circuit=sw_002_chopper_diff  class=switch  pdk=ihp-sg13g2  testbench=dc_ron  corner=tt
** Self-contained deck: testbench + bound params + lowered DUT (.subckt sw_002_chopper_diff).
** PDK corner libs resolve by BARE NAME on the image's ngspice sourcepath — run in a
** PDK-enabled env (the base image / api container), NOT a bare host:
**   docker run --rm -i spicexplorer-spice-base:local \
**     bash -lc 'd=$(mktemp -d) && cat > $d/c.spice && cd $d && ngspice -b c.spice' < raw/sw_002_chopper_diff/ihp-sg13g2/dc_ron.spice
*----------------------------------------------------------*
** params: 4 free + 2 frozen knobs (sizing.yaml) · 18 tied · 0 ratio-derived (abstract/params.yaml) · 3 testbench params
** AUTHORED TEMPLATE — switch/dc_ron_diff (plan_hierarchical_composition P3).
** On-resistance of a differential pass pair (e.g. the CCIA chopper-diff block: two
** transmission gates passing va_p->vb_p and va_n->vb_n when ON). The P path is swept and
** measured; the N path is biased at VMID and loaded identically so both halves conduct.
**
** Assumes the differential pass-pair port order:
**   .subckt <id> va_p va_n vb_p vb_n vctl vctl_not vdd vss
** Required bindings: DUT PORT_LINE VDD VMID ITEST VSWEEP_STEP PDK_INCLUDE.
.lib cornerMOSlv.lib mos_tt
.temp 27

.param VDD=1.2
.param VMID=0.6
.param ITEST=10u

Vdd  vdd 0 dc {VDD}
Vss  vss 0 dc 0
Vctl  vctl 0 dc {VDD}
Vctln vctl_not 0 dc 0
Vap  va_p 0 dc 0
Van  va_n 0 dc {VMID}
Isensep vb_p 0 dc {ITEST}
Isensen vb_n 0 dc {ITEST}

XDUT va_p va_n vb_p vb_n vctl vctl_not vdd vss sw_002_chopper_diff

.control
  set filetype=ascii
  dc Vap 0 1.2 0.01
  let ron_v = (v(va_p) - v(vb_p))/(10u)
  meas dc r_on FIND ron_v AT=0.6
  meas dc r_on_max MAX ron_v
  * MAX meas lines carry an `at=` suffix the result parser skips - re-print clean
  print r_on_max
  write
  quit
.endc
.param x_dut_xm1_w=2u
.param x_dut_xm1_l=0.13u
.param x_dut_xm2_w=2u
.param x_dut_xm2_l=0.13u
.param x_dut_xm1_m=1
.param x_dut_xm2_m=1
* ---- GENERATED parameter ties (abstract/params.yaml groups/ratios) ----
* Each tied symbol is defined exactly once, by its line below; rewrite that
* .param to untie just that symbol (untying = shadowing, plan D-3).
.param x_dut_xm3_w = {x_dut_xm1_w}
.param x_dut_xm5_w = {x_dut_xm1_w}
.param x_dut_xm7_w = {x_dut_xm1_w}
.param x_dut_xm3_l = {x_dut_xm1_l}
.param x_dut_xm5_l = {x_dut_xm1_l}
.param x_dut_xm7_l = {x_dut_xm1_l}
.param x_dut_xm3_m = {x_dut_xm1_m}
.param x_dut_xm5_m = {x_dut_xm1_m}
.param x_dut_xm7_m = {x_dut_xm1_m}
.param x_dut_xm4_w = {x_dut_xm2_w}
.param x_dut_xm6_w = {x_dut_xm2_w}
.param x_dut_xm8_w = {x_dut_xm2_w}
.param x_dut_xm4_l = {x_dut_xm2_l}
.param x_dut_xm6_l = {x_dut_xm2_l}
.param x_dut_xm8_l = {x_dut_xm2_l}
.param x_dut_xm4_m = {x_dut_xm2_m}
.param x_dut_xm6_m = {x_dut_xm2_m}
.param x_dut_xm8_m = {x_dut_xm2_m}
.subckt sw_002_chopper_diff va_p va_n vb_p vb_n vctl vctl_not vdd vss
XM1 va_p vctl vb_p vss sg13_lv_nmos l=x_dut_xm1_l m=x_dut_xm1_m w=x_dut_xm1_w
XM2 vb_p vctl_not va_p vdd sg13_lv_pmos l=x_dut_xm2_l m=x_dut_xm2_m w=x_dut_xm2_w
XM3 va_n vctl vb_n vss sg13_lv_nmos l=x_dut_xm3_l m=x_dut_xm3_m w=x_dut_xm3_w
XM4 vb_n vctl_not va_n vdd sg13_lv_pmos l=x_dut_xm4_l m=x_dut_xm4_m w=x_dut_xm4_w
XM5 va_p vctl_not vb_n vss sg13_lv_nmos l=x_dut_xm5_l m=x_dut_xm5_m w=x_dut_xm5_w
XM6 vb_n vctl va_p vdd sg13_lv_pmos l=x_dut_xm6_l m=x_dut_xm6_m w=x_dut_xm6_w
XM7 va_n vctl_not vb_p vss sg13_lv_nmos l=x_dut_xm7_l m=x_dut_xm7_m w=x_dut_xm7_w
XM8 vb_p vctl va_n vdd sg13_lv_pmos l=x_dut_xm8_l m=x_dut_xm8_m w=x_dut_xm8_w
.ends
.end
