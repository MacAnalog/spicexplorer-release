** GENERATED by `analog-db generate` — DO NOT EDIT. Source: abstract/netlist.spice → ihp-sg13g2
* adc_001_inv1b (emitted by spicexplorer-circuitgraph)
XMN vout vin vss vss sg13_lv_nmos l=x_dut_xmn_l m=x_dut_xmn_m w=x_dut_xmn_w
XMP vout vin vdd vdd sg13_lv_pmos l=x_dut_xmp_l m=x_dut_xmp_m w=x_dut_xmp_w
.end
