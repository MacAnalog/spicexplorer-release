** GENERATED by `analog-db export-raw` — DO NOT EDIT.
** circuit=amp_032_ti_ldo_error_selfbias  class=amplifier  pdk=gf180mcu  testbench=ac_open_loop  corner=tt
** Self-contained deck: testbench + bound params + lowered DUT (.subckt amp_032_ti_ldo_error_selfbias).
** PDK corner libs resolve by BARE NAME on the image's ngspice sourcepath — run in a
** PDK-enabled env (the base image / api container), NOT a bare host:
**   docker run --rm -i spicexplorer-spice-base:local \
**     bash -lc 'd=$(mktemp -d) && cat > $d/c.spice && cd $d && ngspice -b c.spice' < raw/amp_032_ti_ldo_error_selfbias/gf180mcu/ac_open_loop.spice
*----------------------------------------------------------*
** params: 18 free + 0 frozen knobs (sizing.yaml) · 9 tied · 0 ratio-derived (abstract/params.yaml) · 3 testbench params
** AUTHORED TEMPLATE — amplifier/ac_open_loop_biaswrap (plan D-4; the AnalogGym bias-wrap).
** Open-loop gain measured in closed-loop bias (analoggym-amplifiers skill §5): a 1 TH inductor
** DC-shorts the output back to the inverting input — setting the high-gain operating point —
** while a 1 TF cap AC-opens that feedback and injects the AC input. This is the only way a
** high-gain 3-stage amp biases stably while still exposing its open-loop AC response.
**
** Assumes the AnalogGym canonical DUT port order (self-biased; NO ibias port):
**   .subckt <id> vss vdd vinn vinp vout
** Bindings: DUT VDD VCM CL FSTART FSTOP PPD PDK_INCLUDE.
** FIXED 2026-07-20: this template used to hardcode `X1 0 vdd opout_dc opin opout amp_032_ti_ldo_error_selfbias`,
** which silently assumed the AnalogGym port order [vss vdd vinn vinp vout] and MIS-WIRED any
** DUT declaring a different order (e.g. the amplifier-class [vdd vout vinp vinn vss] swaps
** vdd<->vss). It now uses XDUT vdd vout vinp vinn vss with canonical node names, exactly like the
** *_biaswrap_ibias sibling. For the AnalogGym DUTs this is a no-op: their vss port binds to
** node `vss`, which `Vss vss 0 dc 0` ties to ground just as the old direct-to-0 wiring did.
.include design.ngspice
.lib sm141064.ngspice typical
.temp 27

.param VDD=3.3
.param VCM=1.2
.param CL=10p

Vdd  vdd 0 dc {VDD}
Vss  vss 0 dc 0
Vcm  vinp 0 dc {VCM}          ; common-mode bias on the non-inverting input
Vac  sigin 0 dc 0 ac 1        ; AC stimulus
Lfb  vout vinn 1T        ; 1 TH: DC short (bias), AC open
Cin  vinn sigin 1T        ; 1 TF: DC open, AC inject into the inverting node
CLoad vout 0 {CL}

XDUT vdd vout vinp vinn vss amp_032_ti_ldo_error_selfbias
.control
  set filetype=ascii
  ac dec 101 10 100MEG
  meas ac dcgain FIND vdb(vout) AT=10
  meas ac ugf    WHEN vdb(vout)=0 FALL=1
  let phc = cph(vout)*180/3.14159265
  let ph  = 180 + phc - phc[0]
  meas ac pm     FIND ph WHEN vdb(vout)=0 FALL=1
  write
  quit
.endc
.param x_dut_xmbp_w=6.3111e-06
.param x_dut_xmbp_l=2e-06
.param x_dut_xmb0_w=3.4533e-05
.param x_dut_xmb0_l=2e-06
.param x_dut_xmbc_m=1
.param x_dut_xmbo_m=1
.param x_dut_xm1_w=6.8542e-05
.param x_dut_xm1_l=7e-07
.param x_dut_xm3_w=6.9545e-05
.param x_dut_xm3_l=5e-07
.param x_dut_xm4_w=1e-05
.param x_dut_xm4_l=5e-07
.param x_dut_xm6_w=6e-05
.param x_dut_xm6_l=1e-06
.param r_z=10000
.param c_comp=1.5e-11
.param x_dut_xmbf_w=5e-06
.param r_nd=500000
* ---- GENERATED parameter ties (abstract/params.yaml groups/ratios) ----
* Each tied symbol is defined exactly once, by its line below; rewrite that
* .param to untie just that symbol (untying = shadowing, plan D-3).
.param x_dut_xmbc_l = {x_dut_xmb0_l}
.param x_dut_xmbf_l = {x_dut_xmb0_l}
.param x_dut_xmbo_l = {x_dut_xmb0_l}
.param x_dut_xmbc_w = {x_dut_xmb0_w}
.param x_dut_xmbo_w = {x_dut_xmb0_w}
.param x_dut_xm2_w = {x_dut_xm1_w}
.param x_dut_xm2_l = {x_dut_xm1_l}
.param x_dut_xm5_w = {x_dut_xm3_w}
.param x_dut_xm5_l = {x_dut_xm3_l}
.subckt amp_032_ti_ldo_error_selfbias vdd vout vinp vinn vss
CC ncz vout 'c_comp'
RND na nd 'r_nd'
RZ nb ncz 'r_z'
XM1 na vinn tail vss nfet_06v0 l=x_dut_xm1_l w=x_dut_xm1_w
XM2 nb vinp tail vss nfet_06v0 l=x_dut_xm2_l w=x_dut_xm2_w
XM3 na nd vdd vdd pfet_06v0 l=x_dut_xm3_l w=x_dut_xm3_w
XM4 nlev na nd vdd pfet_06v0 l=x_dut_xm4_l w=x_dut_xm4_w
XM5 nb nd vdd vdd pfet_06v0 l=x_dut_xm5_l w=x_dut_xm5_w
XM6 vout nb vdd vdd pfet_06v0 l=x_dut_xm6_l w=x_dut_xm6_w
XMB0 ibias ibias vss vss nfet_06v0 l=x_dut_xmb0_l w=x_dut_xmb0_w
XMBC tail ibias vss vss nfet_06v0 l=x_dut_xmbc_l m=x_dut_xmbc_m w=x_dut_xmbc_w
XMBF nlev ibias vss vss nfet_06v0 l=x_dut_xmbf_l w=x_dut_xmbf_w
XMBO vout ibias vss vss nfet_06v0 l=x_dut_xmbo_l m=x_dut_xmbo_m w=x_dut_xmbo_w
XMBP ibias ibias vdd vdd pfet_06v0 l=x_dut_xmbp_l w=x_dut_xmbp_w
.ends
.end
