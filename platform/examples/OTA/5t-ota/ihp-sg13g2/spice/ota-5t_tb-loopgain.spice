** Example of simple 5-transistor OTA AC analysis testbench
*----------------------------------------------------------*
* Testbench
*----------------------------------------------------------
**.subckt ota-5t_tb-loopgain
Vdd v_dd GND VDD
Vss v_ss GND 0
Vin v_in v_ss dc 0.75
Venable v_ena v_ss VDD
C2 vr1 v_ss 50f m=1
I1 v_dd net1 20u
x1 v_dd vr1 v_in vf1 net1 v_ena v_ss ota-5t
Vtest1 vf1 vr1 dc 0 ac 1
C1 net2 v_ss 50f m=1
I2 v_dd net3 20u
x2 v_dd net2 v_in net4 net3 v_ena v_ss ota-5t
Vir1 net2 net5 0
.save i(vir1)
Vif1 net5 net4 0
.save i(vif1)
Itest1 v_ss net5 dc 0 ac 1
C3 net6 v_ss 50f m=1
I3 v_dd net7 20u
x3 v_dd net6 v_in vmeas1 net7 v_ena v_ss ota-5t
C4 net8 v_ss 50f m=1
I4 v_dd net9 20u
x4 v_dd net8 v_in vmeas2 net9 v_ena v_ss ota-5t
Itest3 v_ss vmeas1 dc 0 ac 0
Vtest2 vmeas1 net10 dc 0 ac 1
Vimeas1 net6 net10 0
.save i(vimeas1)
Itest2 v_ss vmeas2 dc 0 ac 1
Vtest3 vmeas2 net11 dc 0 ac 0
Vimeas2 net8 net11 0
.save i(vimeas2)

*----------------------------------------------------------*
* Technology Library
*----------------------------------------------------------*
 .lib cornerMOSlv.lib mos_tt

* .options savecurrents
.options reltol=1e-3 abstol=1e-12 gmin=1e-15

*----------------------------------------------------------*
* Control Block
*----------------------------------------------------------*
.control

    echo ==================================
    echo start of Control
    echo ==================================

    echo
    echo (A) start of OP
    echo ----------------------------------

    * Operating Point Analysis (not needed in the optimization... could be turned on but it is turned off to save sim time)
    * op
    * remzerovec
    * write
    * set appendwrite

    echo
    echo (B) start of AC Sim
    echo ----------------------------------

    * save the vectors needed in the post-processing
    save vr1 vf1 vir1 vif1 vmeas2 Vimeas2 vmeas1 Vimeas1

    * AC Analysis
    ac dec 101 1 100G

    echo (1) performing Middlebrook's Method

    * Middlebrook's Method
    let tv=-v(vr1)/v(vf1)
    let ti=-i(vir1)/i(vif1)
    let tmb=(tv*ti - 1)/(tv + ti + 2)

    *plot db(tmb) ylabel 'Magnitude - Middlebrook'
    *plot 180/pi*cphase(tmb) ylabel 'Phase - Middlebrook'

    * echo (2) performing Tian's Method

    * Tian's Method
    * * vtest=0, itest=1:
    * let A=i(Vimeas2)
    * let C=v(vmeas2)

    * * vtest=1, itest=0:
    * let B=i(Vimeas1)
    * let D=v(vmeas1)
    * let ttian=(A*D-B*C-A)/(2*(B*C-A*D)+A-D+1)

    *plot db(ttian) ylabel 'Magnitude - Tian'
    *plot 180/pi*cphase(ttian) ylabel 'Phase - Tian'

    echo (3) measuring performance metrics

    * magnitude
    let out = tmb
    let out_mag = db(out)
    let out_phase = cphase(tmb) * 180/pi

    meas ac GMAX max out_mag

    meas ac DCGAIN MAX out_mag FROM=10 TO=10k

    let f3db = DCGAIN-3
    meas ac FBW WHEN out_mag=f3db FALL=1

    meas ac unity_gain_phase find out_phase when out_mag=0
    meas ac UGF when out_mag=0 fall=1

    let PM = (180-unity_gain_phase) % 180

    * Output measured metrics to a file (optional)
    * print DCGAIN FBW PM UGF > meas_results.txt

    echo (4) plotting...

    * Middlebrook vs. Tian
    * plot db(tmb) db(ttian) ylabel 'Magnitude'
    * plot 180/pi*cphase(tmb) 180/pi*cphase(ttian) ylabel 'Phase'

    echo ----------------------------------
    echo END of AC sim
    echo  ----------------------------------

    echo SAVING SIMULATION RESULTS IN THE RAW FILE
    * save out DCGAIN PM FBW UGF
    write

    echo ==================================
    echo END of Control
    echo ==================================

    quit

.endc

*----------------------------------------------------------*
* Parameter Definitions
*----------------------------------------------------------*

.temp 27

* Supply rail as a parameter so PVT corners can override it (default 1.5 V
* reproduces this testbench's original hardcoded supply exactly). The enable pin
* tracks VDD. Input common-mode stays a fixed 0.75 V bias across corners.
.param VDD=1.5

.param x_dut_nfet_input_w=1.5u
.param x_dut_nfet_input_l=1.5u

.param x_dut_nfet_mirror_w=1.5u
.param x_dut_nfet_mirror_l=1.5u

.param x_dut_pfet_load_w=1.5u
.param x_dut_pfet_load_l=1.5u

.param x_dut_nfet_mirror_ref_w=2.0u
.param x_dut_nfet_mirror_ref_l=5.0u

*----------------------------------------------------------*
* Subcircuit Definition
*----------------------------------------------------------*
.subckt ota-5t vdd vout vinp vinn ibias_20u d_ena vss
*.ipin ibias_20u
*.iopin vdd
*.iopin vss
*.ipin vinp
*.ipin vinn
*.opin vout
*.ipin d_ena
XM5 tail gate_n vss vss sg13_lv_nmos w=x_dut_nfet_mirror_w l=x_dut_nfet_mirror_l ng=1 m=1
XM4 vout gate_p vdd vdd sg13_lv_pmos w=x_dut_pfet_load_w l=x_dut_pfet_load_l ng=1 m=1
XM1 gate_p vinp tail vss sg13_lv_nmos w=x_dut_nfet_input_w l=x_dut_nfet_input_l ng=1 m=1
XM2 vout vinn tail vss sg13_lv_nmos w=x_dut_nfet_input_w l=x_dut_nfet_input_l ng=1 m=1
XM3 gate_p gate_p vdd vdd sg13_lv_pmos w=x_dut_pfet_load_w l=x_dut_pfet_load_l ng=1 m=1
XM6 ibias_20u gate_n vss vss sg13_lv_nmos w=x_dut_nfet_mirror_ref_w l=x_dut_nfet_mirror_ref_l ng=1 m=1
XM9 gate_n ena_n vss vss sg13_lv_nmos w=0.5u l=0.13u ng=1 m=1
XM11 gate_p ena vdd vdd sg13_lv_pmos w=1.5u l=0.13u ng=1 m=1
XM7 ena ena_n vss vss sg13_lv_nmos w=0.5u l=0.13u ng=1 m=1
XM8 ena ena_n vdd vdd sg13_lv_pmos w=1.5u l=0.13u ng=1 m=1
XM10 ibias_20u ena gate_n vss sg13_lv_nmos w=0.5u l=0.13u ng=1 m=1
XM12 ena_n d_ena vss vss sg13_lv_nmos w=0.5u l=0.13u ng=1 m=1
XM13 ena_n d_ena vdd vdd sg13_lv_pmos w=1.5u l=0.13u ng=1 m=1
.ends

.GLOBAL GND
.end
