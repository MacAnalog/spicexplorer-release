** GENERATED by `analog-db export-raw` — DO NOT EDIT.
** Standalone lowered DUT subckt for vref_001_vgs on ihp-sg13g2 (sizing .param defaults + .subckt).
** Not a runnable deck on its own — include it under your own testbench:
**   .include _dut.spice
**   XDUT vdd vref vss vref_001_vgs
** Source: pdk/ihp-sg13g2/netlist.spice (run `analog-db generate` to refresh).
*----------------------------------------------------------*
** params: 6 free + 0 frozen knobs (sizing.yaml) · 0 tied · 0 ratio-derived (abstract/params.yaml)
.param x_dut_xm0_w=2.5u
.param x_dut_xm0_l=2.0u
.param x_dut_xm0_m=1
.param x_dut_xm1_w=1.0u
.param x_dut_xm1_l=2.0u
.param x_dut_xm1_m=1
.subckt vref_001_vgs vdd vref vss
XM0 vdd vref vref vss sg13_lv_nmos l=x_dut_xm0_l m=x_dut_xm0_m w=x_dut_xm0_w
XM1 vref vref vss vss sg13_hv_nmos l=x_dut_xm1_l m=x_dut_xm1_m w=x_dut_xm1_w
.ends
