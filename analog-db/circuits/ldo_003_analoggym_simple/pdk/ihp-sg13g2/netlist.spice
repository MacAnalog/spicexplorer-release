** GENERATED by `analog-db generate` — DO NOT EDIT. Source: abstract/netlist.spice → ihp-sg13g2
* ldo_003_analoggym_simple (emitted by spicexplorer-circuitgraph)
CC ncz vout 'c_comp'
RZ ncz ngate 'r_z'
R_BLEED vout vss 'r_bleed'
VB vb vss dc {vb_val}
VLP lp_brk vout dc 0
VREF vref vss dc {vref_val}
XM1 ndiode lp_brk ntail vss sg13_hv_nmos l=x_dut_xm1_l w=x_dut_xm1_w
XM2 ngate vref ntail vss sg13_hv_nmos l=x_dut_xm2_l w=x_dut_xm2_w
XM3 ngate ndiode vdd vdd sg13_hv_pmos l=x_dut_xm3_l w=x_dut_xm3_w
XM4 ndiode ndiode vdd vdd sg13_hv_pmos l=x_dut_xm4_l w=x_dut_xm4_w
XM5 ntail vb vss vss sg13_hv_nmos l=x_dut_xm5_l w=x_dut_xm5_w
XMP vout ngate vdd vdd sg13_hv_pmos l=x_dut_xmp_l m=x_dut_xmp_m w=x_dut_xmp_w
.end
