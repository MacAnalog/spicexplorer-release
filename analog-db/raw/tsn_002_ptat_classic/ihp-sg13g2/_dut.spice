** GENERATED by `analog-db export-raw` — DO NOT EDIT.
** Standalone lowered DUT subckt for tsn_002_ptat_classic on ihp-sg13g2 (sizing .param defaults + .subckt).
** Not a runnable deck on its own — include it under your own testbench:
**   .include _dut.spice
**   XDUT vdd vout vss tsn_002_ptat_classic
** Source: pdk/ihp-sg13g2/netlist.spice (run `analog-db generate` to refresh).
*----------------------------------------------------------*
** params: 6 free + 4 frozen knobs (sizing.yaml) · 3 tied · 0 ratio-derived (abstract/params.yaml)
.param x_dut_xm3_w=2.0u
.param x_dut_xm3_l=1.0u
.param x_dut_xm0_w=8.0u
.param x_dut_xm1_w=2.0u
.param x_dut_xm0_l=1.0u
.param x_r0=20000
.param x_dut_xm3_m=1
.param x_dut_xm4_m=1
.param x_dut_xm0_m=1
.param x_dut_xm1_m=1
* ---- GENERATED parameter ties (abstract/params.yaml groups/ratios) ----
* Each tied symbol is defined exactly once, by its line below; rewrite that
* .param to untie just that symbol (untying = shadowing, plan D-3).
.param x_dut_xm4_w = {x_dut_xm3_w}
.param x_dut_xm4_l = {x_dut_xm3_l}
.param x_dut_xm1_l = {x_dut_xm0_l}
.subckt tsn_002_ptat_classic vdd vout vss
R0 vout vss x_r0
XM0 vmir net1 vout vout sg13_lv_nmos l=x_dut_xm0_l m=x_dut_xm0_m w=x_dut_xm0_w
XM1 net1 net1 vss vss sg13_lv_nmos l=x_dut_xm1_l m=x_dut_xm1_m w=x_dut_xm1_w
XM3 vmir vmir vdd vdd sg13_lv_pmos l=x_dut_xm3_l m=x_dut_xm3_m w=x_dut_xm3_w
XM4 net1 vmir vdd vdd sg13_lv_pmos l=x_dut_xm4_l m=x_dut_xm4_m w=x_dut_xm4_w
.ends
