** GENERATED by `analog-db export-raw` — DO NOT EDIT.
** circuit=cmfb_003_5t_nmos_input  class=cmfb  pdk=sky130  testbench=ac_servo  corner=tt
** Self-contained deck: testbench + bound params + lowered DUT (.subckt cmfb_003_5t_nmos_input).
** PDK corner libs resolve by BARE NAME on the image's ngspice sourcepath — run in a
** PDK-enabled env (the base image / api container), NOT a bare host:
**   docker run --rm -i spicexplorer-spice-base:local \
**     bash -lc 'd=$(mktemp -d) && cat > $d/c.spice && cd $d && ngspice -b c.spice' < raw/cmfb_003_5t_nmos_input/sky130/ac_servo.spice
*----------------------------------------------------------*
** params: 11 free + 5 frozen knobs (sizing.yaml) · 7 tied · 0 ratio-derived (abstract/params.yaml) · 3 testbench params
** AUTHORED TEMPLATE — cmfb/ac_servo (servo path transfer). Moved from support/
** 2026-07-20 when CMFB circuits got their own class (sup_002 -> cmfb_001); extended
** with ugf_servo_hz. History: plan_hierarchical_composition P3.
** CMFB-servo transfer: both sense inputs driven together (common-mode) with an AC unit
** about VCM; the servo's control output (vcmfb) transfer gives the CM-loop path gain,
** bandwidth, and unity-gain frequency into the bound control-node load CL (the actuator
** gate proxy). The DC bias point is the ZERO-ERROR point (sensed == vref), i.e. the
** small-signal is taken about vcmfb_nat (see dc_cmfb_transfer).
**   gain_servo_db  low-frequency servo path gain, db(v(vcmfb)) at FSTART
**   bw_servo_hz    -3 dB rolloff into CL
**   ugf_servo_hz   |servo transfer| = 0 dB crossing (absent when gain < 0 dB —
**                  harmless meas failure; keep it in `produces:` only for members
**                  with above-unity servo gain)
** Assumes the CMFB-servo port order:
**   .subckt <id> vinp vinn vcmfb vref vdd vss
** Required bindings: DUT PORT_LINE VDD VCM CL FSTART FSTOP PPD PDK_INCLUDE.
.lib sky130.lib.spice tt
.temp 27

.param VDD=1.8
.param VCM=0.9
.param CL=50f

Vdd  vdd 0 dc {VDD}
Vss  vss 0 dc 0
Vref vref 0 dc {VCM}
Vcm  vcm 0 dc {VCM} ac 1
* common-mode drive: both inputs follow the same AC source
Vinp vinp vcm dc 0
Vinn vinn vcm dc 0
CLoad vcmfb 0 {CL}

XDUT vinp vinn vcmfb vref vdd vss cmfb_003_5t_nmos_input

.control
  set filetype=ascii
  ac dec 61 10 1G
  let gdb = db(v(vcmfb))
  meas ac gain_servo_db FIND gdb AT=10
  let g3 = gain_servo_db - 3
  meas ac bw_servo_hz WHEN gdb=g3 FALL=1
  meas ac ugf_servo_hz WHEN gdb=0 FALL=1
  write
  quit
.endc
.param x_dut_xm1_w=8
.param x_dut_xm1_l=1
.param x_dut_xm3_w=12
.param x_dut_xm3_l=2
.param x_dut_xm8_w=10
.param x_dut_xm8_l=1
.param x_dut_xm5_w=5
.param x_dut_xm5_l=1
.param x_dut_xm6_w=30
.param x_dut_xm6_l=1
.param x_dut_rmp_value=5Meg
.param x_dut_xm1_m=1
.param x_dut_xm3_m=1
.param x_dut_xm5_m=1
.param x_dut_xm6_m=1
.param x_dut_xm8_m=1
* ---- GENERATED parameter ties (abstract/params.yaml groups/ratios) ----
* Each tied symbol is defined exactly once, by its line below; rewrite that
* .param to untie just that symbol (untying = shadowing, plan D-3).
.param x_dut_xm2_w = {x_dut_xm1_w}
.param x_dut_xm2_l = {x_dut_xm1_l}
.param x_dut_xm2_m = {x_dut_xm1_m}
.param x_dut_xm4_w = {x_dut_xm3_w}
.param x_dut_xm4_l = {x_dut_xm3_l}
.param x_dut_xm4_m = {x_dut_xm3_m}
.param x_dut_rmn_value = {x_dut_rmp_value}
.subckt cmfb_003_5t_nmos_input vinp vinn vcmfb vref vdd vss
RMN vinn cm_sense 'x_dut_rmn_value'
RMP cm_sense vinp 'x_dut_rmp_value'
XM1 mirr cm_sense ntail vss sky130_fd_pr__nfet_01v8 l=x_dut_xm1_l m=x_dut_xm1_m w=x_dut_xm1_w
XM2 vcmfb vref ntail vss sky130_fd_pr__nfet_01v8 l=x_dut_xm2_l m=x_dut_xm2_m w=x_dut_xm2_w
XM3 mirr mirr vdd vdd sky130_fd_pr__pfet_01v8 l=x_dut_xm3_l m=x_dut_xm3_m w=x_dut_xm3_w
XM4 vcmfb mirr vdd vdd sky130_fd_pr__pfet_01v8 l=x_dut_xm4_l m=x_dut_xm4_m w=x_dut_xm4_w
XM5 bias bias vss vss sky130_fd_pr__nfet_01v8 l=x_dut_xm5_l m=x_dut_xm5_m w=x_dut_xm5_w
XM6 bias bias vdd vdd sky130_fd_pr__pfet_01v8 l=x_dut_xm6_l m=x_dut_xm6_m w=x_dut_xm6_w
XM8 ntail bias vss vss sky130_fd_pr__nfet_01v8 l=x_dut_xm8_l m=x_dut_xm8_m w=x_dut_xm8_w
.ends
.end
