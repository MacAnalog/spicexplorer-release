** Abstract classic Miller two-stage opamp (PMOS input).
** AUTHORED source of truth (plan D-2). PDK-neutral model tokens (nmos/pmos + an ideal C);
** per-PDK device names + geometry come from circuitgraph lowering + pdk/<pdk>/ bindings.
** Subckt port order (= circuit.yaml ports): vdd vout vinp vinn ibias vss
**
** Topology (ferrosim / circuit-bench "two-stage-opamp"): PMOS input pair (XM0/XM1) with NMOS
** mirror load (XM3 diode / XM4), PMOS tail (XM5) and second-stage PMOS current-source load
** (XM6) both gated from the XM7 PMOS bias diode; NMOS common-source second stage (XM2);
** Miller cap CC from the stage-1 output (b) to vout.
** Bias front-end (promotion addition, class ibias convention): XMBD = NMOS diode at the ibias
** port (bench pushes IBIAS in from vdd), XMBS mirrors it to SINK the reference current out of
** the PMOS diode XM7 — replacing the upstream deck's external ideal sink.
** Device widths stay per-finger (IHP lv MOS w <= ~10 um; PSP clips silently) — totals via m=.
**
** ATOMIC parameterization (plan_parameterization D-1): every instance carries its own
** mechanically-derived x_dut_<id>_<field> symbols — pure topology, no design opinion.
** The legacy shared knobs (ONE x_n_l across all NMOS, x_p_l across all PMOS, x_nload_w across
** mirror load + 2nd stage, frozen m=3/5/17/24) now live in abstract/params.yaml as tagged
** groups/ratios and lower to a generated .param tie block in the exported decks.
XMBD ibias ibias vss vss nmos w=x_dut_xmbd_w l=x_dut_xmbd_l m=x_dut_xmbd_m
XMBS pbias ibias vss vss nmos w=x_dut_xmbs_w l=x_dut_xmbs_l m=x_dut_xmbs_m
XM7  pbias pbias vdd vdd pmos w=x_dut_xm7_w  l=x_dut_xm7_l  m=x_dut_xm7_m
XM5  c     pbias vdd vdd pmos w=x_dut_xm5_w  l=x_dut_xm5_l  m=x_dut_xm5_m
XM0  a     vinn  c   vdd pmos w=x_dut_xm0_w  l=x_dut_xm0_l  m=x_dut_xm0_m
XM1  b     vinp  c   vdd pmos w=x_dut_xm1_w  l=x_dut_xm1_l  m=x_dut_xm1_m
XM3  a     a     vss vss nmos w=x_dut_xm3_w  l=x_dut_xm3_l  m=x_dut_xm3_m
XM4  b     a     vss vss nmos w=x_dut_xm4_w  l=x_dut_xm4_l  m=x_dut_xm4_m
XM6  vout  pbias vdd vdd pmos w=x_dut_xm6_w  l=x_dut_xm6_l  m=x_dut_xm6_m
XM2  vout  b     vss vss nmos w=x_dut_xm2_w  l=x_dut_xm2_l  m=x_dut_xm2_m
CC   b     vout  c=x_dut_cc_value
.end
