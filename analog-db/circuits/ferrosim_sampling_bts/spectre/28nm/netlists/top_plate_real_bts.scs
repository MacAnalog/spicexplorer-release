// Top-plate sampling linearity TB: Maestro schematic_real transistor bootstrap.

simulator lang=spectre
global 0

parameters VDD=900m Vcm=450m A=400m Fs=1G N=128 J=37 t_delay=20p
parameters Fin=((J/N)*Fs) t_end=((N+2)/Fs)

include "../../common/stdcell_netlist/tcbn28hpcplusbwp12t30p140lvt_170a.spi"
include "${PDK_ROOT}/models/spectre/toplevel_modified.scs" section=top_tt
include "bootstrap.scs"
include "top_plate_dut.scs"

V_INN (VINN 0) vsource dc=Vcm type=sine sinedc=Vcm ampl=A sinephase=180 freq=Fin
V_INP (VINP 0) vsource dc=Vcm type=sine sinedc=Vcm ampl=A freq=Fin
V_VDDBTS (VDDBTS 0) vsource dc=VDD type=dc
V_VSSBTS (VSSBTS 0) vsource dc=0 type=dc
V_CLKS (CLKS 0) vsource dc=VDD type=pulse val0=0 val1=VDD period=1/Fs \
    delay=t_delay+50p rise=10p fall=10p width=1/4/Fs-50p

I_BTS_N (VGN VSSBTS CLKS VDDBTS VINN) LB_BOOTSTRAPPER_REAL
I_BTS_P (VGP VSSBTS CLKS VDDBTS VINP) LB_BOOTSTRAPPER_REAL
I_DUT (VSP VSN VGP VGN VINP VINN 0) TOP_PLATE_SAMPLER

simulatorOptions options psfversion="1.4.0" temp=27 tnom=27 scalem=1.0 \
    scale=1.0 gmin=1e-12 rforce=1 maxnotes=5 maxwarns=5 digits=5 cols=80 \
    pivrel=1e-3 checklimitdest=psf
tran tran stop=t_end write="spectre.ic" writefinal="spectre.fc" \
    annotate=status save=selected flushtime=30
finalTimeOP info what=oppoint where=rawfile
modelParameter info what=models where=rawfile
element info what=inst where=rawfile
outputParameter info what=output where=rawfile
designParamVals info what=parameters where=rawfile
primitives info what=primitives where=rawfile
subckts info what=subckts where=rawfile
save CLKS VINP VINN VSP VSN VGP VGN
save I_DUT.M_P:vgs I_DUT.M_P:gds I_DUT.M_N:vgs I_DUT.M_N:gds
saveOptions options save=selected
