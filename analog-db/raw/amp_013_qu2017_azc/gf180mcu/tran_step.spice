** GENERATED by `analog-db export-raw` — DO NOT EDIT.
** circuit=amp_013_qu2017_azc  class=amplifier  pdk=gf180mcu  testbench=tran_step  corner=tt
** Self-contained deck: testbench + bound params + lowered DUT (.subckt amp_013_qu2017_azc).
** PDK corner libs resolve by BARE NAME on the image's ngspice sourcepath — run in a
** PDK-enabled env (the base image / api container), NOT a bare host:
**   docker run --rm -i spicexplorer-spice-base:local \
**     bash -lc 'd=$(mktemp -d) && cat > $d/c.spice && cd $d && ngspice -b c.spice' < raw/amp_013_qu2017_azc/gf180mcu/tran_step.spice
*----------------------------------------------------------*
** params: 38 free + 0 frozen knobs (sizing.yaml) · 34 tied · 11 ratio-derived (abstract/params.yaml) · 4 testbench params
** AUTHORED TEMPLATE — amplifier/tran_step_biaswrap: unity-gain step settling for DUTs on the
** AnalogGym self-bias convention (ports vss vdd vinn vinp vout; NO ibias port). Single-ended
** companion of tran_step_diff (M4 follow-up). Unlike the AC/noise bias-wraps — which AC-open the
** loop with Lfb/Cin — a settling measurement WANTS the real closed loop: wire the inverting input
** directly to the output (unity-gain follower) and step the non-inverting input. Settle to the
** FINAL output value, not the input step, so a systematic offset can't hold a fixed-tolerance band
** open forever (see universal/tran_step for the rationale). These are compensated multistage OTAs,
** designed stable in unity feedback.
**
** Assumes the AnalogGym canonical DUT port order (self-biased; NO ibias port):
**   .subckt <id> vss vdd vinn vinp vout
** Bindings: DUT VDD VCM CL VSTEP TSTART TSTEP TSTOP VTOL PDK_INCLUDE.
** FIXED 2026-07-20: this template used to hardcode `X1 0 vdd opout_dc opin opout amp_013_qu2017_azc`,
** which silently assumed the AnalogGym port order [vss vdd vinn vinp vout] and MIS-WIRED any
** DUT declaring a different order (e.g. the amplifier-class [vdd vout vinp vinn vss] swaps
** vdd<->vss). It now uses XDUT vss vdd vinn vinp vout with canonical node names, exactly like the
** *_biaswrap_ibias sibling. For the AnalogGym DUTs this is a no-op: their vss port binds to
** node `vss`, which `Vss vss 0 dc 0` ties to ground just as the old direct-to-0 wiring did.
.include design.ngspice
.lib sm141064.ngspice noise_corner
.lib sm141064.ngspice nfet_03v3_t
.lib sm141064.ngspice pfet_03v3_t
.lib sm141064.ngspice fets_mm
.temp 27

.param VDD=1.8
.param VCM=300m
.param CL=1500p
.param VSTEP=0.2

Vdd  vdd 0 dc {VDD}
Vss  vss 0 dc 0
CLoad vout 0 {CL}
Vinp vinp 0 dc {VCM} pulse({VCM} {VCM+VSTEP} 1u 1n 1n 1 1)
Vfb  vinn vout dc 0          ; unity-gain feedback wire (vinn <- vout; 0 V source = ideal wire)

XDUT vss vdd vinn vinp vout amp_013_qu2017_azc
.control
  set filetype=ascii
  tran 10n 200u
  * settle to the FINAL value, not the input step — a follower's systematic offset would
  * otherwise keep |vout - vfinal| outside a tight tolerance band forever.
  meas tran vfinal FIND v(vout) AT=200u
  let verr = abs(v(vout) - vfinal)
  meas tran tcross WHEN verr=2m FALL=LAST
  let t_settle = tcross - 1u
  print t_settle
  write
  quit
.endc
.param CAPACITOR_0=9.89825533013604e-13
.param CAPACITOR_1=9.699486474277936e-13
.param CAPACITOR_2=3.4301380908385716e-13
.param CURRENT_0_BIAS=1.1407160477046306e-06
.param x_dut_xm3_l=2.935577622893652e-06
.param x_dut_xm5_m=4
.param x_dut_xm3_w=7.211308519223292e-07
.param x_dut_xm11_l=1.9336964656148824e-06
.param x_dut_xm11_m=4
.param x_dut_xm11_w=1.888255317373759e-06
.param x_dut_xm12_l=2.66307335147796e-06
.param x_dut_xm12_m=4
.param x_dut_xm12_w=4.6071488558508376e-07
.param x_dut_xm13_l=2.6551593738610703e-06
.param x_dut_xm13_m=4
.param x_dut_xm13_w=2.973856479546674e-06
.param x_dut_xm16_l=2.8345445398725867e-06
.param x_dut_xm16_m=4
.param x_dut_xm16_w=1.42164317225128e-06
.param x_dut_xm18_l=6.877294178273821e-07
.param x_dut_xm18_m=4
.param x_dut_xm18_w=2.588437638222415e-06
.param x_dut_xm19_l=2.610327701333222e-06
.param x_dut_xm19_m=4
.param x_dut_xm20_w=2.5993169079035972e-06
.param x_dut_xm24_l=2.3573338427611332e-06
.param x_dut_xm24_m=4
.param x_dut_xm24_w=6.255420156088461e-07
.param x_dut_xm6_l=1.5337011063452708e-06
.param x_dut_xm6_m=4
.param x_dut_xm6_w=1.6264538203401115e-06
.param x_dut_xm10_l=5.285041676119048e-07
.param x_dut_xm10_m=4
.param x_dut_xm10_w=1.1228490677621372e-06
.param RESISTOR_0=92438.64289092096
.param RESISTOR_1=76335.16886584445
.param RESISTOR_2=1034441.999157821
.param RESISTOR_3=78556.82747520377
* ---- GENERATED parameter ties (abstract/params.yaml groups/ratios) ----
* Each tied symbol is defined exactly once, by its line below; rewrite that
* .param to untie just that symbol (untying = shadowing, plan D-3).
.param x_dut_xm7_w = {x_dut_xm6_w}
.param x_dut_xm7_l = {x_dut_xm6_l}
.param x_dut_xm8_w = {x_dut_xm3_w}
.param x_dut_xm5_w = {x_dut_xm3_w}
.param x_dut_xm4_w = {x_dut_xm3_w}
.param x_dut_xm2_w = {x_dut_xm3_w}
.param x_dut_xm1_w = {x_dut_xm3_w}
.param x_dut_xm0_w = {x_dut_xm3_w}
.param x_dut_xm8_l = {x_dut_xm3_l}
.param x_dut_xm5_l = {x_dut_xm3_l}
.param x_dut_xm4_l = {x_dut_xm3_l}
.param x_dut_xm2_l = {x_dut_xm3_l}
.param x_dut_xm1_l = {x_dut_xm3_l}
.param x_dut_xm0_l = {x_dut_xm3_l}
.param x_dut_xm9_w = {x_dut_xm10_w}
.param x_dut_xm9_l = {x_dut_xm10_l}
.param x_dut_xm9_m = {x_dut_xm10_m}
.param x_dut_xm22_w = {x_dut_xm24_w}
.param x_dut_xm23_w = {x_dut_xm24_w}
.param x_dut_xm22_l = {x_dut_xm24_l}
.param x_dut_xm23_l = {x_dut_xm24_l}
.param x_dut_xm17_w = {x_dut_xm16_w}
.param x_dut_xm14_w = {x_dut_xm16_w}
.param x_dut_xm15_w = {x_dut_xm16_w}
.param x_dut_xm17_l = {x_dut_xm16_l}
.param x_dut_xm14_l = {x_dut_xm16_l}
.param x_dut_xm15_l = {x_dut_xm16_l}
.param x_dut_xm17_m = {x_dut_xm16_m}
.param x_dut_xm14_m = {x_dut_xm16_m}
.param x_dut_xm15_m = {x_dut_xm16_m}
.param x_dut_xm20_l = {x_dut_xm19_l}
.param x_dut_xm21_l = {x_dut_xm19_l}
.param x_dut_xm20_m = {x_dut_xm19_m}
.param x_dut_xm21_m = {x_dut_xm19_m}
.param x_dut_xm7_m = {x_dut_xm6_m*2}
.param x_dut_xm3_m = {x_dut_xm5_m*6}
.param x_dut_xm8_m = {x_dut_xm5_m*2}
.param x_dut_xm4_m = {x_dut_xm5_m*1}
.param x_dut_xm2_m = {x_dut_xm5_m*2}
.param x_dut_xm1_m = {x_dut_xm5_m*1}
.param x_dut_xm0_m = {x_dut_xm5_m*1}
.param x_dut_xm22_m = {x_dut_xm24_m*4}
.param x_dut_xm23_m = {x_dut_xm24_m*3}
.param x_dut_xm21_w = {x_dut_xm20_w*1}
.param x_dut_xm19_w = {x_dut_xm20_w*2/7}
.subckt amp_013_qu2017_azc vss vdd vinn vinp vout
C0 net063 VOUT 'CAPACITOR_0'
C1 net051 vss 'CAPACITOR_1'
C2 net043 vss 'CAPACITOR_2'
I0 VB1 vss 'CURRENT_0_BIAS'
R0 net078 net077 'RESISTOR_0'
R1 net078 net082 'RESISTOR_1'
R2 net057 net051 'RESISTOR_2'
R3 net057 net043 'RESISTOR_3'
XM0 VB1 VB1 vdd vdd pfet_03v3 l=x_dut_xm0_l m=x_dut_xm0_m w=x_dut_xm0_w
XM1 VB4 VB1 vdd vdd pfet_03v3 l=x_dut_xm1_l m=x_dut_xm1_m w=x_dut_xm1_w
XM10 net063 VINP net019 net019 pfet_03v3 l=x_dut_xm10_l m=x_dut_xm10_m w=x_dut_xm10_w
XM11 net094 net050 vdd vdd pfet_03v3 l=x_dut_xm11_l m=x_dut_xm11_m w=x_dut_xm11_w
XM12 net055 net094 vss vss nfet_03v3 l=x_dut_xm12_l m=x_dut_xm12_m w=x_dut_xm12_w
XM13 VOUT net050 vdd vdd pfet_03v3 l=x_dut_xm13_l m=x_dut_xm13_m w=x_dut_xm13_w
XM14 VOUTN net077 DM_2 vss nfet_03v3 l=x_dut_xm14_l m=x_dut_xm14_m w=x_dut_xm14_w
XM15 net050 net082 net063 vss nfet_03v3 l=x_dut_xm15_l m=x_dut_xm15_m w=x_dut_xm15_w
XM16 net077 DM_2 vss vss nfet_03v3 l=x_dut_xm16_l m=x_dut_xm16_m w=x_dut_xm16_w
XM17 net082 net063 vss vss nfet_03v3 l=x_dut_xm17_l m=x_dut_xm17_m w=x_dut_xm17_w
XM18 VOUT net049 vss vss nfet_03v3 l=x_dut_xm18_l m=x_dut_xm18_m w=x_dut_xm18_w
XM19 VB4 VB4 vss vss nfet_03v3 l=x_dut_xm19_l m=x_dut_xm19_m w=x_dut_xm19_w
XM2 net019 VB1 vdd vdd pfet_03v3 l=x_dut_xm2_l m=x_dut_xm2_m w=x_dut_xm2_w
XM20 DM_2 VB4 vss vss nfet_03v3 l=x_dut_xm20_l m=x_dut_xm20_m w=x_dut_xm20_w
XM21 net063 VB4 vss vss nfet_03v3 l=x_dut_xm21_l m=x_dut_xm21_m w=x_dut_xm21_w
XM22 net094 net051 vss vss nfet_03v3 l=x_dut_xm22_l m=x_dut_xm22_m w=x_dut_xm22_w
XM23 net057 net043 vss vss nfet_03v3 l=x_dut_xm23_l m=x_dut_xm23_m w=x_dut_xm23_w
XM24 net049 net057 vss vss nfet_03v3 l=x_dut_xm24_l m=x_dut_xm24_m w=x_dut_xm24_w
XM3 net078 VB1 vdd vdd pfet_03v3 l=x_dut_xm3_l m=x_dut_xm3_m w=x_dut_xm3_w
XM4 VOUTN VOUTN vdd vdd pfet_03v3 l=x_dut_xm4_l m=x_dut_xm4_m w=x_dut_xm4_w
XM5 net050 VOUTN vdd vdd pfet_03v3 l=x_dut_xm5_l m=x_dut_xm5_m w=x_dut_xm5_w
XM6 net055 net055 vdd vdd pfet_03v3 l=x_dut_xm6_l m=x_dut_xm6_m w=x_dut_xm6_w
XM7 net057 net055 vdd vdd pfet_03v3 l=x_dut_xm7_l m=x_dut_xm7_m w=x_dut_xm7_w
XM8 net049 VB1 vdd vdd pfet_03v3 l=x_dut_xm8_l m=x_dut_xm8_m w=x_dut_xm8_w
XM9 DM_2 VINN net019 net019 pfet_03v3 l=x_dut_xm9_l m=x_dut_xm9_m w=x_dut_xm9_w
.ends
.end
