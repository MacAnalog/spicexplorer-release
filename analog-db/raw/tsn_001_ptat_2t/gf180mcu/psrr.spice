** GENERATED by `analog-db export-raw` — DO NOT EDIT.
** circuit=tsn_001_ptat_2t  class=temp_sensor  pdk=gf180mcu  testbench=psrr  corner=tt
** Self-contained deck: testbench + bound params + lowered DUT (.subckt tsn_001_ptat_2t).
** PDK corner libs resolve by BARE NAME on the image's ngspice sourcepath — run in a
** PDK-enabled env (the base image / api container), NOT a bare host:
**   docker run --rm -i spicexplorer-spice-base:local \
**     bash -lc 'd=$(mktemp -d) && cat > $d/c.spice && cd $d && ngspice -b c.spice' < raw/tsn_001_ptat_2t/gf180mcu/psrr.spice
*----------------------------------------------------------*
** params: 6 free + 0 frozen knobs (sizing.yaml) · 0 tied · 0 ratio-derived (abstract/params.yaml) · 1 testbench params
** AUTHORED TEMPLATE — temp_sensor/psrr (plan D-4): low-frequency supply rejection (PSR) of a
** PTAT sensor. Drives the supply with a 1 V AC and reports the supply→output gain at the low
** frequency edge (dB; more-negative = better rejection).
** Bindings: DUT PORT_LINE VDD, FSTART FSTOP PPD, PDK_INCLUDE.
.include design.ngspice
.lib sm141064.ngspice noise_corner
.lib sm141064.ngspice nfet_03v3_t
.lib sm141064.ngspice pfet_03v3_t
.lib sm141064.ngspice fets_mm
.lib sm141064.ngspice res_typical
.lib sm141064.ngspice mimcap_typical
.lib sm141064.ngspice cap_mim
.temp 27

.param VDD=1.2

Vdd  vdd 0 dc {VDD} ac 1
Vss  vss 0 dc 0

XDUT vdd vout vss tsn_001_ptat_2t

.control
  set filetype=ascii
  ac dec 10 10 10meg
  meas ac psr_db FIND vdb(vout) AT=10
  write
  quit
.endc
.param x_dut_xm0_w=8u
.param x_dut_xm0_l=0.28u
.param x_dut_xm0_m=8
.param x_dut_xm1_w=4u
.param x_dut_xm1_l=1u
.param x_dut_xm1_m=8
.subckt tsn_001_ptat_2t vdd vout vss
XM0 vdd vout vout vss nfet_03v3 l=x_dut_xm0_l m=x_dut_xm0_m w=x_dut_xm0_w
XM1 vout vout vss vss nfet_03v3 l=x_dut_xm1_l m=x_dut_xm1_m w=x_dut_xm1_w
.ends
.end
