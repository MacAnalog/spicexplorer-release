** GENERATED by `analog-db export-raw` — DO NOT EDIT.
** circuit=amp_034_fan_chopper_cmfb  class=amplifier  pdk=ihp-sg13g2  testbench=stb  corner=tt
** Self-contained deck: testbench + bound params + lowered DUT (.subckt amp_034_fan_chopper_cmfb).
** PDK corner libs resolve by BARE NAME on the image's ngspice sourcepath — run in a
** PDK-enabled env (the base image / api container), NOT a bare host:
**   docker run --rm -i spicexplorer-spice-base:local \
**     bash -lc 'd=$(mktemp -d) && cat > $d/c.spice && cd $d && ngspice -b c.spice' < raw/amp_034_fan_chopper_cmfb/ihp-sg13g2/stb.spice
*----------------------------------------------------------*
** params: 36 free + 15 frozen knobs (sizing.yaml) · 49 tied · 0 ratio-derived (abstract/params.yaml) · 3 testbench params
** AUTHORED TEMPLATE — amplifier/stb_diff: TRUE loop gain, phase margin and gain margin of the
** DIFFERENTIAL loop of a fully-differential (self-biased, voutp/voutn) DUT, by antiphase
** Middlebrook voltage injection at the VIPRB/VIPRBM loop-break markers.
**
** WHY A _diff VARIANT EXISTS. The SE stb bench closes vinn <- vout with one wire and injects at
** that break. An FD cell has no single output to close on. tran_step_diff's single-wire trick
** (vinn <- voutp) DOES close a loop, but its transmission is only Add/2, mixed with whatever
** CM->DM cross terms the cell has, and its DC point drags the input CM to the output CM — so a
** probe of THAT loop would neither match ac_open_loop_diff's pm_deg nor share its operating
** point, and the crosscheck between the two independent routes would be meaningless.
**
** THE CLOSED LOOP USED HERE — differential unity feedback with the common mode PINNED:
**     Efbn: fbn = VCM + (voutp-voutn)/2        Efbp: fbp = VCM - (voutp-voutn)/2
**     vinn <- fbn,  vinp <- fbp   (through the 0 V markers)
** so vin_d = vinp - vinn = -(voutp-voutn): full differential unity feedback, loop transmission
** EXACTLY Add (the differential gain — the same complex function whose magnitude/phase
** ac_open_loop_diff sweeps), with ZERO common-mode content in the feedback path: the input CM
** sits at VCM by construction and the output CM is left entirely to the DUT's own CMFB. That
** buys three things at once:
**   1. the DC operating point is the matched-inputs-at-VCM point that dc_op_diff /
**      ac_open_loop_diff / noise_diff all use (the loop nulls vout_d to the residual offset,
**      and the E-sources return exactly VCM +/- vout_d/2 ~= VCM), so this bench works on every
**      FD cell those benches work on — REGARDLESS of CMFB quality, because no CM loop is closed
**      or disturbed by the bench itself (small-signal: only the OP must exist);
**   2. pm_loop here and ac_open_loop_diff's pm_deg measure the same loop at the same OP, so
**      they crosscheck each other to within the phase-reference convention (measured on the
**      pilots: agreement to well under a degree);
**   3. no CM positive-feedback hazard: a raw cross-coupled wire pair (vinn<-voutp, vinp<-voutn)
**      would also tie input CM to output CM and could latch a cell whose input-CM -> output-CM
**      gain exceeds unity. The VCVS sense feeds back the DIFFERENCE only.
** The VCVSs are ideal: they load voutp/voutn with infinite impedance and drive the (purely
** capacitive) input gates with zero source impedance through the markers — so Middlebrook's
** single-injection impedance condition (low-Z source side, high-Z load side at the break) is
** satisfied by construction, even better than in the SE bench.
**
** INJECTION MATH (exact, same algebra as stb.spice). The markers are plain 0 V sources in the
** netlist; only this deck's .control alters them into an ANTIPHASE pair (+0.5 / -0.5), forcing
** exactly 1 V of differential break:  vinn = fbn + 0.5,  vinp = fbp - 0.5. With vout_d =
** Add*vin_d (vin_c is AC-quiet, so no Adc term survives):
**     vin_d = -vout_d - 1  =>  vin_d = -1/(1+Add),  vout_d = -Add/(1+Add)
**     =>  tloop = vout_d/vin_d = Add   identically.
** NOTE the DC sign: the SE bench's T = v(vout)/v(vinn) = -A carries the loop inversion (DC
** phase +/-180); here tloop = +Add is positive real at DC (phase 0). Both are handled by the
** same snapped phase reference below — ph0 lands on 0 here instead of +/-180, and
** tph = 180 + tphc - ph0 still starts at 180, so pm_loop keeps the usual "180 minus total lag"
** meaning and is directly comparable to ac_open_loop_diff's pm (which normalises 180 + phc -
** phc[0]). A cell wired with INVERTED differential polarity would make this bench positive
** feedback at DC and rail — same standing assumption the SE stb makes about its buffer.
**
** SPECTRE LANE (unlike stb.spice, NOT wired). The SE bench's VIPRB marker maps to a single
** `iprobe` for `stb stb probe=VIPRB`. This differential loop is broken in TWO places and a
** single iprobe on one wire measures a different (single-wire) loop; Spectre's native answer is
** a diffstbprobe pair, and no spectre-benches.yaml entry exists for stb_diff yet — this bench
** is ngspice-only until that mapping is decided. The markers still cost nothing in any other
** analysis (0 V sources with no AC spec are ideal wires).
**
** MEASURES + SENTINEL DISCIPLINE — copied verbatim from stb.spice; see THAT header for the
** full derivations and the measured tables (phase-reference snap + the branch-change guard at
** |phref_dev| = 30 deg; LAST-crossing pm / FIRST-crossing gm convention and why first-crossing
** pm certifies unstable loops; the -999 seeds and why a seed must never look like a reading;
** why the sentinel is NEGATIVE: ppa._spec_verdict only fails value<min / value>max, so a +999
** PASSES every min-bound margin spec silently while -999 fails it, which is the honest verdict).
**   loopgain_db   |T| in dB read AT FSTART (unguarded; low by 20*log10(cos(phref_dev)))
**   ugf_loop      last |T|=1 crossing; FSTOP = |T|>1 everywhere, 0 = never reaches unity
**   pm_loop       tph at the LAST |T|=1 crossing; -999 = no crossing or guard tripped
**   gm_loop       -|T|dB at the FIRST tph=0 crossing; -999 = no crossing or guard tripped
**   pm_loop_first tph at the FIRST |T|=1 crossing; != pm_loop flags multiple crossings
**   phref_dev     loop lag already present at FSTART (deg); phref_ok = |phref_dev| <= 30
** CHOOSING FSTART: same rule as stb.spice — well below the dominant pole so |phref_dev| stays
** small; the SE corpus class value FSTART=0.01 Hz clears the guard everywhere and is the right
** default here too (the FD pilots sit orders of magnitude inside it).
**
** NGSPICE PARSER GOTCHA — no `>` inside `let` (stripped as output redirection, silently
** truncates the RHS). All masks are `<=` inverted with `1 - mask`.
**
** Bindings: DUT PORT_LINE VDD VCM CL FSTART FSTOP PPD PDK_INCLUDE.
.lib cornerMOSlv.lib mos_tt
.temp 27

.param VDD=1.2
.param VCM=0.6
.param CL=10p

Vdd  vdd 0 dc {VDD}
Vss  vss 0 dc 0
CLoadp voutp 0 {CL}
CLoadn voutn 0 {CL}

* differential unity feedback, CM pinned at VCM (see header): fbn/fbp = VCM +/- vodm/2.
* Ideal VCVS sense — no loading on the outputs, zero source impedance into the gates.
Vcm  vcm 0 dc {VCM}
Efbn fbn vcm voutp voutn 0.5
Efbp fbp vcm voutp voutn -0.5

* loop-break markers: plain 0 V sources (= ideal wires to every other analysis); only this
* deck's .control turns them into the antiphase injection pair.
VIPRB  vinn fbn dc 0
VIPRBM vinp fbp dc 0

XDUT vinp vinn voutp voutn vdd vss amp_034_fan_chopper_cmfb

.control
  set filetype=ascii
  * break the loop: the marker pair becomes an ANTIPHASE +/-0.5 V generator, forcing exactly
  * 1 V of differential break (vinn-fbn) - (vinp-fbp) = 1. Nothing else in the bench carries AC.
  alter @VIPRB[acmag] = 0.5
  alter @VIPRBM[acmag] = -0.5
  ac dec 101 1e-4 1G

  let tloop = (v(voutp)-v(voutn))/(v(vinp)-v(vinn))
  let tdb   = db(tloop)
  let ntdb  = 0 - tdb
  let f     = real(frequency)
  let tphc  = cph(tloop)*180/3.14159265
  * snap the DC phase reference to the exact 0/+-180 the loop must have at DC (here tloop = +Add
  * so ph0 lands on 0; the snap keeps the idiom identical to stb.spice)
  let ph0   = 180*floor(tphc[0]/180 + 0.5)
  let phref_dev = tphc[0] - ph0

  * PHASE-REFERENCE GUARD (see stb.spice). |phref_dev| <= 90 by construction, branch changes at
  * 90; below 30 deg the branch is unique with 60 deg to spare, at/above it the deck refuses to
  * pick one and blanks the phase vector to the sentinel.
  let phref_ok  = (abs(phref_dev) <= 30)
  let phref_bad = 1 - phref_ok
  let tph = (180 + tphc - ph0)*phref_ok + (-999)*phref_bad

  * mask (no `>` — see the parser gotcha in the header)
  let mb = (tdb <= 0)
  let ma = 1 - mb

  * seeds. ugf_loop's reduction is itself information (FSTOP = |T| > 1 everywhere, 0 = never
  * reaches unity). The margins get the bare sentinel: a seed must never look like a reading.
  let loopgain_db   = tdb[0]
  let ugf_loop      = maximum(f*ma)
  let pm_loop       = -999
  let gm_loop       = -999
  let pm_loop_first = -999

  * interpolated refinements; each silently leaves its seed in place if it finds no crossing
  meas ac loopgain_db FIND tdb  AT=1e-4
  meas ac ugf_loop    WHEN tdb=0 FALL=LAST
  meas ac pm_loop     FIND tph  WHEN tdb=0 FALL=LAST
  meas ac gm_loop     FIND ntdb WHEN tph=0 FALL=1
  meas ac pm_loop_first FIND tph WHEN tdb=0 FALL=1

  print loopgain_db ugf_loop pm_loop gm_loop pm_loop_first phref_dev phref_ok
  write
  quit
.endc
.param x_dut_xm4_cmfb_w=1.42u
.param x_dut_xm4_cmfb_l=0.27u
.param x_dut_xm2_cmfb_w=2.32u
.param x_dut_xm2_cmfb_l=1.31u
.param x_dut_xm1_cmfb_w=0.329u
.param x_dut_xm7_cmfb_w=0.293u
.param x_dut_xm7_cmfb_l=0.22u
.param x_dut_xm3_cmfb_w=0.881u
.param x_dut_xm3_cmfb_l=0.259u
.param x_dut_rmp_cmfb_value=1Meg
.param x_dut_xm1_cmfb_m=1
.param x_dut_xm2_cmfb_m=1
.param x_dut_xm3_cmfb_m=1
.param x_dut_xm4_cmfb_m=1
.param x_dut_xm7_cmfb_m=1
.param x_dut_xm1_core_w=20u
.param x_dut_xm1_core_l=1u
.param x_dut_xm2_core_w=20u
.param x_dut_xm2_core_l=0.5u
.param x_dut_xm4_core_w=10u
.param x_dut_xm4_core_l=1u
.param x_dut_xm6_core_w=10u
.param x_dut_xm10_core_w=10u
.param x_dut_xm10_core_l=0.3u
.param x_dut_xm12_core_w=5u
.param x_dut_xm12_core_l=0.3u
.param x_dut_xm14_core_w=20u
.param x_dut_xm14_core_l=0.25u
.param x_dut_xm16_core_w=2u
.param x_dut_xm16_core_l=0.13u
.param x_dut_xm17_core_w=2u
.param x_dut_xm17_core_l=0.13u
.param x_dut_cm1_core_value=6p
.param vb1_core=0.3983759766
.param vb2_core=0.65
.param vb3_core=0.45
.param vb4_core=0.55
.param x_dut_xm1_core_m=1
.param x_dut_xm2_core_m=1
.param x_dut_xm4_core_m=1
.param x_dut_xm6_core_m=1
.param x_dut_xm10_core_m=1
.param x_dut_xm12_core_m=1
.param x_dut_xm14_core_m=1
.param x_dut_xm16_core_m=1
.param x_dut_xm17_core_m=1
.param vcm_ref=0.5
.param x_dut_xm8o_w=20u
.param x_dut_xm8o_l=1u
.param x_dut_xm8o_m=1
.param c_cm=1f
* ---- GENERATED parameter ties (abstract/params.yaml groups/ratios) ----
* Each tied symbol is defined exactly once, by its line below; rewrite that
* .param to untie just that symbol (untying = shadowing, plan D-3).
.param x_dut_xm9o_w = {x_dut_xm8o_w}
.param x_dut_xm9o_l = {x_dut_xm8o_l}
.param x_dut_xm9o_m = {x_dut_xm8o_m}
.param x_dut_xm5_cmfb_w = {x_dut_xm4_cmfb_w}
.param x_dut_xm5_cmfb_l = {x_dut_xm4_cmfb_l}
.param x_dut_xm5_cmfb_m = {x_dut_xm4_cmfb_m}
.param x_dut_xm6_cmfb_w = {x_dut_xm2_cmfb_w}
.param x_dut_xm6_cmfb_l = {x_dut_xm2_cmfb_l}
.param x_dut_xm6_cmfb_m = {x_dut_xm2_cmfb_m}
.param x_dut_rmn_cmfb_value = {x_dut_rmp_cmfb_value}
.param x_dut_xm3_core_w = {x_dut_xm2_core_w}
.param x_dut_xm3_core_l = {x_dut_xm2_core_l}
.param x_dut_xm3_core_m = {x_dut_xm2_core_m}
.param x_dut_xm5_core_w = {x_dut_xm4_core_w}
.param x_dut_xm5_core_l = {x_dut_xm4_core_l}
.param x_dut_xm5_core_m = {x_dut_xm4_core_m}
.param x_dut_xm13_core_w = {x_dut_xm12_core_w}
.param x_dut_xm13_core_l = {x_dut_xm12_core_l}
.param x_dut_xm13_core_m = {x_dut_xm12_core_m}
.param x_dut_xm11_core_w = {x_dut_xm10_core_w}
.param x_dut_xm11_core_l = {x_dut_xm10_core_l}
.param x_dut_xm11_core_m = {x_dut_xm10_core_m}
.param x_dut_xm7_core_w = {x_dut_xm6_core_w}
.param x_dut_xm7_core_m = {x_dut_xm6_core_m}
.param x_dut_xm6_core_l = {x_dut_xm1_core_l}
.param x_dut_xm7_core_l = {x_dut_xm1_core_l}
.param x_dut_xm15_core_w = {x_dut_xm14_core_w}
.param x_dut_xm15_core_l = {x_dut_xm14_core_l}
.param x_dut_xm15_core_m = {x_dut_xm14_core_m}
.param x_dut_xm18_core_w = {x_dut_xm16_core_w}
.param x_dut_xm20_core_w = {x_dut_xm16_core_w}
.param x_dut_xm22_core_w = {x_dut_xm16_core_w}
.param x_dut_xm18_core_l = {x_dut_xm16_core_l}
.param x_dut_xm20_core_l = {x_dut_xm16_core_l}
.param x_dut_xm22_core_l = {x_dut_xm16_core_l}
.param x_dut_xm18_core_m = {x_dut_xm16_core_m}
.param x_dut_xm20_core_m = {x_dut_xm16_core_m}
.param x_dut_xm22_core_m = {x_dut_xm16_core_m}
.param x_dut_xm19_core_w = {x_dut_xm17_core_w}
.param x_dut_xm21_core_w = {x_dut_xm17_core_w}
.param x_dut_xm23_core_w = {x_dut_xm17_core_w}
.param x_dut_xm19_core_l = {x_dut_xm17_core_l}
.param x_dut_xm21_core_l = {x_dut_xm17_core_l}
.param x_dut_xm23_core_l = {x_dut_xm17_core_l}
.param x_dut_xm19_core_m = {x_dut_xm17_core_m}
.param x_dut_xm21_core_m = {x_dut_xm17_core_m}
.param x_dut_xm23_core_m = {x_dut_xm17_core_m}
.param x_dut_cm2_core_value = {x_dut_cm1_core_value}
.param x_dut_xm1_cmfb_l = {x_dut_xm3_cmfb_l}
.param x_dut_xm20_core_w = {x_dut_xm16_core_w}
.param x_dut_xm20_core_l = {x_dut_xm16_core_l}
.param x_dut_xm20_core_m = {x_dut_xm16_core_m}
.param x_dut_xm23_core_w = {x_dut_xm17_core_w}
.param x_dut_xm23_core_l = {x_dut_xm17_core_l}
.param x_dut_xm23_core_m = {x_dut_xm17_core_m}
.param x_dut_xm22_core_w = {x_dut_xm18_core_w}
.param x_dut_xm22_core_l = {x_dut_xm18_core_l}
.param x_dut_xm22_core_m = {x_dut_xm18_core_m}
.param x_dut_xm21_core_w = {x_dut_xm19_core_w}
.param x_dut_xm21_core_l = {x_dut_xm19_core_l}
.param x_dut_xm21_core_m = {x_dut_xm19_core_m}
.subckt amp_034_fan_chopper_cmfb vinp vinn voutp voutn vdd vss
CCM vb4o vss 'c_cm'
CM1_CORE core__g2_p voutp 'x_dut_cm1_core_value'
CM2_CORE core__g2_n voutn 'x_dut_cm2_core_value'
RMN_CMFB voutn cmfb__cm_sense 'x_dut_rmn_cmfb_value'
RMP_CMFB cmfb__cm_sense voutp 'x_dut_rmp_cmfb_value'
VB1_CORE core__vb1 vss dc {vb1_core}
VB2_CORE core__vb2 vss dc {vb2_core}
VB3_CORE core__vb3 vss dc {vb3_core}
VB4_CORE core__vb4 vss dc {vb4_core}
VREFCM vref_cm vss dc {vcm_ref}
XM10_CORE core__out1_n core__vb3 core__casc_src_n vdd sg13_lv_pmos l=x_dut_xm10_core_l m=x_dut_xm10_core_m w=x_dut_xm10_core_w
XM11_CORE core__out1_p core__vb3 core__casc_src_p vdd sg13_lv_pmos l=x_dut_xm11_core_l m=x_dut_xm11_core_m w=x_dut_xm11_core_w
XM12_CORE core__out1_p core__vb2 core__fold_p vss sg13_lv_nmos l=x_dut_xm12_core_l m=x_dut_xm12_core_m w=x_dut_xm12_core_w
XM13_CORE core__out1_n core__vb2 core__fold_n vss sg13_lv_nmos l=x_dut_xm13_core_l m=x_dut_xm13_core_m w=x_dut_xm13_core_w
XM14_CORE voutp core__g2_p vss vss sg13_lv_nmos l=x_dut_xm14_core_l m=x_dut_xm14_core_m w=x_dut_xm14_core_w
XM15_CORE voutn core__g2_n vss vss sg13_lv_nmos l=x_dut_xm15_core_l m=x_dut_xm15_core_m w=x_dut_xm15_core_w
XM16_CORE core__out1_n vdd core__g2_n vss sg13_lv_nmos l=x_dut_xm16_core_l m=x_dut_xm16_core_m w=x_dut_xm16_core_w
XM17_CORE core__g2_n vss core__out1_n vdd sg13_lv_pmos l=x_dut_xm17_core_l m=x_dut_xm17_core_m w=x_dut_xm17_core_w
XM18_CORE core__out1_p vdd core__g2_p vss sg13_lv_nmos l=x_dut_xm18_core_l m=x_dut_xm18_core_m w=x_dut_xm18_core_w
XM19_CORE core__g2_p vss core__out1_p vdd sg13_lv_pmos l=x_dut_xm19_core_l m=x_dut_xm19_core_m w=x_dut_xm19_core_w
XM1_CMFB cmfb__ptail cmfb__bias vdd vdd sg13_lv_pmos l=x_dut_xm1_cmfb_l m=x_dut_xm1_cmfb_m w=x_dut_xm1_cmfb_w
XM1_CORE core__tail core__vb4 vdd vdd sg13_lv_pmos l=x_dut_xm1_core_l m=x_dut_xm1_core_m w=x_dut_xm1_core_w
XM20_CORE core__out1_p vss core__g2_n vss sg13_lv_nmos l=x_dut_xm20_core_l m=x_dut_xm20_core_m w=x_dut_xm20_core_w
XM21_CORE core__g2_n vdd core__out1_p vdd sg13_lv_pmos l=x_dut_xm21_core_l m=x_dut_xm21_core_m w=x_dut_xm21_core_w
XM22_CORE core__out1_n vss core__g2_p vss sg13_lv_nmos l=x_dut_xm22_core_l m=x_dut_xm22_core_m w=x_dut_xm22_core_w
XM23_CORE core__g2_p vdd core__out1_n vdd sg13_lv_pmos l=x_dut_xm23_core_l m=x_dut_xm23_core_m w=x_dut_xm23_core_w
XM2_CMFB vb4o cmfb__mirr vss vss sg13_lv_nmos l=x_dut_xm2_cmfb_l m=x_dut_xm2_cmfb_m w=x_dut_xm2_cmfb_w
XM2_CORE core__fold_p vinp core__tail vdd sg13_lv_pmos l=x_dut_xm2_core_l m=x_dut_xm2_core_m w=x_dut_xm2_core_w
XM3_CMFB cmfb__bias cmfb__bias vdd vdd sg13_lv_pmos l=x_dut_xm3_cmfb_l m=x_dut_xm3_cmfb_m w=x_dut_xm3_cmfb_w
XM3_CORE core__fold_n vinn core__tail vdd sg13_lv_pmos l=x_dut_xm3_core_l m=x_dut_xm3_core_m w=x_dut_xm3_core_w
XM4_CMFB cmfb__mirr cmfb__cm_sense cmfb__ptail vdd sg13_lv_pmos l=x_dut_xm4_cmfb_l m=x_dut_xm4_cmfb_m w=x_dut_xm4_cmfb_w
XM4_CORE core__fold_p core__vb1 vss vss sg13_lv_nmos l=x_dut_xm4_core_l m=x_dut_xm4_core_m w=x_dut_xm4_core_w
XM5_CMFB vb4o vref_cm cmfb__ptail vdd sg13_lv_pmos l=x_dut_xm5_cmfb_l m=x_dut_xm5_cmfb_m w=x_dut_xm5_cmfb_w
XM5_CORE core__fold_n core__vb1 vss vss sg13_lv_nmos l=x_dut_xm5_core_l m=x_dut_xm5_core_m w=x_dut_xm5_core_w
XM6_CMFB cmfb__mirr cmfb__mirr vss vss sg13_lv_nmos l=x_dut_xm6_cmfb_l m=x_dut_xm6_cmfb_m w=x_dut_xm6_cmfb_w
XM6_CORE core__casc_src_n core__vb4 vdd vdd sg13_lv_pmos l=x_dut_xm6_core_l m=x_dut_xm6_core_m w=x_dut_xm6_core_w
XM7_CMFB cmfb__bias cmfb__bias vss vss sg13_lv_nmos l=x_dut_xm7_cmfb_l m=x_dut_xm7_cmfb_m w=x_dut_xm7_cmfb_w
XM7_CORE core__casc_src_p core__vb4 vdd vdd sg13_lv_pmos l=x_dut_xm7_core_l m=x_dut_xm7_core_m w=x_dut_xm7_core_w
XM8O voutp vb4o vdd vdd sg13_lv_pmos l=x_dut_xm8o_l m=x_dut_xm8o_m w=x_dut_xm8o_w
XM9O voutn vb4o vdd vdd sg13_lv_pmos l=x_dut_xm9o_l m=x_dut_xm9o_m w=x_dut_xm9o_w
.ends
.end
