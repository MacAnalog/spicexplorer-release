** GENERATED by `analog-db export-raw` — DO NOT EDIT.
** Standalone lowered DUT subckt for adc_001_inv1b on ihp-sg13g2 (sizing .param defaults + .subckt).
** Not a runnable deck on its own — include it under your own testbench:
**   .include _dut.spice
**   XDUT vdd vin vout vss adc_001_inv1b
** Source: pdk/ihp-sg13g2/netlist.spice (run `analog-db generate` to refresh).
*----------------------------------------------------------*
** params: 6 free + 0 frozen knobs (sizing.yaml) · 0 tied · 0 ratio-derived (abstract/params.yaml)
.param x_dut_xmn_w=1.0u
.param x_dut_xmn_l=0.13u
.param x_dut_xmn_m=1
.param x_dut_xmp_w=2.5u
.param x_dut_xmp_l=0.13u
.param x_dut_xmp_m=1
.subckt adc_001_inv1b vdd vin vout vss
XMN vout vin vss vss sg13_lv_nmos l=x_dut_xmn_l m=x_dut_xmn_m w=x_dut_xmn_w
XMP vout vin vdd vdd sg13_lv_pmos l=x_dut_xmp_l m=x_dut_xmp_m w=x_dut_xmp_w
.ends
