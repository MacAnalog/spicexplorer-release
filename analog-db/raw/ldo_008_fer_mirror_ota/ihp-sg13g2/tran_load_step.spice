** GENERATED by `analog-db export-raw` — DO NOT EDIT.
** circuit=ldo_008_fer_mirror_ota  class=ldo  pdk=ihp-sg13g2  testbench=tran_load_step  corner=tt
** Self-contained deck: testbench + bound params + lowered DUT (.subckt ldo_008_fer_mirror_ota).
** PDK corner libs resolve by BARE NAME on the image's ngspice sourcepath — run in a
** PDK-enabled env (the base image / api container), NOT a bare host:
**   docker run --rm -i spicexplorer-spice-base:local \
**     bash -lc 'd=$(mktemp -d) && cat > $d/c.spice && cd $d && ngspice -b c.spice' < raw/ldo_008_fer_mirror_ota/ihp-sg13g2/tran_load_step.spice
*----------------------------------------------------------*
** params: 11 free + 9 frozen knobs (sizing.yaml) · 7 tied · 0 ratio-derived (abstract/params.yaml) · 1 testbench params
** AUTHORED TEMPLATE — ldo/tran_load_step: fast lo->hi load step into Cout; undershoot + recovery.
** Bindings: DUT PORT_LINE VDD COUT ILOAD_LO ILOAD_HI TSTART TEDGE TPULSE TPER TSTEP TSTOP VTOL
**   PDK_INCLUDE.
.lib cornerMOSlv.lib mos_tt
.temp 27

.param VDD=1.8

Vdd  vdd 0 dc {VDD}
Vss  vss 0 dc 0
CLoad vout 0 1u
Iload vout 0 pulse(1m 10m 5u 10n 10n 20u 40u)

XDUT vdd vout vss ldo_008_fer_mirror_ota

.control
  set filetype=ascii
  tran 50n 30u
  meas tran vout_min  MIN  v(vout) from=5u to=30u
  meas tran vout_post FIND v(vout) AT=30u
  let v_undershoot = vout_post - vout_min
  * recovery: time after the step for v(vout) to re-enter the +/-VTOL band around its final value
  let verr = abs(v(vout) - vout_post)
  meas tran tcross WHEN verr=1m FALL=LAST
  let t_transient = tcross - 5u
  print v_undershoot t_transient
  write
  quit
.endc
.param x_dut_xmnb_w=8u
.param x_dut_xmnb_l=0.5u
.param x_dut_xmdr_w=6u
.param x_dut_xmdr_l=0.3u
.param x_dut_xmld_w=8u
.param x_dut_xmld_l=0.5u
.param x_dut_xmp_w=8u
.param x_dut_xmp_l=0.2u
.param x_rcomp=2000
.param x_ccomp=160e-12
.param x_dut_rt_value=9000
.param x_vref_val=0.6
.param x_ibias_val=20e-6
.param x_dut_xmnb_m=1
.param x_dut_xmnt_m=4
.param x_dut_xmdr_m=4
.param x_dut_xmdf_m=4
.param x_dut_xmld_m=4
.param x_dut_xmlm_m=4
.param x_dut_xmp_m=60
* ---- GENERATED parameter ties (abstract/params.yaml groups/ratios) ----
* Each tied symbol is defined exactly once, by its line below; rewrite that
* .param to untie just that symbol (untying = shadowing, plan D-3).
.param x_dut_xmnt_w = {x_dut_xmnb_w}
.param x_dut_xmnt_l = {x_dut_xmnb_l}
.param x_dut_xmdf_w = {x_dut_xmdr_w}
.param x_dut_xmdf_l = {x_dut_xmdr_l}
.param x_dut_xmlm_w = {x_dut_xmld_w}
.param x_dut_xmlm_l = {x_dut_xmld_l}
.param x_dut_rb_value = {x_dut_rt_value}
.subckt ldo_008_fer_mirror_ota vdd vout vss
CC czero vout x_ccomp
IBI vdd nbias dc {x_ibias_val}
RB fb vss x_dut_rb_value
RC egate czero x_rcomp
RT lp_brk fb x_dut_rt_value
VLP lp_brk vout dc 0
VREF vref vss dc {x_vref_val}
XMDF ldiode fb tail vss sg13_lv_nmos l=x_dut_xmdf_l m=x_dut_xmdf_m w=x_dut_xmdf_w
XMDR egate vref tail vss sg13_lv_nmos l=x_dut_xmdr_l m=x_dut_xmdr_m w=x_dut_xmdr_w
XMLD ldiode ldiode vdd vdd sg13_lv_pmos l=x_dut_xmld_l m=x_dut_xmld_m w=x_dut_xmld_w
XMLM egate ldiode vdd vdd sg13_lv_pmos l=x_dut_xmlm_l m=x_dut_xmlm_m w=x_dut_xmlm_w
XMNB nbias nbias vss vss sg13_lv_nmos l=x_dut_xmnb_l m=x_dut_xmnb_m w=x_dut_xmnb_w
XMNT tail nbias vss vss sg13_lv_nmos l=x_dut_xmnt_l m=x_dut_xmnt_m w=x_dut_xmnt_w
XMP vout egate vdd vdd sg13_lv_pmos l=x_dut_xmp_l m=x_dut_xmp_m w=x_dut_xmp_w
.ends
.end
