** AUTHORED TEMPLATE — filter/dc_op: DC operating point + supply current of a filter.
** [SKELETON - NOT VALIDATED, 2026-07-15]: well-formed but not yet exercised against a real DUT;
** forward scaffolding for a future open-PDK promotion of this class. Develop + validate the meas
** blocks and add the class metric reader then. See _shared/classes/TODO_new_class_testbenches.md
** Biases the input at the common mode and reports the static supply draw and output level.
** Port convention: vdd vin vout vss. Bindings: DUT PORT_LINE VDD VCM PDK_INCLUDE.
${PDK_INCLUDE}

.param VDD=${VDD}
.param VCM=${VCM}

Vdd vdd 0 dc {VDD}
Vss vss 0 dc 0
Vin vin 0 dc {VCM}

${PORT_LINE} ${DUT}

.control
  set filetype=ascii
  op
  let i_supply = abs(i(Vdd))
  let v_out = v(vout)
  print i_supply v_out
  write
  quit
.endc
.end
