** GENERATED by `analog-db export-raw` — DO NOT EDIT.
** Standalone lowered DUT subckt for cmfb_003_5t_nmos_input on gf180mcu (sizing .param defaults + .subckt).
** Not a runnable deck on its own — include it under your own testbench:
**   .include _dut.spice
**   XDUT vinp vinn vcmfb vref vdd vss cmfb_003_5t_nmos_input
** Source: pdk/gf180mcu/netlist.spice (run `analog-db generate` to refresh).
*----------------------------------------------------------*
** params: 11 free + 5 frozen knobs (sizing.yaml) · 7 tied · 0 ratio-derived (abstract/params.yaml)
.param x_dut_xm1_w=10u
.param x_dut_xm1_l=1u
.param x_dut_xm3_w=42u
.param x_dut_xm3_l=2u
.param x_dut_xm8_w=13u
.param x_dut_xm8_l=1u
.param x_dut_xm5_w=6.5u
.param x_dut_xm5_l=1u
.param x_dut_xm6_w=1u
.param x_dut_xm6_l=2u
.param x_dut_rmp_value=5Meg
.param x_dut_xm1_m=1
.param x_dut_xm3_m=1
.param x_dut_xm5_m=1
.param x_dut_xm6_m=1
.param x_dut_xm8_m=1
* ---- GENERATED parameter ties (abstract/params.yaml groups/ratios) ----
* Each tied symbol is defined exactly once, by its line below; rewrite that
* .param to untie just that symbol (untying = shadowing, plan D-3).
.param x_dut_xm2_w = {x_dut_xm1_w}
.param x_dut_xm2_l = {x_dut_xm1_l}
.param x_dut_xm2_m = {x_dut_xm1_m}
.param x_dut_xm4_w = {x_dut_xm3_w}
.param x_dut_xm4_l = {x_dut_xm3_l}
.param x_dut_xm4_m = {x_dut_xm3_m}
.param x_dut_rmn_value = {x_dut_rmp_value}
.subckt cmfb_003_5t_nmos_input vinp vinn vcmfb vref vdd vss
RMN vinn cm_sense 'x_dut_rmn_value'
RMP cm_sense vinp 'x_dut_rmp_value'
XM1 mirr cm_sense ntail vss nfet_03v3 l=x_dut_xm1_l m=x_dut_xm1_m w=x_dut_xm1_w
XM2 vcmfb vref ntail vss nfet_03v3 l=x_dut_xm2_l m=x_dut_xm2_m w=x_dut_xm2_w
XM3 mirr mirr vdd vdd pfet_03v3 l=x_dut_xm3_l m=x_dut_xm3_m w=x_dut_xm3_w
XM4 vcmfb mirr vdd vdd pfet_03v3 l=x_dut_xm4_l m=x_dut_xm4_m w=x_dut_xm4_w
XM5 bias bias vss vss nfet_03v3 l=x_dut_xm5_l m=x_dut_xm5_m w=x_dut_xm5_w
XM6 bias bias vdd vdd pfet_03v3 l=x_dut_xm6_l m=x_dut_xm6_m w=x_dut_xm6_w
XM8 ntail bias vss vss nfet_03v3 l=x_dut_xm8_l m=x_dut_xm8_m w=x_dut_xm8_w
.ends
