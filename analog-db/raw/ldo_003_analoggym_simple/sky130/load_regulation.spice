** GENERATED by `analog-db export-raw` — DO NOT EDIT.
** circuit=ldo_003_analoggym_simple  class=ldo  pdk=sky130  testbench=load_regulation  corner=tt
** Self-contained deck: testbench + bound params + lowered DUT (.subckt ldo_003_analoggym_simple).
** PDK corner libs resolve by BARE NAME on the image's ngspice sourcepath — run in a
** PDK-enabled env (the base image / api container), NOT a bare host:
**   docker run --rm -i spicexplorer-spice-base:local \
**     bash -lc 'd=$(mktemp -d) && cat > $d/c.spice && cd $d && ngspice -b c.spice' < raw/ldo_003_analoggym_simple/sky130/load_regulation.spice
*----------------------------------------------------------*
** params: 14 free + 0 frozen knobs (sizing.yaml) · 4 tied · 0 ratio-derived (abstract/params.yaml) · 1 testbench params
** AUTHORED TEMPLATE — ldo/load_regulation (plan D-10 STUB).
** Placeholder: DC load sweep measuring delta-vout per delta-iload. Completed when the
** first real LDO circuit lands; the stub exists so the class abstraction is exercised
** (template resolution + Tier 2 assembly) by a non-amplifier class.
** Bindings: DUT PORT_LINE VDD ILOAD_START ILOAD_STOP ILOAD_STEP PDK_INCLUDE.
.lib sky130.lib.spice tt
.temp 27

.param VDD=2.0

Vdd  vdd 0 dc {VDD}
Vss  vss 0 dc 0
Iload vout 0 dc 0

XDUT vdd vout vss ldo_003_analoggym_simple

.control
  set filetype=ascii
  dc Iload 0 10m 0.5m
  meas dc vout_max MAX v(vout)
  meas dc vout_min MIN v(vout)
  let load_reg = vout_max - vout_min
  print load_reg
  write
  quit
.endc
.param x_dut_xm1_w=2
.param x_dut_xm1_l=2
.param x_dut_xm4_w=80
.param x_dut_xm4_l=0.5
.param x_dut_xm5_w=100
.param x_dut_xm5_l=0.5
.param x_dut_xmp_w=20
.param x_dut_xmp_l=0.5
.param x_dut_xmp_m=360
.param r_z=3k
.param c_comp=1p
.param vref_val=1.8
.param vb_val=1.2
.param r_bleed=100k
* ---- GENERATED parameter ties (abstract/params.yaml groups/ratios) ----
* Each tied symbol is defined exactly once, by its line below; rewrite that
* .param to untie just that symbol (untying = shadowing, plan D-3).
.param x_dut_xm2_w = {x_dut_xm1_w}
.param x_dut_xm2_l = {x_dut_xm1_l}
.param x_dut_xm3_w = {x_dut_xm4_w}
.param x_dut_xm3_l = {x_dut_xm4_l}
.subckt ldo_003_analoggym_simple vdd vout vss
CC ncz vout 'c_comp'
RZ ncz ngate 'r_z'
R_BLEED vout vss 'r_bleed'
VB vb vss dc {vb_val}
VREF vref vss dc {vref_val}
XM1 ndiode vout ntail vss sky130_fd_pr__nfet_g5v0d10v5 l=x_dut_xm1_l w=x_dut_xm1_w
XM2 ngate vref ntail vss sky130_fd_pr__nfet_g5v0d10v5 l=x_dut_xm2_l w=x_dut_xm2_w
XM3 ngate ndiode vdd vdd sky130_fd_pr__pfet_g5v0d10v5 l=x_dut_xm3_l w=x_dut_xm3_w
XM4 ndiode ndiode vdd vdd sky130_fd_pr__pfet_g5v0d10v5 l=x_dut_xm4_l w=x_dut_xm4_w
XM5 ntail vb vss vss sky130_fd_pr__nfet_g5v0d10v5 l=x_dut_xm5_l w=x_dut_xm5_w
XMP vout ngate vdd vdd sky130_fd_pr__pfet_g5v0d10v5 l=x_dut_xmp_l m=x_dut_xmp_m w=x_dut_xmp_w
.ends
.end
