** GENERATED by `analog-db export-raw` — DO NOT EDIT.
** circuit=ldo_003_analoggym_simple  class=ldo  pdk=sky130  testbench=dropout  corner=tt
** Self-contained deck: testbench + bound params + lowered DUT (.subckt ldo_003_analoggym_simple).
** PDK corner libs resolve by BARE NAME on the image's ngspice sourcepath — run in a
** PDK-enabled env (the base image / api container), NOT a bare host:
**   docker run --rm -i spicexplorer-spice-base:local \
**     bash -lc 'd=$(mktemp -d) && cat > $d/c.spice && cd $d && ngspice -b c.spice' < raw/ldo_003_analoggym_simple/sky130/dropout.spice
*----------------------------------------------------------*
** params: 14 free + 0 frozen knobs (sizing.yaml) · 4 tied · 0 ratio-derived (abstract/params.yaml) · 0 testbench params
** AUTHORED TEMPLATE — ldo/dropout: the smallest (Vin - Vout) at which the regulator still
** REGULATES, under heavy load. Vin is swept upward and dropout is read at the first point where
** the output is genuinely in regulation.
**
** REWRITTEN 2026-07-21. The previous form was
**     meas dc vin_at WHEN v(vout)=1.764 RISE=1
**     let v_dropout = vin_at - 1.764
** i.e. purely "when does vout first rise past a threshold". That cannot tell REGULATION from a
** DEAD PASS DEVICE, and it fails in the worst possible direction — optimistically. When the loop
** is not working the pass transistor sits fully on, so vout simply follows vin; vout then crosses
** VOUT_THRESH at vin ~ VOUT_THRESH and the bench reports a dropout of ~0. A completely broken
** regulator scores a PERFECT dropout number.
**
** That is not hypothetical: it green-lit a real candidate here. A resistor-biased variant of
** ldo_005_buffered_ref reported dropout 0.090 V (against 0.490 V for the working design) while
** actually RAILING below ~3.1 V — vout was 2.59 V at vin 2.6 V. Only line_reg (1.185 V) caught it.
** This is the same class of defect as the amplifier ICMR bench measuring rail coincidence instead
** of tracking, and it takes the same cure: an ACTIVITY criterion alongside the level test.
**
** In regulation now requires BOTH:
**   * the output is at its target:      |vout - VOUT_NOM| <= VREG_TOL
**   * the output is not following vin:  |dvout/dvin| <= REG_SLOPE_MAX
** A regulating LDO has dvout/dvin ~ line-regulation slope (1e-3 or less); a railed one has ~1, so
** the slope test separates them cleanly no matter where the level test happens to land.
**
** Bindings: DUT PORT_LINE ILOAD VDD_START VDD_STOP VDD_STEP VOUT_NOM VREG_TOL REG_SLOPE_MAX
**           PDK_INCLUDE.
** VOUT_NOM defaults to the datasheet's default_conditions.vout typical value; VREG_TOL and
** REG_SLOPE_MAX have defaults in assemble.py, so existing circuits need no edits. The legacy
** VOUT_THRESH binding is no longer used — a threshold alone is exactly what was wrong.
.lib sky130.lib.spice tt
.temp 27

Vdd  vdd 0 dc 1.2
Vss  vss 0 dc 0
Iload vout 0 dc 10m

XDUT vdd vout vss ldo_003_analoggym_simple

.control
  set filetype=ascii
  dc Vdd 1.2 2.0 0.01
  let vo    = v(vout)
  let vsw   = v(vdd)
  let dvo   = deriv(vo)
  let dvi   = deriv(vsw)
  let slope = dvo / dvi
  let inreg = (abs(vo - 1.8) <= 0.05) & (abs(slope) <= 0.1)
  let npts  = length(inreg)
  let k     = 0
  let found = 0
  let vin_at = 0
  let vout_at = 0
  while k < npts
    if found < 0.5
      if inreg[k] > 0.5
        let vin_at  = vsw[k]
        let vout_at = vo[k]
        let found   = 1
      end
    end
    let k = k + 1
  end
  * NaN rather than a fabricated number when the sweep never reaches regulation — an honest
  * "this circuit does not regulate anywhere in the swept range".
  if found < 0.5
    * 0*log(0) — NOT 0/0: ngspice-45 hard-errors on 0/0 ("argument out of range for
    * divide"), so the vector never exists and the runner reports sim_error instead of
    * the intended honest NaN (found live on ldo_004's committed sizing, 2026-07-24).
    let v_dropout = 0*log(0)
  else
    let v_dropout = vin_at - vout_at
  end
  print vin_at vout_at v_dropout
  write
  quit
.endc
.param x_dut_xm1_w=2
.param x_dut_xm1_l=2
.param x_dut_xm4_w=80
.param x_dut_xm4_l=0.5
.param x_dut_xm5_w=100
.param x_dut_xm5_l=0.5
.param x_dut_xmp_w=20
.param x_dut_xmp_l=0.5
.param x_dut_xmp_m=360
.param r_z=3k
.param c_comp=1p
.param vref_val=1.8
.param vb_val=1.2
.param r_bleed=100k
* ---- GENERATED parameter ties (abstract/params.yaml groups/ratios) ----
* Each tied symbol is defined exactly once, by its line below; rewrite that
* .param to untie just that symbol (untying = shadowing, plan D-3).
.param x_dut_xm2_w = {x_dut_xm1_w}
.param x_dut_xm2_l = {x_dut_xm1_l}
.param x_dut_xm3_w = {x_dut_xm4_w}
.param x_dut_xm3_l = {x_dut_xm4_l}
.subckt ldo_003_analoggym_simple vdd vout vss
CC ncz vout 'c_comp'
RZ ncz ngate 'r_z'
R_BLEED vout vss 'r_bleed'
VB vb vss dc {vb_val}
VLP lp_brk vout dc 0
VREF vref vss dc {vref_val}
XM1 ndiode lp_brk ntail vss sky130_fd_pr__nfet_g5v0d10v5 l=x_dut_xm1_l w=x_dut_xm1_w
XM2 ngate vref ntail vss sky130_fd_pr__nfet_g5v0d10v5 l=x_dut_xm2_l w=x_dut_xm2_w
XM3 ngate ndiode vdd vdd sky130_fd_pr__pfet_g5v0d10v5 l=x_dut_xm3_l w=x_dut_xm3_w
XM4 ndiode ndiode vdd vdd sky130_fd_pr__pfet_g5v0d10v5 l=x_dut_xm4_l w=x_dut_xm4_w
XM5 ntail vb vss vss sky130_fd_pr__nfet_g5v0d10v5 l=x_dut_xm5_l w=x_dut_xm5_w
XMP vout ngate vdd vdd sky130_fd_pr__pfet_g5v0d10v5 l=x_dut_xmp_l m=x_dut_xmp_m w=x_dut_xmp_w
.ends
.end
