** GENERATED by `analog-db export-raw` — DO NOT EDIT.
** circuit=amp_033_ti_ldo_ref_selfbias  class=amplifier  pdk=gf180mcu  testbench=cmrr_vcm  corner=tt
** Self-contained deck: testbench + bound params + lowered DUT (.subckt amp_033_ti_ldo_ref_selfbias).
** PDK corner libs resolve by BARE NAME on the image's ngspice sourcepath — run in a
** PDK-enabled env (the base image / api container), NOT a bare host:
**   docker run --rm -i spicexplorer-spice-base:local \
**     bash -lc 'd=$(mktemp -d) && cat > $d/c.spice && cd $d && ngspice -b c.spice' < raw/amp_033_ti_ldo_ref_selfbias/gf180mcu/cmrr_vcm.spice
*----------------------------------------------------------*
** params: 16 free + 0 frozen knobs (sizing.yaml) · 6 tied · 0 ratio-derived (abstract/params.yaml) · 3 testbench params
** AUTHORED TEMPLATE — amplifier/cmrr_vcm_selfbias (plan D-4/D-5): common-mode rejection
** for self-biased DUTs (no ibias port — the AnalogGym amplifiers). Identical to cmrr_vcm
** except there is no external bias source. The DUT is closed in a unity-gain buffer and the
** SAME 1 V AC rides on both inputs (Vinp ac 1, and the vinn–vout short also ac 1, so
** vinn = vout + vac); the differential input is −vout while the common mode moves by a full
** volt, giving vout ≈ (Acm/Ad)·vac = vac/CMRR and CMRR = −vdb(vout). Reported at FSTART.
** The unity-buffer DC op point is the same one the ac_open_loop_biaswrap bench already
** proves out for these DUTs, so biasing is safe.
** Bindings: DUT PORT_LINE VDD VCM CL FSTART FSTOP PPD PDK_INCLUDE.
.include design.ngspice
.lib sm141064.ngspice typical
.temp 27

.param VDD=3.3
.param VCM=0.8
.param CL=10p

Vdd  vdd 0 dc {VDD}          ; supply quiet — isolate the common-mode path
Vss  vss 0 dc 0
CLoad vout 0 {CL}

Vinp vinp 0 dc {VCM} ac 1    ; +1 V AC on the + input ...
Vfb  vinn vout dc 0 ac 1     ; ... and the same +1 V AC lifted onto vinn (unity buffer at DC)

XDUT vdd vout vinp vinn vss amp_033_ti_ldo_ref_selfbias

.control
  set filetype=ascii
  ac dec 101 1k 1G
  let cmrr = -vdb(vout)
  meas ac cmrr_db FIND cmrr AT=1k
  write
  quit
.endc
.param x_dut_xmbp_w=1.0844e-05
.param x_dut_xmbp_l=2e-06
.param x_dut_xmb0_w=1.2e-05
.param x_dut_xmb0_l=2e-06
.param x_dut_xmbc_w=8.316e-06
.param x_dut_xmbc_m=1
.param x_dut_xmbo_w=4e-06
.param x_dut_xmbo_m=1
.param x_dut_xm1_w=8.642e-05
.param x_dut_xm1_l=7e-07
.param x_dut_xm3_w=2e-05
.param x_dut_xm3_l=1e-06
.param x_dut_xm5_w=3.776e-05
.param x_dut_xm5_l=2.646e-06
.param r_z=30853
.param c_comp=4.508e-12
* ---- GENERATED parameter ties (abstract/params.yaml groups/ratios) ----
* Each tied symbol is defined exactly once, by its line below; rewrite that
* .param to untie just that symbol (untying = shadowing, plan D-3).
.param x_dut_xm4_w = {x_dut_xm3_w}
.param x_dut_xm4_l = {x_dut_xm3_l}
.param x_dut_xm2_w = {x_dut_xm1_w}
.param x_dut_xm2_l = {x_dut_xm1_l}
.param x_dut_xmbc_l = {x_dut_xmb0_l}
.param x_dut_xmbo_l = {x_dut_xmb0_l}
.subckt amp_033_ti_ldo_ref_selfbias vdd vout vinp vinn vss
CC ncz vout 'c_comp'
RZ nb ncz 'r_z'
XM1 na vinn tail vss nfet_06v0 l=x_dut_xm1_l w=x_dut_xm1_w
XM2 nb vinp tail vss nfet_06v0 l=x_dut_xm2_l w=x_dut_xm2_w
XM3 na na vdd vdd pfet_06v0 l=x_dut_xm3_l w=x_dut_xm3_w
XM4 nb na vdd vdd pfet_06v0 l=x_dut_xm4_l w=x_dut_xm4_w
XM5 vout nb vdd vdd pfet_06v0 l=x_dut_xm5_l w=x_dut_xm5_w
XMB0 ibias ibias vss vss nfet_06v0 l=x_dut_xmb0_l w=x_dut_xmb0_w
XMBC tail ibias vss vss nfet_06v0 l=x_dut_xmbc_l m=x_dut_xmbc_m w=x_dut_xmbc_w
XMBO vout ibias vss vss nfet_06v0 l=x_dut_xmbo_l m=x_dut_xmbo_m w=x_dut_xmbo_w
XMBP ibias ibias vdd vdd pfet_06v0 l=x_dut_xmbp_l w=x_dut_xmbp_w
.ends
.end
