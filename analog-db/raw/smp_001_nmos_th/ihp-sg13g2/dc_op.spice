** GENERATED by `analog-db export-raw` — DO NOT EDIT.
** circuit=smp_001_nmos_th  class=sampler  pdk=ihp-sg13g2  testbench=dc_op  corner=tt
** Self-contained deck: testbench + bound params + lowered DUT (.subckt smp_001_nmos_th).
** PDK corner libs resolve by BARE NAME on the image's ngspice sourcepath — run in a
** PDK-enabled env (the base image / api container), NOT a bare host:
**   docker run --rm -i spicexplorer-spice-base:local \
**     bash -lc 'd=$(mktemp -d) && cat > $d/c.spice && cd $d && ngspice -b c.spice' < raw/smp_001_nmos_th/ihp-sg13g2/dc_op.spice
*----------------------------------------------------------*
** AUTHORED TEMPLATE — sampler/dc_op: DC operating point + supply current of a sample-and-hold.
** [VALIDATED 2026-07-16 on ihp-sg13g2 against smp_001_nmos_th — live ngspice].
** Holds the input at the common mode with the clock in track and reports the static supply draw
** and the tracked output. Port convention: vdd vin clk vout vss.
** Bindings: DUT PORT_LINE VDD VCM VCLK PDK_INCLUDE.
.lib cornerMOSlv.lib mos_tt
.temp 27

.param VDD=1.2
.param VCM=0.6
.param VCLK=1.2

Vdd vdd 0 dc {VDD}
Vss vss 0 dc 0
Vin vin 0 dc {VCM}
Vclk clk 0 dc {VCLK}

XDUT vdd vin clk vout vss smp_001_nmos_th

.control
  set filetype=ascii
  op
  let i_supply = abs(i(Vdd))
  let v_out = v(vout)
  print i_supply v_out
  write
  quit
.endc
.param x_dut_xm0_w=2.0u
.param x_dut_xm0_l=0.13u
.param x_dut_xm0_m=1
.param x_dut_c0_value=500f
.subckt smp_001_nmos_th vdd vin clk vout vss
C0 vout vss x_dut_c0_value
XM0 vin clk vout vss sg13_lv_nmos l=x_dut_xm0_l m=x_dut_xm0_m w=x_dut_xm0_w
.ends
.end
