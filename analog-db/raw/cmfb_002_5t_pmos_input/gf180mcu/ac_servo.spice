** GENERATED by `analog-db export-raw` — DO NOT EDIT.
** circuit=cmfb_002_5t_pmos_input  class=cmfb  pdk=gf180mcu  testbench=ac_servo  corner=tt
** Self-contained deck: testbench + bound params + lowered DUT (.subckt cmfb_002_5t_pmos_input).
** PDK corner libs resolve by BARE NAME on the image's ngspice sourcepath — run in a
** PDK-enabled env (the base image / api container), NOT a bare host:
**   docker run --rm -i spicexplorer-spice-base:local \
**     bash -lc 'd=$(mktemp -d) && cat > $d/c.spice && cd $d && ngspice -b c.spice' < raw/cmfb_002_5t_pmos_input/gf180mcu/ac_servo.spice
*----------------------------------------------------------*
** params: 11 free + 5 frozen knobs (sizing.yaml) · 7 tied · 0 ratio-derived (abstract/params.yaml) · 3 testbench params
** AUTHORED TEMPLATE — cmfb/ac_servo (servo path transfer). Moved from support/
** 2026-07-20 when CMFB circuits got their own class (sup_002 -> cmfb_001); extended
** with ugf_servo_hz. History: plan_hierarchical_composition P3.
** CMFB-servo transfer: both sense inputs driven together (common-mode) with an AC unit
** about VCM; the servo's control output (vcmfb) transfer gives the CM-loop path gain,
** bandwidth, and unity-gain frequency into the bound control-node load CL (the actuator
** gate proxy). The DC bias point is the ZERO-ERROR point (sensed == vref), i.e. the
** small-signal is taken about vcmfb_nat (see dc_cmfb_transfer).
**   gain_servo_db  low-frequency servo path gain, db(v(vcmfb)) at FSTART
**   bw_servo_hz    -3 dB rolloff into CL
**   ugf_servo_hz   |servo transfer| = 0 dB crossing (absent when gain < 0 dB —
**                  harmless meas failure; keep it in `produces:` only for members
**                  with above-unity servo gain)
** Assumes the CMFB-servo port order:
**   .subckt <id> vinp vinn vcmfb vref vdd vss
** Required bindings: DUT PORT_LINE VDD VCM CL FSTART FSTOP PPD PDK_INCLUDE.
.include design.ngspice
.lib sm141064.ngspice noise_corner
.lib sm141064.ngspice nfet_03v3_t
.lib sm141064.ngspice pfet_03v3_t
.lib sm141064.ngspice fets_mm
.lib sm141064.ngspice res_typical
.lib sm141064.ngspice mimcap_typical
.lib sm141064.ngspice cap_mim
.temp 27

.param VDD=1.2
.param VCM=0.5
.param CL=50f

Vdd  vdd 0 dc {VDD}
Vss  vss 0 dc 0
Vref vref 0 dc {VCM}
Vcm  vcm 0 dc {VCM} ac 1
* common-mode drive: both inputs follow the same AC source
Vinp vinp vcm dc 0
Vinn vinn vcm dc 0
CLoad vcmfb 0 {CL}

XDUT vinp vinn vcmfb vref vdd vss cmfb_002_5t_pmos_input

.control
  set filetype=ascii
  ac dec 61 10 1G
  let gdb = db(v(vcmfb))
  meas ac gain_servo_db FIND gdb AT=10
  let g3 = gain_servo_db - 3
  meas ac bw_servo_hz WHEN gdb=g3 FALL=1
  meas ac ugf_servo_hz WHEN gdb=0 FALL=1
  write
  quit
.endc
.param x_dut_xm4_w=1.42u
.param x_dut_xm4_l=0.28u
.param x_dut_xm2_w=2.32u
.param x_dut_xm2_l=1.31u
.param x_dut_xm1_w=0.329u
.param x_dut_xm1_l=0.28u
.param x_dut_xm7_w=0.293u
.param x_dut_xm7_l=0.28u
.param x_dut_xm3_w=0.881u
.param x_dut_xm3_l=0.28u
.param x_dut_rmp_value=1Meg
.param x_dut_xm1_m=1
.param x_dut_xm2_m=1
.param x_dut_xm3_m=1
.param x_dut_xm4_m=1
.param x_dut_xm7_m=1
* ---- GENERATED parameter ties (abstract/params.yaml groups/ratios) ----
* Each tied symbol is defined exactly once, by its line below; rewrite that
* .param to untie just that symbol (untying = shadowing, plan D-3).
.param x_dut_xm5_w = {x_dut_xm4_w}
.param x_dut_xm5_l = {x_dut_xm4_l}
.param x_dut_xm5_m = {x_dut_xm4_m}
.param x_dut_xm6_w = {x_dut_xm2_w}
.param x_dut_xm6_l = {x_dut_xm2_l}
.param x_dut_xm6_m = {x_dut_xm2_m}
.param x_dut_rmn_value = {x_dut_rmp_value}
.subckt cmfb_002_5t_pmos_input vinp vinn vcmfb vref vdd vss
RMN vinn cm_sense 'x_dut_rmn_value'
RMP cm_sense vinp 'x_dut_rmp_value'
XM1 ptail bias vdd vdd pfet_03v3 l=x_dut_xm1_l m=x_dut_xm1_m w=x_dut_xm1_w
XM2 vcmfb mirr vss vss nfet_03v3 l=x_dut_xm2_l m=x_dut_xm2_m w=x_dut_xm2_w
XM3 bias bias vdd vdd pfet_03v3 l=x_dut_xm3_l m=x_dut_xm3_m w=x_dut_xm3_w
XM4 mirr cm_sense ptail vdd pfet_03v3 l=x_dut_xm4_l m=x_dut_xm4_m w=x_dut_xm4_w
XM5 vcmfb vref ptail vdd pfet_03v3 l=x_dut_xm5_l m=x_dut_xm5_m w=x_dut_xm5_w
XM6 mirr mirr vss vss nfet_03v3 l=x_dut_xm6_l m=x_dut_xm6_m w=x_dut_xm6_w
XM7 bias bias vss vss nfet_03v3 l=x_dut_xm7_l m=x_dut_xm7_m w=x_dut_xm7_w
.ends
.end
