** 5T OTA THD/linearity testbench - unity buffer, 100 kHz 100 mV sine; thd/thd_db do a coherent FFT platform-side (f0 = 100k)
*----------------------------------------------------------*
* Testbench
*----------------------------------------------------------*
Vdd v_dd GND VDD
Vss v_ss GND 0
xota v_dd v_out v_inp v_inn net2 v_ena v_ss ota-5t
C1 v_out v_ss CL m=1
I0 v_dd net2 IBIAS
Venable v_ena v_ss VDD
* 100 mV sine riding the input common mode (buffer => vout tracks it)
Vp v_inp v_ss dc VCM SIN( {VCM} 0.1 100k )
Vfb v_inn v_out dc 0
.save v(v_out)

*----------------------------------------------------------*
* Technology Library
*----------------------------------------------------------*
 .lib cornerMOSlv.lib mos_tt

.temp 27
*----------------------------------------------------------*
* Control Block
*----------------------------------------------------------*
.control
  echo ==================================
  echo start of Control
  echo ==================================
  option sparse
  set filetype=ascii
  save all

  echo
  echo (C) start of THD transient (8 periods of 100 kHz)
  echo ----------------------------------
  tran 0.02u 80u
  let out = v(v_out)

  echo
  echo SAVING SIMULATION RESULTS IN THE RAW FILE
  remzerovec
  write

  echo ==================================
  echo END of Control
  echo ==================================
  quit
  * ^ This is needed for spicelib (uncommented)

.endc

*----------------------------------------------------------*
* Parameter Definitions
*----------------------------------------------------------*

.param VDD=1.5
.param VCM=0.8
.param CL=50f

.param IBIAS=20u

.param x_dut_nfet_input_w=0.5u
.param x_dut_nfet_input_l=5.0u

.param x_dut_nfet_mirror_w=2.0u
.param x_dut_nfet_mirror_l=5.0u

.param x_dut_pfet_load_w=1.5u
.param x_dut_pfet_load_l=5.0u

.param x_dut_nfet_mirror_ref_w=2.0u
.param x_dut_nfet_mirror_ref_l=5.0u

*----------------------------------------------------------*
* Subcircuit Definition
*----------------------------------------------------------*
* expanding   symbol:  ota-5t.sym # of pins=7
** sym_path: ota-5t.sym
** sch_path: ota-5t.sch
.subckt ota-5t vdd vout vinp vinn ibias_20u d_ena vss
*.ipin ibias_20u
*.iopin vdd
*.iopin vss
*.ipin vinp
*.ipin vinn
*.opin vout
*.ipin d_ena
XM5 tail gate_n vss vss sg13_lv_nmos w=x_dut_nfet_mirror_w l=x_dut_nfet_mirror_l ng=1 m=1
XM4 vout gate_p vdd vdd sg13_lv_pmos w=x_dut_pfet_load_w l=x_dut_pfet_load_l ng=1 m=1
XM1 gate_p vinp tail vss sg13_lv_nmos w=x_dut_nfet_input_w l=x_dut_nfet_input_l ng=1 m=1
XM2 vout vinn tail vss sg13_lv_nmos w=x_dut_nfet_input_w l=x_dut_nfet_input_l ng=1 m=1
XM3 gate_p gate_p vdd vdd sg13_lv_pmos w=x_dut_pfet_load_w l=x_dut_pfet_load_l ng=1 m=1
XM6 ibias_20u gate_n vss vss sg13_lv_nmos w=x_dut_nfet_mirror_ref_w l=x_dut_nfet_mirror_ref_l ng=1 m=1
XM9 gate_n ena_n vss vss sg13_lv_nmos w=0.5u l=0.13u ng=1 m=1
XM11 gate_p ena vdd vdd sg13_lv_pmos w=1.5u l=0.13u ng=1 m=1
XM7 ena ena_n vss vss sg13_lv_nmos w=0.5u l=0.13u ng=1 m=1
XM8 ena ena_n vdd vdd sg13_lv_pmos w=1.5u l=0.13u ng=1 m=1
XM10 ibias_20u ena gate_n vss sg13_lv_nmos w=0.5u l=0.13u ng=1 m=1
XM12 ena_n d_ena vss vss sg13_lv_nmos w=0.5u l=0.13u ng=1 m=1
XM13 ena_n d_ena vdd vdd sg13_lv_pmos w=1.5u l=0.13u ng=1 m=1
.ends

.GLOBAL GND
.end
