** GENERATED by `analog-db export-raw` — DO NOT EDIT.
** Standalone lowered DUT subckt for amp_028_ideal_fully_diff on ihp-sg13g2 (sizing .param defaults + .subckt).
** Not a runnable deck on its own — include it under your own testbench:
**   .include _dut.spice
**   XDUT vinp vinn voutp voutn vdd vss amp_028_ideal_fully_diff
** Source: pdk/ihp-sg13g2/netlist.spice (run `analog-db generate` to refresh).
*----------------------------------------------------------*
** params: 5 free + 0 frozen knobs (sizing.yaml) · 0 tied · 0 ratio-derived (abstract/params.yaml)
.param gm_val=100u
.param rout_val=10Meg
.param rin_val=1e12
.param cout_val=1p
.param cin_val=10f
.subckt amp_028_ideal_fully_diff vinp vinn voutp voutn vdd vss
CIN vinp vinn 'cin_val'
COUT voutn voutp 'cout_val'
GM voutn voutp vinp vinn {gm_val}
RIN vinp vinn 'rin_val'
ROUT voutn voutp 'rout_val'
.ends
