** AUTHORED TEMPLATE — filter/tran_step: transient step response of a filter.
** [SKELETON - NOT VALIDATED, 2026-07-15]: well-formed but not yet exercised against a real DUT;
** forward scaffolding for a future open-PDK promotion of this class. Develop + validate the meas
** blocks and add the class metric reader then. See _shared/classes/TODO_new_class_testbenches.md
** Applies a small input step about the common mode and captures the settling waveform (the .raw
** carries the full transient for overshoot / settling-time post-processing).
** Port convention: vdd vin vout vss. Bindings: DUT PORT_LINE VDD VCM VSTEP TSTEP TSTOP PDK_INCLUDE.
${PDK_INCLUDE}

.param VDD=${VDD}
.param VCM=${VCM}
.param VSTEP=${VSTEP}

Vdd vdd 0 dc {VDD}
Vss vss 0 dc 0
Vin vin 0 dc {VCM} pulse({VCM} {VCM+VSTEP} ${TSTEP} 1p 1p {TSTOP} {2*TSTOP})

${PORT_LINE} ${DUT}

.control
  set filetype=ascii
  tran {TSTOP/1000} ${TSTOP}
  let v_out = v(vout)
  write
  quit
.endc
.end
