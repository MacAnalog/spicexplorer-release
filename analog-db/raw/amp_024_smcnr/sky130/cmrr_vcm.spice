** GENERATED by `analog-db export-raw` — DO NOT EDIT.
** circuit=amp_024_smcnr  class=amplifier  pdk=sky130  testbench=cmrr_vcm  corner=tt
** Self-contained deck: testbench + bound params + lowered DUT (.subckt amp_024_smcnr).
** PDK corner libs resolve by BARE NAME on the image's ngspice sourcepath — run in a
** PDK-enabled env (the base image / api container), NOT a bare host:
**   docker run --rm -i spicexplorer-spice-base:local \
**     bash -lc 'd=$(mktemp -d) && cat > $d/c.spice && cd $d && ngspice -b c.spice' < raw/amp_024_smcnr/sky130/cmrr_vcm.spice
*----------------------------------------------------------*
** params: 9 free + 9 frozen knobs (sizing.yaml) · 9 tied · 0 ratio-derived (abstract/params.yaml) · 3 testbench params
** AUTHORED TEMPLATE — amplifier/cmrr_vcm_selfbias (plan D-4/D-5): common-mode rejection
** for self-biased DUTs (no ibias port — the AnalogGym amplifiers). Identical to cmrr_vcm
** except there is no external bias source. The DUT is closed in a unity-gain buffer and the
** SAME 1 V AC rides on both inputs (Vinp ac 1, and the vinn–vout short also ac 1, so
** vinn = vout + vac); the differential input is −vout while the common mode moves by a full
** volt, giving vout ≈ (Acm/Ad)·vac = vac/CMRR and CMRR = −vdb(vout). Reported at FSTART.
** The unity-buffer DC op point is the same one the ac_open_loop_biaswrap bench already
** proves out for these DUTs, so biasing is safe.
** Bindings: DUT PORT_LINE VDD VCM CL FSTART FSTOP PPD PDK_INCLUDE.
.lib sky130.lib.spice tt
.temp 27

.param VDD=1.5
.param VCM=0.5
.param CL=10p

Vdd  vdd 0 dc {VDD}          ; supply quiet — isolate the common-mode path
Vss  vss 0 dc 0
CLoad vout 0 {CL}

Vinp vinp 0 dc {VCM} ac 1    ; +1 V AC on the + input ...
Vfb  vinn vout dc 0 ac 1     ; ... and the same +1 V AC lifted onto vinn (unity buffer at DC)

XDUT vss vdd vinn vinp vout amp_024_smcnr

.control
  set filetype=ascii
  ac dec 101 1k 1G
  let cmrr = -vdb(vout)
  meas ac cmrr_db FIND cmrr AT=1k
  write
  quit
.endc
.param x_dut_xm7_w=0.42
.param x_dut_xm7_l=10
.param x_dut_xm0_w=7.5
.param x_dut_xm0_l=8
.param x_dut_xm1_w=1.5
.param x_dut_xm1_l=10
.param x_dut_xm4_w=1.5
.param x_rz=1e5
.param x_c0=2e-12
.param x_ibias_val=1e-7
.param x_dut_xm7_m=1
.param x_dut_xm6_m=2
.param x_dut_xm5_m=10
.param x_dut_xm0_m=1
.param x_dut_xm2_m=1
.param x_dut_xm1_m=1
.param x_dut_xm3_m=1
.param x_dut_xm4_m=10
* ---- GENERATED parameter ties (abstract/params.yaml groups/ratios) ----
* Each tied symbol is defined exactly once, by its line below; rewrite that
* .param to untie just that symbol (untying = shadowing, plan D-3).
.param x_dut_xm6_w = {x_dut_xm7_w}
.param x_dut_xm5_w = {x_dut_xm7_w}
.param x_dut_xm6_l = {x_dut_xm7_l}
.param x_dut_xm5_l = {x_dut_xm7_l}
.param x_dut_xm2_w = {x_dut_xm0_w}
.param x_dut_xm2_l = {x_dut_xm0_l}
.param x_dut_xm3_l = {x_dut_xm1_l}
.param x_dut_xm4_l = {x_dut_xm1_l}
.param x_dut_xm3_w = {x_dut_xm1_w}
.subckt amp_024_smcnr vss vdd vinn vinp vout
C0 outn nzo x_c0
IBS ibias vss dc {x_ibias_val}
R0 nzo vout x_rz
XM0 outp vinn tailp vdd sky130_fd_pr__pfet_01v8 l=x_dut_xm0_l m=x_dut_xm0_m w=x_dut_xm0_w
XM1 outp outp vss vss sky130_fd_pr__nfet_01v8 l=x_dut_xm1_l m=x_dut_xm1_m w=x_dut_xm1_w
XM2 outn vinp tailp vdd sky130_fd_pr__pfet_01v8 l=x_dut_xm2_l m=x_dut_xm2_m w=x_dut_xm2_w
XM3 outn outp vss vss sky130_fd_pr__nfet_01v8 l=x_dut_xm3_l m=x_dut_xm3_m w=x_dut_xm3_w
XM4 vout outn vss vss sky130_fd_pr__nfet_01v8 l=x_dut_xm4_l m=x_dut_xm4_m w=x_dut_xm4_w
XM5 vout ibias vdd vdd sky130_fd_pr__pfet_01v8 l=x_dut_xm5_l m=x_dut_xm5_m w=x_dut_xm5_w
XM6 tailp ibias vdd vdd sky130_fd_pr__pfet_01v8 l=x_dut_xm6_l m=x_dut_xm6_m w=x_dut_xm6_w
XM7 ibias ibias vdd vdd sky130_fd_pr__pfet_01v8 l=x_dut_xm7_l m=x_dut_xm7_m w=x_dut_xm7_w
.ends
.end
