** GENERATED by `analog-db export-raw` — DO NOT EDIT.
** circuit=amp_018_telescopic_cascode  class=amplifier  pdk=sky130  testbench=iip3  corner=tt
** Self-contained deck: testbench + bound params + lowered DUT (.subckt amp_018_telescopic_cascode).
** PDK corner libs resolve by BARE NAME on the image's ngspice sourcepath — run in a
** PDK-enabled env (the base image / api container), NOT a bare host:
**   docker run --rm -i spicexplorer-spice-base:local \
**     bash -lc 'd=$(mktemp -d) && cat > $d/c.spice && cd $d && ngspice -b c.spice' < raw/amp_018_telescopic_cascode/sky130/iip3.spice
*----------------------------------------------------------*
** params: 15 free + 10 frozen knobs (sizing.yaml) · 8 tied · 0 ratio-derived (abstract/params.yaml) · 5 testbench params
** AUTHORED TEMPLATE — amplifier/iip3: two-tone third-order intercept in the unity buffer.
** Two equal-amplitude tones (ASIG at F1 and F2, series-stacked on the input, offset VCM)
** intermodulate through the DUT; the IM3 products at 2F1-F2 / 2F2-F1 set the intercept.
**
** BIN PLACEMENT: F1/F2 MUST be integer multiples of a common fundamental F0 = gcd(F1,F2)
** (shipped: 0.9/1.0 MHz -> F0 = 100 kHz, n1=9, n2=10), so the tones AND both IM3 products
** (2F1-F2 = 0.8 MHz = 8*F0, 2F2-F1 = 1.1 MHz = 11*F0) land on EXACT bins of F0 and the
** rectangular-window DFT below has zero scalloping/leakage error.
**
** ngspice lane: the four amplitudes are extracted IN-DECK by a coherent single-bin DFT
** (control-script vector math, same shape as ia/thd_diff.spice — no FFT windowing error),
** so the measure parser picks up iip3_dbv / im3_dbc directly. There is no registry route
** in analog-db's runner: a deck that only `write`s the raw yields "no measures parsed".
** Spectre lane: the platform composes a NATIVE pss at F0 instead (tones + IM3 are plain
** harmonics of the fd-PSF -> {meas: iip3_dbv, im3_dbc}); ngspice has no PSS. Both lanes use
** the SAME convention: worst-side IM3 over the weaker tone (see engines/spectre/calculator.yaml).
**
** COHERENCE + SETTLING: recording starts at TSTART (the tran third argument) so the buffer's
** closed-loop startup transient is DISCARDED — without it the transient leaks into every bin
** and buries the (µV-scale) IM3 products. BOTH TSTART and (TSTOP-TSTART) must be integer
** numbers of BEAT periods 1/F0 (shipped: 5 and 20), and TSTEP <= 1/(200*F2). The DC term is
** removed before the DFT (`vac = vo - mean(vo)`) so it cannot bleed into the low bins.
**
** a_floor is a DIAGNOSTIC bin at 5*F0 = 500 kHz, whose lowest-order intermodulation product
** of these two tones is NINTH order — i.e. it reads the deck's numerical floor, not the DUT.
** a_im3l/a_im3h must sit well above it or the tones/window are wrong (a_floor is NOT a metric,
** it is the trust check). It is what caught the endpoint bias corrected below: measured on
** amp_022@ihp-sg13g2, a plain `mean()` DFT floored at 2.3e-7 V (only 11 dB under the real IM3)
** and fell exactly as 1/N under BOTH TSTEP and window scaling; dropping the duplicated last
** sample took the same floor to 1.6e-11 V and made a_im3 TSTEP-independent from 10 ns down.
**
** DRIVE LEVEL — WHY 6.25 mV AND NOT 50 mV (2026-07-31). An IP3 is an EXTRAPOLATED intercept:
** it is only the intercept if the IM3 bin is still on its 3:1 slope, i.e. if the drive is small
** enough that the 5th-order term has not started eating it. The shipped 50 mV was NOT, measured
** as an ASIG sweep at fixed window/step (iip3_dbv in dBV, error against the converged plateau):
**     ASIG            50 m    25 m    12.5 m   6.25 m   3.125 m
**     amp_001@sky130  +1.402  +0.250  +0.036   +0.006   +0.001
**     amp_022@sky130  +0.504  +0.125  +0.031   +0.007   +0.002
**     amp_022@gf180   -0.421  -0.100  -0.023   -0.004   -0.001
**     amp_001@gf180   -0.157  -0.049  -0.012   -0.002    0.000
** i.e. the shipped point was 1.40 dB OPTIMISTIC on amp_001@sky130 (the sign is set by the sign
** of the 5th-order coefficient — it is optimistic on sky130, pessimistic on gf180, so it is not
** even a consistent bias). The error falls as ASIG^2, exactly as a 5th-order contamination must.
**
** The window is bounded BELOW too, by this deck's own numerical floor: on the most linear cell
** in the corpus (amp_022@ihp-sg13g2 — im3_dbc = -123 dBc at 12.5 mV, -135 dBc at the shipped
** 6.25 mV, since im3_dbc itself falls 2 dB per dB of drive) a_im3 falls into a_floor as the drive
** drops, and iip3_dbv starts drifting again — -0.030 dB at 3.125 mV and -0.130 dB at 1.5625 mV,
** where a_im3/a_floor is down to 30 dB. So the VALID DRIVE WINDOW on this corpus is bounded by
** compression above (0.05 dB error at ~14 mV) and by the floor below (0.05 dB error at ~2.5 mV);
** 6.25 mV is its geometric centre. At 6.25 mV the four cells above are converged to <= 0.007 dB
** and the most linear cell still holds 54 dB of a_im3/a_floor margin.
**
** WHAT 6.25 mV DOES NOT BUY. A single drive cannot converge the WHOLE class. On the most
** nonlinear cells that still pass the guard the intercept is still moving at 6.25 mV —
** amp_005_hoilee_affc@sky130 -0.82 dB, amp_012_peng_tcfc@gf180 -4.73 dB, amp_007@ihp -0.43 dB —
** because those buffers are slew-limited at these tones (their measured gain_tone climbs from
** 0.33/0.45/0.80 at 50 mV to 0.91/0.93/1.07 at 1.5625 mV). That is what iip3_comp_db below is
** for: it is printed on EVERY run so a reader never has to assume the number is asymptotic. On
** these three cells AT THE SHIPPED DRIVE it does bound the residual (0.89/6.90/0.51 estimated
** against 0.82/4.73/0.43 measured) — but see the ESTIMATE-NOT-A-BOUND paragraph below before
** quoting it anywhere: that property is measured at 6.25 mV and does NOT hold at higher drive.
**
** COMPRESSION INDICATOR (iip3_comp_db). For a memoryless odd-order series the two-tone IM3 bin
** carries (3/4)a3*A^3 + (25/8)a5*A^5 while the IM5 bin at 3F1-2F2 carries (5/8)a5*A^5, so the
** 5th-order contamination of IM3 is 5x the measured IM5/IM3 ratio and the resulting IIP3 error
** is 10*log10(1 + 5r) ~ 21.7*r dB with r = a_im5/a_im3. Both IM5 products are DFT'd here (0.7
** and 1.2 MHz = bins 7 and 12 of F0 — already on the coherent grid, so they cost two bin pairs
** and no extra simulation) and iip3_comp_db = 21.71*a_im5/a_im3 is printed as an ESTIMATED
** |IIP3 error| in dB.
**
** IT IS AN ESTIMATE, NOT A BOUND — DO NOT QUOTE IT AS ONE. An earlier version of this header
** claimed it was "CONSERVATIVE in every clean pair measured ... never below 1". That claim is
** FALSE above the shipped drive and has been withdrawn. Re-measured as est/|err|, where |err|
** is the drift from a 1.5625 mV reference and only references with >= 65 dB of a_im3/a_floor
** margin are counted (a floor-limited reference makes |err| meaningless):
**   - AT THE SHIPPED 6.25 mV every cell measured came out conservative, ratio 1.09 .. 4.43,
**     the tightest being amp_005_hoilee_affc@sky130 (0.890 estimated vs 0.816 measured).
**   - ABOVE 6.25 mV it UNDERSTATES on slew-limited cells, by up to 2.9x: amp_005@sky130
**     @25 mV reads 3.23 estimated against 9.49 measured (0.34x), amp_012_peng_tcfc@gf180mcu
**     @12.5 mV reads 5.69 against 11.59 (0.49x), amp_007_leung_dfcfc2@ihp @25 mV 4.34 against
**     6.11 (0.71x), amp_010_peng_acbc@sky130 @50 mV 4.33 against 5.57 (0.78x).
** The reason is caveat (1) below: those cells are slewing, and a slew-rate limit is a MEMORY
** effect that the 5th-order series cannot see at all. Read iip3_comp_db as "at least this much
** error", and only at the shipped drive as a usable one-sided estimate.
** TWO CAVEATS: (1) it only models 5th-order contamination, so it cannot see a purely 7th-order
** or memory (slew) effect — that is exactly what the counterexamples above are; (2) when a_im5
** sinks into a_floor the ratio reads the FLOOR, so iip3_comp_db rises again at very low drive
** (amp_022@ihp: 0.013 at 12.5 mV, 0.18 at 3.125 mV, 0.73 at 1.5625 mV). That is not a defect —
** it means "this drive is outside the valid window" at BOTH ends. Compare it with a_floor to
** tell which end you are on.
**
** DEAD-OUTPUT GUARD. Like thd.spice, this deck's `vout` node exists whether or not the DUT has a
** `vout` PORT: on a fully-differential member (voutp/voutn) the node carries only CLoad and the
** Vfb feedback probe, so it is fed purely by capacitive coupling out of the DUT's vinn pin — and
** a_fund/a_im3/a_floor then all come back finite and plausible-looking. The guard is a MEASURED
** gain: the F1 and F2 bins are ALSO taken on the drive v(vinp) (a_dr1/a_dr2, worst-side a_drv),
** and gain_tone = a_fund/a_drv must clear 0.5 V/V. Referencing the measured drive rather than
** the 0.00625 binding makes the guard immune to a mis-bound or mis-parsed stimulus. On a fail
** iip3_dbv becomes the loud -999 sentinel and im3_dbc +999 — both in the BAD direction, and NOT
** NaN, which would make the runner discard the whole analysis.
** WHY 0.5 AND NOT ia/thd_diff.spice's 0.1: this is a UNITY buffer, so the ideal gain_tone is 1
** and dead-node feedthrough is only ~1 decade down, not the ~3 an IA's 20 V/V buys. 0.5 is the
** PHYSICAL line rather than a fitted one — gain_tone = A/(1+A), so 0.5 is exactly |A| = 1, the
** point below which the loop has less than unity gain at the test tones and the deck is not a
** buffer at all. Re-measured across the WHOLE amplifier corpus AT THE SHIPPED 6.25 mV DRIVE
** (80 cell x PDK pairs, 77 of which simulate). An earlier version of this paragraph calibrated
** the threshold on a partial 30-cell scan at the OLD 12.5 mV drive; those counts did not
** describe this deck once the drive moved, so they are replaced here:
**   - 12 fully-differential (structurally dead, no `vout` PORT) pairs read gain_tone
**     0.00026 .. 0.4136, the top of that range being amp_031_srmc_core_cmfb@ihp-sg13g2.
**   - 65 single-ended pairs read 0.00041 .. 1.4582.
** All 12/12 dead pairs trip. 12 of the 65 single-ended pairs also trip, the highest at 0.4354
** (amp_017_tan_clia@gf180mcu) against a lowest PASSING 0.5472 (amp_010_peng_acbc@gf180mcu), so
** the threshold falls in a GAP rather than through a cluster; every tripping single-ended pair
** is attenuating >= 7.2 dB at the test tones, i.e. correctly rejected. The measured a_drv agreed
** with the ASIG binding to better than 0.1 % on all 77 pairs that ran — the stimulus is bound.
** THE GUARD IS A SCREEN, NOT A PROOF: the worst dead cell (0.4136) sits only 1.21x under the
** threshold, and the highest-TRIPPING live cell (0.4354) sits ABOVE it — the two populations
** OVERLAP, so no ratio threshold can separate them in general. The structural fix for a
** differential DUT is a differential template (the ia class has one), not a number here.
**
** BINDING FORM: ASIG, F0, F1 and F2 are substituted into control-language ARITHMETIC below,
** so they must be plain decimals / scientific notation (0.00625, 0.9e6) — NOT SPICE engineering
** suffixes (6.25m, 900k), which the .control parser does not read the same way. TSTEP/TSTART/
** TSTOP only reach the `tran` card, so suffixes are fine there (5n / 50u / 250u).
**
** Measures: a_f1 a_f2 (tone amplitudes at vout), a_drv (measured worst-side per-tone DRIVE —
** compare it with the ASIG binding to catch a mis-bound stimulus), gain_tone / gain_tone_db,
** a_im3l a_im3h (IM3 products), a_im5l a_im5h (IM5 products), a_floor (numerical-floor trust
** check), im3_dbc, iip3_dbv, im5_im3_db, iip3_comp_db. None of these names is in
** raw_project._SPEC_REGISTRY, so they stay recorded diagnostics and score nothing (in
** particular the buffer gain is `gain_tone`, NOT the registry's `gain_cl`). On a guard trip
** iip3_comp_db is forced to 0 — there is no intercept left for it to bound; read iip3_dbv =
** -999 / im3_dbc = +999 as the verdict, not the 0.
** Bindings: DUT PORT_LINE VDD VCM IBIAS CL ASIG F0 F1 F2 TSTEP TSTART TSTOP PDK_INCLUDE.
.lib sky130.lib.spice tt
.temp 27

.param VDD=1.5
.param VCM=0.8
.param IBIAS=5u
.param CL=10p
.param ASIG=0.00625

Vdd  vdd 0 dc {VDD}
Vss  vss 0 dc 0
Ibias vdd ibias dc {IBIAS}
CLoad vout 0 {CL}

* unity buffer; two series-stacked tones — the lower source carries the VCM offset
Vton vinp mid sin(0 {ASIG} 9.0e3)
Vtwo mid  0   sin({VCM} {ASIG} 1.0e4)
Vfb  vinn vout dc 0

XDUT vdd vout vinp vinn ibias vss amp_018_telescopic_cascode

.control
  set filetype=ascii
  tran 500n 21m 1m
  * raw first — `linearize` below switches the current plot to its interpolated scratch
  * copy, so a trailing `write` guts the raw to the DFT leftovers instead of the full
  * node set (thd.spice's header has the measured story)
  write
  let vo = v(vout)
  let vi = v(vinp)
  linearize vo vi
  let t = time
  let vac = vo - mean(vo)
  let vin_ac = vi - mean(vi)
  let np = length(vac)
  let nd = np - 1
* --- coherent single-bin DFT: amplitude at f is 2*|(1/N) sum vac*e^-jwt| over the N
* --- NON-redundant samples. `linearize` returns N+1 points spanning exactly 20 beat
* --- periods, so its last sample REPEATS its first; leaving it in biases every bin by
* --- |vac[0]|/N — measured, that bias WAS this deck's whole noise floor (it fell exactly
* --- as 1/N under both TSTEP and window scaling). mean()*np recovers the sum; the
* --- vac[0]*c[0] term drops the duplicate, making the window exactly rectangular.
  let c_f1 = cos(2*pi*9.0e3*t)
  let s_f1 = sin(2*pi*9.0e3*t)
  let re_f1 = (mean(vac*c_f1)*np - vac[0]*c_f1[0])/nd
  let im_f1 = (mean(vac*s_f1)*np - vac[0]*s_f1[0])/nd
  let a_f1  = 2*sqrt(re_f1^2+im_f1^2)
* --- the SAME bin taken on the DRIVE v(vinp) — the reference for the dead-output guard ---
  let rd_f1 = (mean(vin_ac*c_f1)*np - vin_ac[0]*c_f1[0])/nd
  let id_f1 = (mean(vin_ac*s_f1)*np - vin_ac[0]*s_f1[0])/nd
  let a_dr1 = 2*sqrt(rd_f1^2+id_f1^2)
  let c_f2 = cos(2*pi*1.0e4*t)
  let s_f2 = sin(2*pi*1.0e4*t)
  let re_f2 = (mean(vac*c_f2)*np - vac[0]*c_f2[0])/nd
  let im_f2 = (mean(vac*s_f2)*np - vac[0]*s_f2[0])/nd
  let a_f2  = 2*sqrt(re_f2^2+im_f2^2)
  let rd_f2 = (mean(vin_ac*c_f2)*np - vin_ac[0]*c_f2[0])/nd
  let id_f2 = (mean(vin_ac*s_f2)*np - vin_ac[0]*s_f2[0])/nd
  let a_dr2 = 2*sqrt(rd_f2^2+id_f2^2)
  let c_3l = cos(2*pi*(2*9.0e3-1.0e4)*t)
  let s_3l = sin(2*pi*(2*9.0e3-1.0e4)*t)
  let re_3l = (mean(vac*c_3l)*np - vac[0]*c_3l[0])/nd
  let im_3l = (mean(vac*s_3l)*np - vac[0]*s_3l[0])/nd
  let a_im3l = 2*sqrt(re_3l^2+im_3l^2)
  let c_3h = cos(2*pi*(2*1.0e4-9.0e3)*t)
  let s_3h = sin(2*pi*(2*1.0e4-9.0e3)*t)
  let re_3h = (mean(vac*c_3h)*np - vac[0]*c_3h[0])/nd
  let im_3h = (mean(vac*s_3h)*np - vac[0]*s_3h[0])/nd
  let a_im3h = 2*sqrt(re_3h^2+im_3h^2)
* --- 5th-order products at 3F1-2F2 and 3F2-2F1 (0.7 / 1.2 MHz = bins 7 / 12 of F0) — the
* --- COMPRESSION INDICATOR (see the header). They ride the same coherent grid as everything
* --- else, so they cost two bin pairs and no extra simulation.
  let c_5l = cos(2*pi*(3*9.0e3-2*1.0e4)*t)
  let s_5l = sin(2*pi*(3*9.0e3-2*1.0e4)*t)
  let re_5l = (mean(vac*c_5l)*np - vac[0]*c_5l[0])/nd
  let im_5l = (mean(vac*s_5l)*np - vac[0]*s_5l[0])/nd
  let a_im5l = 2*sqrt(re_5l^2+im_5l^2)
  let c_5h = cos(2*pi*(3*1.0e4-2*9.0e3)*t)
  let s_5h = sin(2*pi*(3*1.0e4-2*9.0e3)*t)
  let re_5h = (mean(vac*c_5h)*np - vac[0]*c_5h[0])/nd
  let im_5h = (mean(vac*s_5h)*np - vac[0]*s_5h[0])/nd
  let a_im5h = 2*sqrt(re_5h^2+im_5h^2)
  let c_fl = cos(2*pi*5*1.0e3*t)
  let s_fl = sin(2*pi*5*1.0e3*t)
  let re_fl = (mean(vac*c_fl)*np - vac[0]*c_fl[0])/nd
  let im_fl = (mean(vac*s_fl)*np - vac[0]*s_fl[0])/nd
  let a_floor = 2*sqrt(re_fl^2+im_fl^2)
* --- worst-side IM3/IM5 over the weaker tone; min/max of two scalars without branching ---
  let a_fund = 0.5*(a_f1+a_f2 - abs(a_f1-a_f2))
  let a_im3  = 0.5*(a_im3l+a_im3h + abs(a_im3l-a_im3h))
  let a_im5  = 0.5*(a_im5l+a_im5h + abs(a_im5l-a_im5h))
  let a_drv  = 0.5*(a_dr1+a_dr2 - abs(a_dr1-a_dr2))
* --- floors keep log10() finite when a bin lands on zero (a NaN aborts the run) ---
  let a_fund_g = a_fund + 1e-15
  let a_im3_g  = a_im3 + 1e-15
* --- DEAD-OUTPUT GUARD (see the header): a MEASURED gain, not a NaN check. Do NOT write
* --- `>` inside a `let` — the control preprocessor strips it as an output redirection and
* --- silently truncates the RHS. Masks use `<=`, inverted with 1 - mask.
  let gain_tone = a_fund/(a_drv + 1e-18)
  let gain_tone_db = 20*log10(gain_tone + 1e-18)
  let dead = (gain_tone <= 0.5)
  let live = 1 - dead
* input-referred: OIP3 = 20log10(a_fund) - im3_dbc/2, and the measured buffer gain is
* a_fund/ASIG, so IIP3 = OIP3 - 20log10(a_fund/ASIG) = 20log10(ASIG) - im3_dbc/2.
* ASIG (the BINDING, not a_drv) is the reference on purpose: the Spectre lane's
* calculator.yaml iip3_dbv passes the same `AMPL: 0.00625`, so both lanes stay identical.
* a_drv is printed beside it — if it disagrees with ASIG, the stimulus is mis-bound.
  let im3_raw  = 20*log10(a_im3_g/a_fund_g)
  let iip3_raw = 20*log10(0.00625) - im3_raw/2
  let im3_dbc  = live*im3_raw  + dead*999
  let iip3_dbv = live*iip3_raw - dead*999
* --- COMPRESSION INDICATOR (see the header): |IIP3 error| ~ 21.7 * a_im5/a_im3 dB.
  let im5_im3_db  = 20*log10((a_im5 + 1e-18)/a_im3_g)
  let iip3_comp_db = live*21.71*a_im5/a_im3_g
  print a_f1 a_f2 a_drv gain_tone gain_tone_db a_im3l a_im3h a_im5l a_im5h a_floor
  print im3_dbc iip3_dbv im5_im3_db iip3_comp_db
  quit
.endc
.param x_dut_xm1_w=50
.param x_dut_xm1_l=0.5
.param x_dut_xm1c_w=50
.param x_dut_xm1c_l=0.5
.param x_dut_xm3_w=50
.param x_dut_xm3_l=1
.param x_dut_xm3c_w=50
.param x_dut_xm3c_l=1
.param x_dut_xm5_w=40
.param x_dut_xm5_l=1
.param x_dut_xm5_ng=2
.param x_dut_xm6_w=20
.param x_dut_xm6_l=1
.param x_dut_v_bias_1=0.81
.param x_dut_v_bias_2=1.28
.param x_dut_xm1_m=1
.param x_dut_xm2_m=1
.param x_dut_xm1c_m=1
.param x_dut_xm2c_m=1
.param x_dut_xm3_m=1
.param x_dut_xm4_m=1
.param x_dut_xm3c_m=1
.param x_dut_xm4c_m=1
.param x_dut_xm5_m=1
.param x_dut_xm6_m=1
* ---- GENERATED parameter ties (abstract/params.yaml groups/ratios) ----
* Each tied symbol is defined exactly once, by its line below; rewrite that
* .param to untie just that symbol (untying = shadowing, plan D-3).
.param x_dut_xm2_w = {x_dut_xm1_w}
.param x_dut_xm2_l = {x_dut_xm1_l}
.param x_dut_xm2c_w = {x_dut_xm1c_w}
.param x_dut_xm2c_l = {x_dut_xm1c_l}
.param x_dut_xm4_w = {x_dut_xm3_w}
.param x_dut_xm4_l = {x_dut_xm3_l}
.param x_dut_xm4c_w = {x_dut_xm3c_w}
.param x_dut_xm4c_l = {x_dut_xm3c_l}
.subckt amp_018_telescopic_cascode vdd vout vinp vinn ibias vss
V1 vdd gate_pc x_dut_v_bias_2
V2 casc_n tail x_dut_v_bias_1
XM1 d1 vinp tail vss sky130_fd_pr__nfet_01v8 l=x_dut_xm1_l m=x_dut_xm1_m w=x_dut_xm1_w
XM1C gate_p casc_n d1 vss sky130_fd_pr__nfet_01v8 l=x_dut_xm1c_l m=x_dut_xm1c_m w=x_dut_xm1c_w
XM2 d2 vinn tail vss sky130_fd_pr__nfet_01v8 l=x_dut_xm2_l m=x_dut_xm2_m w=x_dut_xm2_w
XM2C vout casc_n d2 vss sky130_fd_pr__nfet_01v8 l=x_dut_xm2c_l m=x_dut_xm2c_m w=x_dut_xm2c_w
XM3 s3 gate_p vdd vdd sky130_fd_pr__pfet_01v8 l=x_dut_xm3_l m=x_dut_xm3_m w=x_dut_xm3_w
XM3C gate_p gate_pc s3 vdd sky130_fd_pr__pfet_01v8 l=x_dut_xm3c_l m=x_dut_xm3c_m w=x_dut_xm3c_w
XM4 s4 gate_p vdd vdd sky130_fd_pr__pfet_01v8 l=x_dut_xm4_l m=x_dut_xm4_m w=x_dut_xm4_w
XM4C vout gate_pc s4 vdd sky130_fd_pr__pfet_01v8 l=x_dut_xm4c_l m=x_dut_xm4c_m w=x_dut_xm4c_w
XM5 tail ibias vss vss sky130_fd_pr__nfet_01v8 l=x_dut_xm5_l m=x_dut_xm5_m nf=x_dut_xm5_ng w=x_dut_xm5_w
XM6 ibias ibias vss vss sky130_fd_pr__nfet_01v8 l=x_dut_xm6_l m=x_dut_xm6_m w=x_dut_xm6_w
.ends
.end
