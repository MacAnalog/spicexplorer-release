** GENERATED by `analog-db export-raw` — DO NOT EDIT.
** Standalone lowered DUT subckt for tsn_001_ptat_2t on sky130 (sizing .param defaults + .subckt).
** Not a runnable deck on its own — include it under your own testbench:
**   .include _dut.spice
**   XDUT vdd vout vss tsn_001_ptat_2t
** Source: pdk/sky130/netlist.spice (run `analog-db generate` to refresh).
*----------------------------------------------------------*
** params: 6 free + 0 frozen knobs (sizing.yaml) · 0 tied · 0 ratio-derived (abstract/params.yaml)
.param x_dut_xm0_w=8
.param x_dut_xm0_l=0.2
.param x_dut_xm0_m=8
.param x_dut_xm1_w=4
.param x_dut_xm1_l=1
.param x_dut_xm1_m=8
.subckt tsn_001_ptat_2t vdd vout vss
XM0 vdd vout vout vss sky130_fd_pr__nfet_01v8 l=x_dut_xm0_l m=x_dut_xm0_m w=x_dut_xm0_w
XM1 vout vout vss vss sky130_fd_pr__nfet_01v8 l=x_dut_xm1_l m=x_dut_xm1_m w=x_dut_xm1_w
.ends
