** GENERATED by `analog-db export-raw` — DO NOT EDIT.
** Standalone lowered DUT subckt for ldo_006_stub on sky130 (sizing .param defaults + .subckt).
** Not a runnable deck on its own — include it under your own testbench:
**   .include _dut.spice
**   XDUT vdd vout vss ldo_006_stub
** Source: pdk/sky130/netlist.spice (run `analog-db generate` to refresh).
*----------------------------------------------------------*
** params: 4 free + 1 frozen knobs (sizing.yaml) · 0 tied · 0 ratio-derived (abstract/params.yaml)
.param x_dut_xm1_w=50
.param x_dut_xm1_l=0.5
.param r_top=100k
.param r_bot=100k
.param x_dut_xm1_m=1
.subckt ldo_006_stub vdd vout vss
R1 vdd vref r_top
R2 vref vss r_bot
XM1 vdd vref vout vss sky130_fd_pr__nfet_01v8 l=x_dut_xm1_l m=x_dut_xm1_m w=x_dut_xm1_w
.ends
