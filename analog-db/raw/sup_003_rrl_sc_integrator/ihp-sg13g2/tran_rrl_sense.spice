** GENERATED by `analog-db export-raw` — DO NOT EDIT.
** circuit=sup_003_rrl_sc_integrator  class=support  pdk=ihp-sg13g2  testbench=tran_rrl_sense  corner=tt
** Self-contained deck: testbench + bound params + lowered DUT (.subckt sup_003_rrl_sc_integrator).
** PDK corner libs resolve by BARE NAME on the image's ngspice sourcepath — run in a
** PDK-enabled env (the base image / api container), NOT a bare host:
**   docker run --rm -i spicexplorer-spice-base:local \
**     bash -lc 'd=$(mktemp -d) && cat > $d/c.spice && cd $d && ngspice -b c.spice' < raw/sup_003_rrl_sc_integrator/ihp-sg13g2/tran_rrl_sense.spice
*----------------------------------------------------------*
** params: 36 free + 13 frozen knobs (sizing.yaml) · 74 tied · 0 ratio-derived (abstract/params.yaml) · 6 testbench params
** AUTHORED TEMPLATE — support/tran_rrl_sense (drawings/DRAWING_REVIEW.md S4, option A).
** Ripple-sensing demodulating SC integrator bench: the DUT's job is to sense the main
** amplifier's output RIPPLE (an AC square wave at f_chop), synchronously demodulate it
** (the internal chopper, CLK_CH_RRL at f_chop), and integrate the demodulated product.
** So the stimulus is a differential SQUARE ripple of amplitude +/-VR/2 per side at
** FCHOP, with CLK_CH_RRL clocked in phase at FCHOP and PHI_1/PHI_2 as exact
** complements at TWICE the chop rate (2*FCHOP, phi_1 rising with the chop edge) —
** the CCIA architecture's SC-integrator clocking (two charge transfers per chop
** period; matches the hand-tuned drawings/ccia-dut decks). A DC input is (correctly) rejected by the AC-coupled front end — the old
** tran_sc_integrate DC-ramp expectation does not apply to this topology.
** Measures: ramp_rate between two ONE-CHOP-PERIOD AVG windows W1/W2 centered inside
** the linear ramp (window centers an integer number of periods apart) and
** ripple_gain = ramp_rate/VR (V/s per V of ripple) — the RRL sensing gain.
** Period-averaged windows (not FIND point samples) so the integrator output's
** residual f_chop ripple integrates to ~zero per window and cannot alias into the
** slope (adversarial-review nit closed).
** The SIGN of ripple_gain records the demodulation polarity of the drawn clock hookup
** (S4.2): it is the sign of the composed RRL loop.
**
** Assumes the RRL-integrator port order:
**   .subckt <id> vinp vinn voutp voutn clk_ch_rrl clk_ch_rrl_not clk_phi_1 clk_phi_2
**                vdd vss
** Required bindings: DUT PORT_LINE VDD VCM VR FCHOP TEDGE W1A W1B W2A W2B TSTEP TSTOP
**                    TMAX PDK_INCLUDE.  Each window MUST span exactly one chop period
**                    (W1B-W1A = W2B-W2A = 1/FCHOP); the slope denominator is the
**                    window-center distance.
**                    TMAX = max internal step (TSTEP is only the print
**                    interval; the SC network needs ~200n or the solver steps over TG
**                    conduction and dies).
.lib cornerMOSlv.lib mos_tt
.temp 27

.param VDD=1.2
.param VCM=0.6
.param VR=2m
.param FCHOP=5k
.param TCHOP={1/FCHOP}
.param TEDGE=100n

Vdd  vdd 0 dc {VDD}
Vss  vss 0 dc 0
Vcm  vcm 0 dc {VCM}
* differential square ripple at FCHOP, +/-VR/2 per side about the common mode
Vinp vinp vcm pulse({-VR/2} {VR/2} 0 {TEDGE} {TEDGE} {TCHOP/2-TEDGE} {TCHOP})
Vinn vinn vcm pulse({VR/2} {-VR/2} 0 {TEDGE} {TEDGE} {TCHOP/2-TEDGE} {TCHOP})

* synchronous demodulation clock + two-phase SC clock (exact complements)
Vckr  clk_ch_rrl     0 pulse(0 {VDD} 0 {TEDGE} {TEDGE} {TCHOP/2-TEDGE} {TCHOP})
Vckrn clk_ch_rrl_not 0 pulse({VDD} 0 0 {TEDGE} {TEDGE} {TCHOP/2-TEDGE} {TCHOP})
Vphi1 clk_phi_1 0 pulse(0 {VDD} 0 {TEDGE} {TEDGE} {TCHOP/4-TEDGE} {TCHOP/2})
Vphi2 clk_phi_2 0 pulse({VDD} 0 0 {TEDGE} {TEDGE} {TCHOP/4-TEDGE} {TCHOP/2})

XDUT vinp vinn voutp voutn clk_ch_rrl clk_ch_rrl_not clk_phi_1 clk_phi_2 vdd vss sup_003_rrl_sc_integrator

.control
  set filetype=ascii
  tran 500n 2m 0 200n
  let vd = v(voutp) - v(voutn)
  meas tran v1 AVG vd from=0.5m to=0.7m
  meas tran v2 AVG vd from=1.7m to=1.9m
  let ramp_rate = (v2 - v1)/((1.7m+1.9m)/2 - (0.5m+0.7m)/2)
  let ripple_gain = ramp_rate/(2m)
  print ramp_rate ripple_gain
  write
  quit
.endc
.param x_dut_xm1_opamp_w=20u
.param x_dut_xm1_opamp_l=1u
.param x_dut_xm2_opamp_w=20u
.param x_dut_xm2_opamp_l=0.5u
.param x_dut_xm4_opamp_w=10u
.param x_dut_xm5_opamp_w=4u
.param x_dut_xm5_opamp_l=0.5u
.param x_dut_xm6_opamp_w=4u
.param x_dut_xm6_opamp_l=0.5u
.param x_dut_xm9_opamp_w=10u
.param x_dut_xm9_opamp_l=0.3u
.param x_dut_xm11_opamp_w=5u
.param x_dut_xm11_opamp_l=0.3u
.param x_dut_xm13_opamp_w=6u
.param x_dut_xm15_opamp_w=2u
.param x_dut_xm15_opamp_l=1u
.param x_dut_xm1_s1_w=2u
.param x_dut_xm1_s1_l=0.13u
.param x_dut_xm2_s1_w=2u
.param x_dut_xm2_s1_l=0.13u
.param x_dut_xm1_chrrl_1_w=2u
.param x_dut_xm1_chrrl_1_l=0.13u
.param x_dut_xm2_chrrl_1_w=2u
.param x_dut_xm2_chrrl_1_l=0.13u
.param x_dut_cs1_value=1p
.param x_dut_caz1_value=1p
.param x_dut_cint1_value=4p
.param gm_val=100u
.param rout_val=10Meg
.param cout_val=100f
.param rin_val=1T
.param cin_val=10f
.param vb1=0.45
.param vb2=0.75
.param vb3=0.55
.param vb4=0.6
.param x_dut_xm1_opamp_m=1
.param x_dut_xm2_opamp_m=1
.param x_dut_xm4_opamp_m=1
.param x_dut_xm5_opamp_m=1
.param x_dut_xm6_opamp_m=1
.param x_dut_xm9_opamp_m=1
.param x_dut_xm11_opamp_m=1
.param x_dut_xm13_opamp_m=1
.param x_dut_xm15_opamp_m=1
.param x_dut_xm1_s1_m=1
.param x_dut_xm2_s1_m=1
.param x_dut_xm1_chrrl_1_m=1
.param x_dut_xm2_chrrl_1_m=1
* ---- GENERATED parameter ties (abstract/params.yaml groups/ratios) ----
* Each tied symbol is defined exactly once, by its line below; rewrite that
* .param to untie just that symbol (untying = shadowing, plan D-3).
.param x_dut_xm13_opamp_l = {x_dut_xm15_opamp_l}
.param x_dut_xm14_opamp_l = {x_dut_xm15_opamp_l}
.param x_dut_xm3_opamp_w = {x_dut_xm2_opamp_w}
.param x_dut_xm3_opamp_l = {x_dut_xm2_opamp_l}
.param x_dut_xm3_opamp_m = {x_dut_xm2_opamp_m}
.param x_dut_xm10_opamp_w = {x_dut_xm9_opamp_w}
.param x_dut_xm10_opamp_l = {x_dut_xm9_opamp_l}
.param x_dut_xm10_opamp_m = {x_dut_xm9_opamp_m}
.param x_dut_xm12_opamp_w = {x_dut_xm11_opamp_w}
.param x_dut_xm12_opamp_l = {x_dut_xm11_opamp_l}
.param x_dut_xm12_opamp_m = {x_dut_xm11_opamp_m}
.param x_dut_xm14_opamp_w = {x_dut_xm13_opamp_w}
.param x_dut_xm14_opamp_m = {x_dut_xm13_opamp_m}
.param x_dut_xm7_opamp_w = {x_dut_xm5_opamp_w}
.param x_dut_xm7_opamp_l = {x_dut_xm5_opamp_l}
.param x_dut_xm7_opamp_m = {x_dut_xm5_opamp_m}
.param x_dut_xm8_opamp_w = {x_dut_xm6_opamp_w}
.param x_dut_xm8_opamp_l = {x_dut_xm6_opamp_l}
.param x_dut_xm8_opamp_m = {x_dut_xm6_opamp_m}
.param x_dut_xm16_opamp_w = {x_dut_xm15_opamp_w}
.param x_dut_xm16_opamp_l = {x_dut_xm15_opamp_l}
.param x_dut_xm16_opamp_m = {x_dut_xm15_opamp_m}
.param x_dut_xm4_opamp_l = {x_dut_xm1_opamp_l}
.param x_dut_cs2_value = {x_dut_cs1_value}
.param x_dut_caz2_value = {x_dut_caz1_value}
.param x_dut_cint2_value = {x_dut_cint1_value}
.param x_dut_xm1_s2_w = {x_dut_xm1_s1_w}
.param x_dut_xm1_s3_w = {x_dut_xm1_s1_w}
.param x_dut_xm1_s4_w = {x_dut_xm1_s1_w}
.param x_dut_xm1_s5_w = {x_dut_xm1_s1_w}
.param x_dut_xm1_s6_w = {x_dut_xm1_s1_w}
.param x_dut_xm1_s2_l = {x_dut_xm1_s1_l}
.param x_dut_xm1_s3_l = {x_dut_xm1_s1_l}
.param x_dut_xm1_s4_l = {x_dut_xm1_s1_l}
.param x_dut_xm1_s5_l = {x_dut_xm1_s1_l}
.param x_dut_xm1_s6_l = {x_dut_xm1_s1_l}
.param x_dut_xm1_s2_m = {x_dut_xm1_s1_m}
.param x_dut_xm1_s3_m = {x_dut_xm1_s1_m}
.param x_dut_xm1_s4_m = {x_dut_xm1_s1_m}
.param x_dut_xm1_s5_m = {x_dut_xm1_s1_m}
.param x_dut_xm1_s6_m = {x_dut_xm1_s1_m}
.param x_dut_xm2_s2_w = {x_dut_xm2_s1_w}
.param x_dut_xm2_s3_w = {x_dut_xm2_s1_w}
.param x_dut_xm2_s4_w = {x_dut_xm2_s1_w}
.param x_dut_xm2_s5_w = {x_dut_xm2_s1_w}
.param x_dut_xm2_s6_w = {x_dut_xm2_s1_w}
.param x_dut_xm2_s2_l = {x_dut_xm2_s1_l}
.param x_dut_xm2_s3_l = {x_dut_xm2_s1_l}
.param x_dut_xm2_s4_l = {x_dut_xm2_s1_l}
.param x_dut_xm2_s5_l = {x_dut_xm2_s1_l}
.param x_dut_xm2_s6_l = {x_dut_xm2_s1_l}
.param x_dut_xm2_s2_m = {x_dut_xm2_s1_m}
.param x_dut_xm2_s3_m = {x_dut_xm2_s1_m}
.param x_dut_xm2_s4_m = {x_dut_xm2_s1_m}
.param x_dut_xm2_s5_m = {x_dut_xm2_s1_m}
.param x_dut_xm2_s6_m = {x_dut_xm2_s1_m}
.param x_dut_xm1_chrrl_2_w = {x_dut_xm1_chrrl_1_w}
.param x_dut_xm1_chrrl_3_w = {x_dut_xm1_chrrl_1_w}
.param x_dut_xm1_chrrl_4_w = {x_dut_xm1_chrrl_1_w}
.param x_dut_xm1_chrrl_2_l = {x_dut_xm1_chrrl_1_l}
.param x_dut_xm1_chrrl_3_l = {x_dut_xm1_chrrl_1_l}
.param x_dut_xm1_chrrl_4_l = {x_dut_xm1_chrrl_1_l}
.param x_dut_xm1_chrrl_2_m = {x_dut_xm1_chrrl_1_m}
.param x_dut_xm1_chrrl_3_m = {x_dut_xm1_chrrl_1_m}
.param x_dut_xm1_chrrl_4_m = {x_dut_xm1_chrrl_1_m}
.param x_dut_xm2_chrrl_2_w = {x_dut_xm2_chrrl_1_w}
.param x_dut_xm2_chrrl_3_w = {x_dut_xm2_chrrl_1_w}
.param x_dut_xm2_chrrl_4_w = {x_dut_xm2_chrrl_1_w}
.param x_dut_xm2_chrrl_2_l = {x_dut_xm2_chrrl_1_l}
.param x_dut_xm2_chrrl_3_l = {x_dut_xm2_chrrl_1_l}
.param x_dut_xm2_chrrl_4_l = {x_dut_xm2_chrrl_1_l}
.param x_dut_xm2_chrrl_2_m = {x_dut_xm2_chrrl_1_m}
.param x_dut_xm2_chrrl_3_m = {x_dut_xm2_chrrl_1_m}
.param x_dut_xm2_chrrl_4_m = {x_dut_xm2_chrrl_1_m}
.subckt sup_003_rrl_sc_integrator vinp vinn voutp voutn clk_ch_rrl clk_ch_rrl_not clk_phi_1 clk_phi_2 vdd vss
CAZ1 sum_p oa_inp 'x_dut_caz1_value'
CAZ2 sum_n oa_inn 'x_dut_caz2_value'
CINT1 sum_p int_p 'x_dut_cint1_value'
CINT2 sum_n int_n 'x_dut_cint2_value'
CIN_1 int_p int_n 'cin_val'
COUT_1 voutn voutp 'cout_val'
CS1 vinp sc_p 'x_dut_cs1_value'
CS2 vinn sc_n 'x_dut_cs2_value'
GM_1 voutn voutp int_p int_n {gm_val}
RIN_1 int_p int_n 'rin_val'
ROUT_1 voutn voutp 'rout_val'
VB1 vb1 vss dc {vb1}
VB2 vb2 vss dc {vb2}
VB3 vb3 vss dc {vb3}
VB4 vb4 vss dc {vb4}
XM10_OPAMP oa_outp vb1 oa_d1p vdd sg13_lv_pmos l=x_dut_xm10_opamp_l m=x_dut_xm10_opamp_m w=x_dut_xm10_opamp_w
XM11_OPAMP oa_outn vb2 oa_csrc_n vss sg13_lv_nmos l=x_dut_xm11_opamp_l m=x_dut_xm11_opamp_m w=x_dut_xm11_opamp_w
XM12_OPAMP oa_outp vb2 oa_csrc_p vss sg13_lv_nmos l=x_dut_xm12_opamp_l m=x_dut_xm12_opamp_m w=x_dut_xm12_opamp_w
XM13_OPAMP oa_csrc_n oa_cm_bias vss vss sg13_lv_nmos l=x_dut_xm13_opamp_l m=x_dut_xm13_opamp_m w=x_dut_xm13_opamp_w
XM14_OPAMP oa_csrc_p oa_cm_bias vss vss sg13_lv_nmos l=x_dut_xm14_opamp_l m=x_dut_xm14_opamp_m w=x_dut_xm14_opamp_w
XM15_OPAMP oa_cm_bias oa_cm_bias vss vss sg13_lv_nmos l=x_dut_xm15_opamp_l m=x_dut_xm15_opamp_m w=x_dut_xm15_opamp_w
XM16_OPAMP oa_cm_sense oa_cm_sense vss vss sg13_lv_nmos l=x_dut_xm16_opamp_l m=x_dut_xm16_opamp_m w=x_dut_xm16_opamp_w
XM1_CHRRL_1 sum_p clk_ch_rrl sc_p vss sg13_lv_nmos l=x_dut_xm1_chrrl_1_l m=x_dut_xm1_chrrl_1_m w=x_dut_xm1_chrrl_1_w
XM1_CHRRL_2 sum_n clk_ch_rrl sc_n vss sg13_lv_nmos l=x_dut_xm1_chrrl_2_l m=x_dut_xm1_chrrl_2_m w=x_dut_xm1_chrrl_2_w
XM1_CHRRL_3 sum_p clk_ch_rrl_not sc_n vss sg13_lv_nmos l=x_dut_xm1_chrrl_3_l m=x_dut_xm1_chrrl_3_m w=x_dut_xm1_chrrl_3_w
XM1_CHRRL_4 sum_n clk_ch_rrl_not sc_p vss sg13_lv_nmos l=x_dut_xm1_chrrl_4_l m=x_dut_xm1_chrrl_4_m w=x_dut_xm1_chrrl_4_w
XM1_OPAMP oa_tail vb3 vdd vdd sg13_lv_pmos l=x_dut_xm1_opamp_l m=x_dut_xm1_opamp_m w=x_dut_xm1_opamp_w
XM1_S1 sc_n clk_phi_2 vss vss sg13_lv_nmos l=x_dut_xm1_s1_l m=x_dut_xm1_s1_m w=x_dut_xm1_s1_w
XM1_S2 sc_p clk_phi_2 vss vss sg13_lv_nmos l=x_dut_xm1_s2_l m=x_dut_xm1_s2_m w=x_dut_xm1_s2_w
XM1_S3 oa_inp clk_phi_2 oa_outn vss sg13_lv_nmos l=x_dut_xm1_s3_l m=x_dut_xm1_s3_m w=x_dut_xm1_s3_w
XM1_S4 oa_inn clk_phi_2 oa_outp vss sg13_lv_nmos l=x_dut_xm1_s4_l m=x_dut_xm1_s4_m w=x_dut_xm1_s4_w
XM1_S5 oa_outn clk_phi_1 int_p vss sg13_lv_nmos l=x_dut_xm1_s5_l m=x_dut_xm1_s5_m w=x_dut_xm1_s5_w
XM1_S6 oa_outp clk_phi_1 int_n vss sg13_lv_nmos l=x_dut_xm1_s6_l m=x_dut_xm1_s6_m w=x_dut_xm1_s6_w
XM2_CHRRL_1 sc_p clk_ch_rrl_not sum_p vdd sg13_lv_pmos l=x_dut_xm2_chrrl_1_l m=x_dut_xm2_chrrl_1_m w=x_dut_xm2_chrrl_1_w
XM2_CHRRL_2 sc_n clk_ch_rrl_not sum_n vdd sg13_lv_pmos l=x_dut_xm2_chrrl_2_l m=x_dut_xm2_chrrl_2_m w=x_dut_xm2_chrrl_2_w
XM2_CHRRL_3 sc_n clk_ch_rrl sum_p vdd sg13_lv_pmos l=x_dut_xm2_chrrl_3_l m=x_dut_xm2_chrrl_3_m w=x_dut_xm2_chrrl_3_w
XM2_CHRRL_4 sc_p clk_ch_rrl sum_n vdd sg13_lv_pmos l=x_dut_xm2_chrrl_4_l m=x_dut_xm2_chrrl_4_m w=x_dut_xm2_chrrl_4_w
XM2_OPAMP oa_d1n oa_inp oa_tail vdd sg13_lv_pmos l=x_dut_xm2_opamp_l m=x_dut_xm2_opamp_m w=x_dut_xm2_opamp_w
XM2_S1 vss clk_phi_1 sc_n vdd sg13_lv_pmos l=x_dut_xm2_s1_l m=x_dut_xm2_s1_m w=x_dut_xm2_s1_w
XM2_S2 vss clk_phi_1 sc_p vdd sg13_lv_pmos l=x_dut_xm2_s2_l m=x_dut_xm2_s2_m w=x_dut_xm2_s2_w
XM2_S3 oa_outn clk_phi_1 oa_inp vdd sg13_lv_pmos l=x_dut_xm2_s3_l m=x_dut_xm2_s3_m w=x_dut_xm2_s3_w
XM2_S4 oa_outp clk_phi_1 oa_inn vdd sg13_lv_pmos l=x_dut_xm2_s4_l m=x_dut_xm2_s4_m w=x_dut_xm2_s4_w
XM2_S5 int_p clk_phi_2 oa_outn vdd sg13_lv_pmos l=x_dut_xm2_s5_l m=x_dut_xm2_s5_m w=x_dut_xm2_s5_w
XM2_S6 int_n clk_phi_2 oa_outp vdd sg13_lv_pmos l=x_dut_xm2_s6_l m=x_dut_xm2_s6_m w=x_dut_xm2_s6_w
XM3_OPAMP oa_d1p oa_inn oa_tail vdd sg13_lv_pmos l=x_dut_xm3_opamp_l m=x_dut_xm3_opamp_m w=x_dut_xm3_opamp_w
XM4_OPAMP oa_cm_tail vb3 vdd vdd sg13_lv_pmos l=x_dut_xm4_opamp_l m=x_dut_xm4_opamp_m w=x_dut_xm4_opamp_w
XM5_OPAMP oa_cm_sense oa_outn oa_cm_tail vdd sg13_lv_pmos l=x_dut_xm5_opamp_l m=x_dut_xm5_opamp_m w=x_dut_xm5_opamp_w
XM6_OPAMP oa_cm_bias vb4 oa_cm_tail vdd sg13_lv_pmos l=x_dut_xm6_opamp_l m=x_dut_xm6_opamp_m w=x_dut_xm6_opamp_w
XM7_OPAMP oa_cm_sense oa_outp oa_cm_tail vdd sg13_lv_pmos l=x_dut_xm7_opamp_l m=x_dut_xm7_opamp_m w=x_dut_xm7_opamp_w
XM8_OPAMP oa_cm_bias vb4 oa_cm_tail vdd sg13_lv_pmos l=x_dut_xm8_opamp_l m=x_dut_xm8_opamp_m w=x_dut_xm8_opamp_w
XM9_OPAMP oa_outn vb1 oa_d1n vdd sg13_lv_pmos l=x_dut_xm9_opamp_l m=x_dut_xm9_opamp_m w=x_dut_xm9_opamp_w
.ends
.end
