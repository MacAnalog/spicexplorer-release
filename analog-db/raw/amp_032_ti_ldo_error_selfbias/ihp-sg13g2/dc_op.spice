** GENERATED by `analog-db export-raw` — DO NOT EDIT.
** circuit=amp_032_ti_ldo_error_selfbias  class=amplifier  pdk=ihp-sg13g2  testbench=dc_op  corner=tt
** Self-contained deck: testbench + bound params + lowered DUT (.subckt amp_032_ti_ldo_error_selfbias).
** PDK corner libs resolve by BARE NAME on the image's ngspice sourcepath — run in a
** PDK-enabled env (the base image / api container), NOT a bare host:
**   docker run --rm -i spicexplorer-spice-base:local \
**     bash -lc 'd=$(mktemp -d) && cat > $d/c.spice && cd $d && ngspice -b c.spice' < raw/amp_032_ti_ldo_error_selfbias/ihp-sg13g2/dc_op.spice
*----------------------------------------------------------*
** params: 18 free + 0 frozen knobs (sizing.yaml) · 9 tied · 0 ratio-derived (abstract/params.yaml) · 2 testbench params
** AUTHORED TEMPLATE — amplifier/dc_op_biaswrap: DC operating point + supply current for DUTs on
** the AnalogGym self-bias convention (ports vss vdd vinn vinp vout; NO ibias port). Self-bias
** companion of the universal dc_op (M4 follow-up): a high-gain multistage OTA has no stable
** open-loop DC op point (it rails), so i_supply read open-loop is non-representative. Close the DC
** feedback exactly as ac_open_loop_biaswrap does — Lfb DC-shorts vout back to the inverting input
** (unity DC feedback), pinning the real quiescent operating point (vout ≈ VCM) — then read the
** supply current there. No Cin/Vac: this is a pure DC .op (an inductor is a DC short, so the loop
** is closed at DC).
**
** Assumes the AnalogGym canonical DUT port order (self-biased; NO ibias port):
**   .subckt <id> vss vdd vinn vinp vout
** Bindings: DUT VDD VCM PDK_INCLUDE.
** FIXED 2026-07-20: this template used to hardcode `X1 0 vdd opout_dc opin opout amp_032_ti_ldo_error_selfbias`,
** which silently assumed the AnalogGym port order [vss vdd vinn vinp vout] and MIS-WIRED any
** DUT declaring a different order (e.g. the amplifier-class [vdd vout vinp vinn vss] swaps
** vdd<->vss). It now uses XDUT vdd vout vinp vinn vss with canonical node names, exactly like the
** *_biaswrap_ibias sibling. For the AnalogGym DUTs this is a no-op: their vss port binds to
** node `vss`, which `Vss vss 0 dc 0` ties to ground just as the old direct-to-0 wiring did.
.lib cornerMOSlv.lib mos_tt
.lib cornerRES.lib res_typ
.lib cornerCAP.lib cap_typ
.temp 27

.param VDD=1.5
.param VCM=0.75

Vdd  vdd 0 dc {VDD}
Vss  vss 0 dc 0
Vcm  vinp 0 dc {VCM}          ; common-mode bias on the non-inverting input
Lfb  vout vinn 1T        ; 1 TH: DC short → unity feedback sets the quiescent op point

XDUT vdd vout vinp vinn vss amp_032_ti_ldo_error_selfbias
.control
  set filetype=ascii
  op
  let i_supply = abs(i(Vdd))
  * Input-referred systematic offset: the Lfb DC short makes this a unity-gain follower, so the
  * settled (vout - vinp) IS the input offset. Additive metric (2026-07-20) — existing measures
  * are untouched; a topology with a deliberately ratioed sink (e.g. the TI LDO error amp's
  * mirror_e) shows a large vos here, which also caps its ICMR tracking band.
  let vos = v(vout) - v(vinp)
  print i_supply vos
  write
  quit
.endc
.param x_dut_xmbp_w=5.578670789917222e-06
.param x_dut_xmbp_l=4.652399317553778e-06
.param x_dut_xmb0_w=8.276833786204537e-05
.param x_dut_xmb0_l=3.15070605280647e-06
.param x_dut_xmbc_m=1
.param x_dut_xmbo_m=1
.param x_dut_xm1_w=6.400316047920548e-05
.param x_dut_xm1_l=5.758061070605141e-07
.param x_dut_xm3_w=2.269768753572863e-05
.param x_dut_xm3_l=4.103599384216178e-06
.param x_dut_xm4_w=4.622984258189675e-05
.param x_dut_xm4_l=7.560584329408141e-06
.param x_dut_xm6_w=1.0646593948046076e-05
.param x_dut_xm6_l=1.3958157250351549e-06
.param r_z=35759.18207181488
.param c_comp=5.3161930814325235e-12
.param x_dut_xmbf_w=3.1866222602286976e-06
.param r_nd=9882082.54892156
* ---- GENERATED parameter ties (abstract/params.yaml groups/ratios) ----
* Each tied symbol is defined exactly once, by its line below; rewrite that
* .param to untie just that symbol (untying = shadowing, plan D-3).
.param x_dut_xmbc_l = {x_dut_xmb0_l}
.param x_dut_xmbf_l = {x_dut_xmb0_l}
.param x_dut_xmbo_l = {x_dut_xmb0_l}
.param x_dut_xmbc_w = {x_dut_xmb0_w}
.param x_dut_xmbo_w = {x_dut_xmb0_w}
.param x_dut_xm2_w = {x_dut_xm1_w}
.param x_dut_xm2_l = {x_dut_xm1_l}
.param x_dut_xm5_w = {x_dut_xm3_w}
.param x_dut_xm5_l = {x_dut_xm3_l}
.subckt amp_032_ti_ldo_error_selfbias vdd vout vinp vinn vss
CC ncz vout 'c_comp'
RND na nd 'r_nd'
RZ nb ncz 'r_z'
XM1 na vinn tail vss sg13_lv_nmos l=x_dut_xm1_l w=x_dut_xm1_w
XM2 nb vinp tail vss sg13_lv_nmos l=x_dut_xm2_l w=x_dut_xm2_w
XM3 na nd vdd vdd sg13_lv_pmos l=x_dut_xm3_l w=x_dut_xm3_w
XM4 nlev na nd vdd sg13_lv_pmos l=x_dut_xm4_l w=x_dut_xm4_w
XM5 nb nd vdd vdd sg13_lv_pmos l=x_dut_xm5_l w=x_dut_xm5_w
XM6 vout nb vdd vdd sg13_lv_pmos l=x_dut_xm6_l w=x_dut_xm6_w
XMB0 ibias ibias vss vss sg13_lv_nmos l=x_dut_xmb0_l w=x_dut_xmb0_w
XMBC tail ibias vss vss sg13_lv_nmos l=x_dut_xmbc_l m=x_dut_xmbc_m w=x_dut_xmbc_w
XMBF nlev ibias vss vss sg13_lv_nmos l=x_dut_xmbf_l w=x_dut_xmbf_w
XMBO vout ibias vss vss sg13_lv_nmos l=x_dut_xmbo_l m=x_dut_xmbo_m w=x_dut_xmbo_w
XMBP ibias ibias vdd vdd sg13_lv_pmos l=x_dut_xmbp_l w=x_dut_xmbp_w
.ends
.end
