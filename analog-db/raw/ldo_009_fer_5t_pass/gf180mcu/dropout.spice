** GENERATED by `analog-db export-raw` — DO NOT EDIT.
** circuit=ldo_009_fer_5t_pass  class=ldo  pdk=gf180mcu  testbench=dropout  corner=tt
** Self-contained deck: testbench + bound params + lowered DUT (.subckt ldo_009_fer_5t_pass).
** PDK corner libs resolve by BARE NAME on the image's ngspice sourcepath — run in a
** PDK-enabled env (the base image / api container), NOT a bare host:
**   docker run --rm -i spicexplorer-spice-base:local \
**     bash -lc 'd=$(mktemp -d) && cat > $d/c.spice && cd $d && ngspice -b c.spice' < raw/ldo_009_fer_5t_pass/gf180mcu/dropout.spice
*----------------------------------------------------------*
** params: 12 free + 9 frozen knobs (sizing.yaml) · 6 tied · 0 ratio-derived (abstract/params.yaml) · 0 testbench params
** AUTHORED TEMPLATE — ldo/dropout: sweep Vin upward at heavy load; Vin - Vout at the
** regulation threshold. As Vin rises out of dropout, v(vout) climbs to its regulated target;
** dropout = (Vin at which v(vout) first reaches VOUT_THRESH) - VOUT_THRESH.
** Bindings: DUT PORT_LINE ILOAD VDD_START VDD_STOP VDD_STEP VOUT_THRESH PDK_INCLUDE.
.include design.ngspice
.lib sm141064.ngspice noise_corner
.lib sm141064.ngspice nfet_03v3_t
.lib sm141064.ngspice pfet_03v3_t
.lib sm141064.ngspice fets_mm
.lib sm141064.ngspice res_typical
.lib sm141064.ngspice mimcap_typical
.lib sm141064.ngspice cap_mim
.temp 27

Vdd  vdd 0 dc 0.9
Vss  vss 0 dc 0
Iload vout 0 dc 1m

XDUT vdd vout vss ldo_009_fer_5t_pass

.control
  set filetype=ascii
  dc Vdd 0.9 1.8 0.01
  meas dc vin_at WHEN v(vout)=0.8 RISE=1
  let v_dropout = vin_at - 0.8
  print v_dropout
  write
  quit
.endc
.param x_dut_xmnb_w=4u
.param x_dut_xmnb_l=0.4u
.param x_dut_xmip_w=8u
.param x_dut_xmip_l=0.28u
.param x_dut_xmld_w=4u
.param x_dut_xmld_l=0.4u
.param x_dut_xmp_w=8u
.param x_dut_xmp_l=0.28u
.param x_cmil=2e-12
.param x_cout=50e-12
.param x_rbleed=1e5
.param x_rref=10000
.param x_vref_val=0.9
.param x_ibias_val=20e-6
.param x_dut_xmnb_m=1
.param x_dut_xmnt_m=2
.param x_dut_xmip_m=2
.param x_dut_xmin_m=2
.param x_dut_xmld_m=1
.param x_dut_xmlm_m=1
.param x_dut_xmp_m=20
* ---- GENERATED parameter ties (abstract/params.yaml groups/ratios) ----
* Each tied symbol is defined exactly once, by its line below; rewrite that
* .param to untie just that symbol (untying = shadowing, plan D-3).
.param x_dut_xmnt_w = {x_dut_xmnb_w}
.param x_dut_xmnt_l = {x_dut_xmnb_l}
.param x_dut_xmin_w = {x_dut_xmip_w}
.param x_dut_xmin_l = {x_dut_xmip_l}
.param x_dut_xmlm_w = {x_dut_xmld_w}
.param x_dut_xmlm_l = {x_dut_xmld_l}
.subckt ldo_009_fer_5t_pass vdd vout vss
CMIL vout otao x_cmil
COUT vout vss x_cout
IBI vdd nbias dc {x_ibias_val}
RBLD vout vss x_rbleed
RREF ref0 vref x_rref
VREF ref0 vss dc {x_vref_val}
XMIN otao vref tail vss nfet_03v3 l=x_dut_xmin_l m=x_dut_xmin_m w=x_dut_xmin_w
XMIP otax vout tail vss nfet_03v3 l=x_dut_xmip_l m=x_dut_xmip_m w=x_dut_xmip_w
XMLD otax otax vdd vdd pfet_03v3 l=x_dut_xmld_l m=x_dut_xmld_m w=x_dut_xmld_w
XMLM otao otax vdd vdd pfet_03v3 l=x_dut_xmlm_l m=x_dut_xmlm_m w=x_dut_xmlm_w
XMNB nbias nbias vss vss nfet_03v3 l=x_dut_xmnb_l m=x_dut_xmnb_m w=x_dut_xmnb_w
XMNT tail nbias vss vss nfet_03v3 l=x_dut_xmnt_l m=x_dut_xmnt_m w=x_dut_xmnt_w
XMP vout otao vdd vdd pfet_03v3 l=x_dut_xmp_l m=x_dut_xmp_m w=x_dut_xmp_w
.ends
.end
