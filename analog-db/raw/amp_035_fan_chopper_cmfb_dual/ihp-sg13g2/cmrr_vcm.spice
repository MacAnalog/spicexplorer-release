** GENERATED by `analog-db export-raw` — DO NOT EDIT.
** circuit=amp_035_fan_chopper_cmfb_dual  class=amplifier  pdk=ihp-sg13g2  testbench=cmrr_vcm  corner=tt
** Self-contained deck: testbench + bound params + lowered DUT (.subckt amp_035_fan_chopper_cmfb_dual).
** PDK corner libs resolve by BARE NAME on the image's ngspice sourcepath — run in a
** PDK-enabled env (the base image / api container), NOT a bare host:
**   docker run --rm -i spicexplorer-spice-base:local \
**     bash -lc 'd=$(mktemp -d) && cat > $d/c.spice && cd $d && ngspice -b c.spice' < raw/amp_035_fan_chopper_cmfb_dual/ihp-sg13g2/cmrr_vcm.spice
*----------------------------------------------------------*
** params: 46 free + 20 frozen knobs (sizing.yaml) · 57 tied · 0 ratio-derived (abstract/params.yaml) · 3 testbench params
** AUTHORED TEMPLATE — amplifier/cmrr_vcm_diff: common-mode rejection of a fully-differential
** (self-biased, voutp/voutn) DUT, in the same CM-pinned differential unity-feedback network
** stb_diff uses.
**
** CONFIGURATION (see stb_diff.spice for the full why). The differential loop is closed by two
** ideal VCVSs, fbn/fbp = VCM +/- (voutp-voutn)/2, feeding the inputs through 0 V sources; the
** feedback carries the differential output ONLY, so the input CM is pinned at VCM and the DC
** operating point is the matched-inputs-at-VCM point of dc_op_diff/ac_open_loop_diff. No CM
** loop is closed by the bench — the output CM is left to the DUT's own CMFB, and being a
** small-signal bench this works on every FD cell that has a DC OP, regardless of CMFB quality.
**
** STIMULUS + MATH (the exact FD analog of cmrr_vcm.spice). BOTH feedback sources carry the
** SAME +1 V AC, so both inputs ride up together:
**     vinn = fbn + vac,  vinp = fbp + vac
**  => vin_d = vinp - vinn = -(voutp-voutn)   (the unity differential feedback, unchanged)
**     vin_c = VCM + vac                       (the common mode moves by a full volt)
** With vout_d = Add*vin_d + Adc*vin_c (Adc = the cell's CM->differential conversion gain, the
** thing mismatch creates and CMRR measures):
**     vout_d = -Add*vout_d + Adc*vac  =>  vout_d = Adc/(1+Add) * vac ~= vac/CMRR,
** where CMRR = Add/Adc — so cmrr_db = -20*log10|vout_d| (vac = 1), read at FSTART (the DC-band
** floor), exactly mirroring the SE bench's vout ~= vac/CMRR derivation.
**
** SOLVER-RESOLUTION CEILING (why the 1e-15 floor exists). The corpus netlists are written
** perfectly symmetric (matched W/L, no mismatch corners in the tt deck), so the TRUE
** small-signal Adc of the deck is zero and the AC solve's vout_d response to a pure CM
** stimulus cancels to matrix round-off — ~1e-16 relative to the ~1 V node signals in a double-
** precision LU solve. Any |vout_d| below ~1e-13 is solver noise, not physics, and -db() of it
** would report a plausible-looking 260..320 dB "CMRR" (or -db(0) = Inf, which the runner
** cannot parse). The `+ 1e-15` magnitude floor therefore CAPS the reportable figure at 300 dB:
** a cmrr_db at or near 300 means "beyond what the matrix solver can resolve on a symmetric
** netlist" — a statement about the deck, NOT a physical rejection. Consumers should treat
** anything above ~200 dB as unresolved-by-construction; the measured CMRR of real silicon is
** set by mismatch, which this nominal deck does not model.
**
** cmrr_cm_db — the SECONDARY, always-physical figure. Because the differential response of a
** symmetric cell saturates the solver, the bench also reports the OUTPUT-CM response to the
** same 1 V input-CM ride: vocm = (voutp+voutn)/2, cmrr_cm_db = -db|vocm|. That is the closed
** CM-loop's rejection of an input-CM disturbance — finite, CMFB-quality-dependent, and
** therefore the discriminating number between FD cells whose cmrr_db all read "perfect".
** (Naming: the cm figure is NOT a canonical datasheet metric; it rides the scoreboard entry's
** analyses block like stb's loop measures do.)
**
** DIFFERENTIAL-GAIN CORRECTION (downstream, scoreboard.record). cmrr_cm_db here is the RAW CM
** residual -db|vocm| — a CM-to-CM ratio, NOT yet a rejection FIGURE. A CMRR is (differential
** gain)/(CM disturbance gain), so the physical FD CMRR adds the differential open-loop gain
** back: cmrr_cm_corr_db = dc_gain_db + cmrr_cm_db (the SE unity-buffer cmrr_db folds this in via
** its closed loop; the FD CM path does not close a CM loop, so the deck cannot, and the term is
** added when the scoreboard entry is assembled). cmrr_cm_corr_db is the figure the paper prints.
**
** Bindings: DUT PORT_LINE VDD VCM CL FSTART FSTOP PPD PDK_INCLUDE.
.lib cornerMOSlv.lib mos_tt
.temp 27

.param VDD=1.2
.param VCM=0.6
.param CL=10p

Vdd  vdd 0 dc {VDD}          ; supply quiet — isolate the common-mode path
Vss  vss 0 dc 0
CLoadp voutp 0 {CL}
CLoadn voutn 0 {CL}

* differential unity feedback, CM pinned at VCM (see stb_diff.spice)
Vcm  vcm 0 dc {VCM}
Efbn fbn vcm voutp voutn 0.5
Efbp fbp vcm voutp voutn -0.5

* ... and the SAME +1 V AC lifted onto BOTH inputs: pure common-mode ride, zero differential
Vfbn vinn fbn dc 0 ac 1
Vfbp vinp fbp dc 0 ac 1

XDUT vinp vinn voutp voutn vdd vss amp_035_fan_chopper_cmfb_dual

.control
  set filetype=ascii
  ac dec 101 10 1G
  let vodm = v(voutp) - v(voutn)
  let vocm = (v(voutp) + v(voutn))/2
  * 1e-15 magnitude floor: caps the figure at 300 dB = "beyond solver resolution" (see header);
  * also keeps -db() finite on a bit-symmetric netlist whose true response is exactly 0.
  let cmrr   = -db(mag(vodm) + 1e-15)
  let cmrrcm = -db(mag(vocm) + 1e-15)
  meas ac cmrr_db    FIND cmrr   AT=10
  meas ac cmrr_cm_db FIND cmrrcm AT=10
  write
  quit
.endc
.param x_dut_xm4_cmfb_out_w=1.42u
.param x_dut_xm4_cmfb_out_l=0.27u
.param x_dut_xm2_cmfb_out_w=2.32u
.param x_dut_xm2_cmfb_out_l=1.31u
.param x_dut_xm1_cmfb_out_w=0.329u
.param x_dut_xm7_cmfb_out_w=0.293u
.param x_dut_xm7_cmfb_out_l=0.22u
.param x_dut_xm3_cmfb_out_w=0.881u
.param x_dut_xm3_cmfb_out_l=0.259u
.param x_dut_rmp_cmfb_out_value=1Meg
.param x_dut_xm1_cmfb_out_m=1
.param x_dut_xm2_cmfb_out_m=1
.param x_dut_xm3_cmfb_out_m=1
.param x_dut_xm4_cmfb_out_m=1
.param x_dut_xm7_cmfb_out_m=1
.param x_dut_xm4_cmfb_s1_w=1.42u
.param x_dut_xm4_cmfb_s1_l=0.27u
.param x_dut_xm2_cmfb_s1_w=2.32u
.param x_dut_xm2_cmfb_s1_l=1.31u
.param x_dut_xm1_cmfb_s1_w=0.329u
.param x_dut_xm7_cmfb_s1_w=0.293u
.param x_dut_xm7_cmfb_s1_l=0.22u
.param x_dut_xm3_cmfb_s1_w=0.881u
.param x_dut_xm3_cmfb_s1_l=0.259u
.param x_dut_rmp_cmfb_s1_value=50Meg
.param x_dut_xm1_cmfb_s1_m=1
.param x_dut_xm2_cmfb_s1_m=1
.param x_dut_xm3_cmfb_s1_m=1
.param x_dut_xm4_cmfb_s1_m=1
.param x_dut_xm7_cmfb_s1_m=1
.param x_dut_xm1_core_w=20u
.param x_dut_xm1_core_l=1u
.param x_dut_xm2_core_w=20u
.param x_dut_xm2_core_l=0.5u
.param x_dut_xm4_core_w=10u
.param x_dut_xm4_core_l=1u
.param x_dut_xm6_core_w=10u
.param x_dut_xm10_core_w=10u
.param x_dut_xm10_core_l=0.3u
.param x_dut_xm12_core_w=5u
.param x_dut_xm12_core_l=0.3u
.param x_dut_xm14_core_w=20u
.param x_dut_xm14_core_l=0.25u
.param x_dut_xm16_core_w=2u
.param x_dut_xm16_core_l=0.13u
.param x_dut_xm17_core_w=2u
.param x_dut_xm17_core_l=0.13u
.param x_dut_cm1_core_value=6p
.param vb1_core=0.3983759766
.param vb2_core=0.65
.param vb3_core=0.45
.param x_dut_xm1_core_m=1
.param x_dut_xm2_core_m=1
.param x_dut_xm4_core_m=1
.param x_dut_xm6_core_m=1
.param x_dut_xm10_core_m=1
.param x_dut_xm12_core_m=1
.param x_dut_xm14_core_m=1
.param x_dut_xm16_core_m=1
.param x_dut_xm17_core_m=1
.param vcm_ref=0.5
.param vcm_ref_stg1=0.3265
.param x_dut_xm8o_w=20u
.param x_dut_xm8o_l=1u
.param x_dut_xm8o_m=1
.param c_cm_s1=100p
* ---- GENERATED parameter ties (abstract/params.yaml groups/ratios) ----
* Each tied symbol is defined exactly once, by its line below; rewrite that
* .param to untie just that symbol (untying = shadowing, plan D-3).
.param x_dut_xm9o_w = {x_dut_xm8o_w}
.param x_dut_xm9o_l = {x_dut_xm8o_l}
.param x_dut_xm9o_m = {x_dut_xm8o_m}
.param x_dut_xm5_cmfb_out_w = {x_dut_xm4_cmfb_out_w}
.param x_dut_xm5_cmfb_out_l = {x_dut_xm4_cmfb_out_l}
.param x_dut_xm5_cmfb_out_m = {x_dut_xm4_cmfb_out_m}
.param x_dut_xm6_cmfb_out_w = {x_dut_xm2_cmfb_out_w}
.param x_dut_xm6_cmfb_out_l = {x_dut_xm2_cmfb_out_l}
.param x_dut_xm6_cmfb_out_m = {x_dut_xm2_cmfb_out_m}
.param x_dut_rmn_cmfb_out_value = {x_dut_rmp_cmfb_out_value}
.param x_dut_xm5_cmfb_s1_w = {x_dut_xm4_cmfb_s1_w}
.param x_dut_xm5_cmfb_s1_l = {x_dut_xm4_cmfb_s1_l}
.param x_dut_xm5_cmfb_s1_m = {x_dut_xm4_cmfb_s1_m}
.param x_dut_xm6_cmfb_s1_w = {x_dut_xm2_cmfb_s1_w}
.param x_dut_xm6_cmfb_s1_l = {x_dut_xm2_cmfb_s1_l}
.param x_dut_xm6_cmfb_s1_m = {x_dut_xm2_cmfb_s1_m}
.param x_dut_rmn_cmfb_s1_value = {x_dut_rmp_cmfb_s1_value}
.param x_dut_xm3_core_w = {x_dut_xm2_core_w}
.param x_dut_xm3_core_l = {x_dut_xm2_core_l}
.param x_dut_xm3_core_m = {x_dut_xm2_core_m}
.param x_dut_xm5_core_w = {x_dut_xm4_core_w}
.param x_dut_xm5_core_l = {x_dut_xm4_core_l}
.param x_dut_xm5_core_m = {x_dut_xm4_core_m}
.param x_dut_xm13_core_w = {x_dut_xm12_core_w}
.param x_dut_xm13_core_l = {x_dut_xm12_core_l}
.param x_dut_xm13_core_m = {x_dut_xm12_core_m}
.param x_dut_xm11_core_w = {x_dut_xm10_core_w}
.param x_dut_xm11_core_l = {x_dut_xm10_core_l}
.param x_dut_xm11_core_m = {x_dut_xm10_core_m}
.param x_dut_xm7_core_w = {x_dut_xm6_core_w}
.param x_dut_xm7_core_m = {x_dut_xm6_core_m}
.param x_dut_xm6_core_l = {x_dut_xm1_core_l}
.param x_dut_xm7_core_l = {x_dut_xm1_core_l}
.param x_dut_xm15_core_w = {x_dut_xm14_core_w}
.param x_dut_xm15_core_l = {x_dut_xm14_core_l}
.param x_dut_xm15_core_m = {x_dut_xm14_core_m}
.param x_dut_xm18_core_w = {x_dut_xm16_core_w}
.param x_dut_xm20_core_w = {x_dut_xm16_core_w}
.param x_dut_xm22_core_w = {x_dut_xm16_core_w}
.param x_dut_xm18_core_l = {x_dut_xm16_core_l}
.param x_dut_xm20_core_l = {x_dut_xm16_core_l}
.param x_dut_xm22_core_l = {x_dut_xm16_core_l}
.param x_dut_xm18_core_m = {x_dut_xm16_core_m}
.param x_dut_xm20_core_m = {x_dut_xm16_core_m}
.param x_dut_xm22_core_m = {x_dut_xm16_core_m}
.param x_dut_xm19_core_w = {x_dut_xm17_core_w}
.param x_dut_xm21_core_w = {x_dut_xm17_core_w}
.param x_dut_xm23_core_w = {x_dut_xm17_core_w}
.param x_dut_xm19_core_l = {x_dut_xm17_core_l}
.param x_dut_xm21_core_l = {x_dut_xm17_core_l}
.param x_dut_xm23_core_l = {x_dut_xm17_core_l}
.param x_dut_xm19_core_m = {x_dut_xm17_core_m}
.param x_dut_xm21_core_m = {x_dut_xm17_core_m}
.param x_dut_xm23_core_m = {x_dut_xm17_core_m}
.param x_dut_cm2_core_value = {x_dut_cm1_core_value}
.param x_dut_xm1_cmfb_out_l = {x_dut_xm3_cmfb_out_l}
.param x_dut_xm1_cmfb_s1_l = {x_dut_xm3_cmfb_s1_l}
.param x_dut_xm20_core_w = {x_dut_xm16_core_w}
.param x_dut_xm20_core_l = {x_dut_xm16_core_l}
.param x_dut_xm20_core_m = {x_dut_xm16_core_m}
.param x_dut_xm23_core_w = {x_dut_xm17_core_w}
.param x_dut_xm23_core_l = {x_dut_xm17_core_l}
.param x_dut_xm23_core_m = {x_dut_xm17_core_m}
.param x_dut_xm22_core_w = {x_dut_xm18_core_w}
.param x_dut_xm22_core_l = {x_dut_xm18_core_l}
.param x_dut_xm22_core_m = {x_dut_xm18_core_m}
.param x_dut_xm21_core_w = {x_dut_xm19_core_w}
.param x_dut_xm21_core_l = {x_dut_xm19_core_l}
.param x_dut_xm21_core_m = {x_dut_xm19_core_m}
.subckt amp_035_fan_chopper_cmfb_dual vinp vinn voutp voutn vdd vss
CCM_S1 vb4_ctl vss 'c_cm_s1'
CM1_CORE core__g2_p voutp 'x_dut_cm1_core_value'
CM2_CORE core__g2_n voutn 'x_dut_cm2_core_value'
RMN_CMFB_OUT voutn cmfb_out__cm_sense 'x_dut_rmn_cmfb_out_value'
RMN_CMFB_S1 stg1_n cmfb_s1__cm_sense 'x_dut_rmn_cmfb_s1_value'
RMP_CMFB_OUT cmfb_out__cm_sense voutp 'x_dut_rmp_cmfb_out_value'
RMP_CMFB_S1 cmfb_s1__cm_sense stg1_p 'x_dut_rmp_cmfb_s1_value'
VB1_CORE core__vb1 vss dc {vb1_core}
VB2_CORE core__vb2 vss dc {vb2_core}
VB3_CORE core__vb3 vss dc {vb3_core}
VREFOUT vref_out vss dc {vcm_ref}
VREFS1 vref_s1 vss dc {vcm_ref_stg1}
XM10_CORE stg1_n core__vb3 core__casc_src_n vdd sg13_lv_pmos l=x_dut_xm10_core_l m=x_dut_xm10_core_m w=x_dut_xm10_core_w
XM11_CORE stg1_p core__vb3 core__casc_src_p vdd sg13_lv_pmos l=x_dut_xm11_core_l m=x_dut_xm11_core_m w=x_dut_xm11_core_w
XM12_CORE stg1_p core__vb2 core__fold_p vss sg13_lv_nmos l=x_dut_xm12_core_l m=x_dut_xm12_core_m w=x_dut_xm12_core_w
XM13_CORE stg1_n core__vb2 core__fold_n vss sg13_lv_nmos l=x_dut_xm13_core_l m=x_dut_xm13_core_m w=x_dut_xm13_core_w
XM14_CORE voutp core__g2_p vss vss sg13_lv_nmos l=x_dut_xm14_core_l m=x_dut_xm14_core_m w=x_dut_xm14_core_w
XM15_CORE voutn core__g2_n vss vss sg13_lv_nmos l=x_dut_xm15_core_l m=x_dut_xm15_core_m w=x_dut_xm15_core_w
XM16_CORE stg1_n vdd core__g2_n vss sg13_lv_nmos l=x_dut_xm16_core_l m=x_dut_xm16_core_m w=x_dut_xm16_core_w
XM17_CORE core__g2_n vss stg1_n vdd sg13_lv_pmos l=x_dut_xm17_core_l m=x_dut_xm17_core_m w=x_dut_xm17_core_w
XM18_CORE stg1_p vdd core__g2_p vss sg13_lv_nmos l=x_dut_xm18_core_l m=x_dut_xm18_core_m w=x_dut_xm18_core_w
XM19_CORE core__g2_p vss stg1_p vdd sg13_lv_pmos l=x_dut_xm19_core_l m=x_dut_xm19_core_m w=x_dut_xm19_core_w
XM1_CMFB_OUT cmfb_out__ptail cmfb_out__bias vdd vdd sg13_lv_pmos l=x_dut_xm1_cmfb_out_l m=x_dut_xm1_cmfb_out_m w=x_dut_xm1_cmfb_out_w
XM1_CMFB_S1 cmfb_s1__ptail cmfb_s1__bias vdd vdd sg13_lv_pmos l=x_dut_xm1_cmfb_s1_l m=x_dut_xm1_cmfb_s1_m w=x_dut_xm1_cmfb_s1_w
XM1_CORE core__tail vb4_ctl vdd vdd sg13_lv_pmos l=x_dut_xm1_core_l m=x_dut_xm1_core_m w=x_dut_xm1_core_w
XM20_CORE stg1_p vss core__g2_n vss sg13_lv_nmos l=x_dut_xm20_core_l m=x_dut_xm20_core_m w=x_dut_xm20_core_w
XM21_CORE core__g2_n vdd stg1_p vdd sg13_lv_pmos l=x_dut_xm21_core_l m=x_dut_xm21_core_m w=x_dut_xm21_core_w
XM22_CORE stg1_n vss core__g2_p vss sg13_lv_nmos l=x_dut_xm22_core_l m=x_dut_xm22_core_m w=x_dut_xm22_core_w
XM23_CORE core__g2_p vdd stg1_n vdd sg13_lv_pmos l=x_dut_xm23_core_l m=x_dut_xm23_core_m w=x_dut_xm23_core_w
XM2_CMFB_OUT vb4o cmfb_out__mirr vss vss sg13_lv_nmos l=x_dut_xm2_cmfb_out_l m=x_dut_xm2_cmfb_out_m w=x_dut_xm2_cmfb_out_w
XM2_CMFB_S1 vb4_ctl cmfb_s1__mirr vss vss sg13_lv_nmos l=x_dut_xm2_cmfb_s1_l m=x_dut_xm2_cmfb_s1_m w=x_dut_xm2_cmfb_s1_w
XM2_CORE core__fold_p vinp core__tail vdd sg13_lv_pmos l=x_dut_xm2_core_l m=x_dut_xm2_core_m w=x_dut_xm2_core_w
XM3_CMFB_OUT cmfb_out__bias cmfb_out__bias vdd vdd sg13_lv_pmos l=x_dut_xm3_cmfb_out_l m=x_dut_xm3_cmfb_out_m w=x_dut_xm3_cmfb_out_w
XM3_CMFB_S1 cmfb_s1__bias cmfb_s1__bias vdd vdd sg13_lv_pmos l=x_dut_xm3_cmfb_s1_l m=x_dut_xm3_cmfb_s1_m w=x_dut_xm3_cmfb_s1_w
XM3_CORE core__fold_n vinn core__tail vdd sg13_lv_pmos l=x_dut_xm3_core_l m=x_dut_xm3_core_m w=x_dut_xm3_core_w
XM4_CMFB_OUT cmfb_out__mirr cmfb_out__cm_sense cmfb_out__ptail vdd sg13_lv_pmos l=x_dut_xm4_cmfb_out_l m=x_dut_xm4_cmfb_out_m w=x_dut_xm4_cmfb_out_w
XM4_CMFB_S1 cmfb_s1__mirr cmfb_s1__cm_sense cmfb_s1__ptail vdd sg13_lv_pmos l=x_dut_xm4_cmfb_s1_l m=x_dut_xm4_cmfb_s1_m w=x_dut_xm4_cmfb_s1_w
XM4_CORE core__fold_p core__vb1 vss vss sg13_lv_nmos l=x_dut_xm4_core_l m=x_dut_xm4_core_m w=x_dut_xm4_core_w
XM5_CMFB_OUT vb4o vref_out cmfb_out__ptail vdd sg13_lv_pmos l=x_dut_xm5_cmfb_out_l m=x_dut_xm5_cmfb_out_m w=x_dut_xm5_cmfb_out_w
XM5_CMFB_S1 vb4_ctl vref_s1 cmfb_s1__ptail vdd sg13_lv_pmos l=x_dut_xm5_cmfb_s1_l m=x_dut_xm5_cmfb_s1_m w=x_dut_xm5_cmfb_s1_w
XM5_CORE core__fold_n core__vb1 vss vss sg13_lv_nmos l=x_dut_xm5_core_l m=x_dut_xm5_core_m w=x_dut_xm5_core_w
XM6_CMFB_OUT cmfb_out__mirr cmfb_out__mirr vss vss sg13_lv_nmos l=x_dut_xm6_cmfb_out_l m=x_dut_xm6_cmfb_out_m w=x_dut_xm6_cmfb_out_w
XM6_CMFB_S1 cmfb_s1__mirr cmfb_s1__mirr vss vss sg13_lv_nmos l=x_dut_xm6_cmfb_s1_l m=x_dut_xm6_cmfb_s1_m w=x_dut_xm6_cmfb_s1_w
XM6_CORE core__casc_src_n vb4_ctl vdd vdd sg13_lv_pmos l=x_dut_xm6_core_l m=x_dut_xm6_core_m w=x_dut_xm6_core_w
XM7_CMFB_OUT cmfb_out__bias cmfb_out__bias vss vss sg13_lv_nmos l=x_dut_xm7_cmfb_out_l m=x_dut_xm7_cmfb_out_m w=x_dut_xm7_cmfb_out_w
XM7_CMFB_S1 cmfb_s1__bias cmfb_s1__bias vss vss sg13_lv_nmos l=x_dut_xm7_cmfb_s1_l m=x_dut_xm7_cmfb_s1_m w=x_dut_xm7_cmfb_s1_w
XM7_CORE core__casc_src_p vb4_ctl vdd vdd sg13_lv_pmos l=x_dut_xm7_core_l m=x_dut_xm7_core_m w=x_dut_xm7_core_w
XM8O voutp vb4o vdd vdd sg13_lv_pmos l=x_dut_xm8o_l m=x_dut_xm8o_m w=x_dut_xm8o_w
XM9O voutn vb4o vdd vdd sg13_lv_pmos l=x_dut_xm9o_l m=x_dut_xm9o_m w=x_dut_xm9o_w
.ends
.end
