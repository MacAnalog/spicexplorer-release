** AUTHORED TEMPLATE — buffer/ac_gain: small-signal AC response at the VCM bias point.
** The input is DC-biased at VCM with a unit AC stimulus; CL loads the output. Reports the
** low-frequency gain (dB, ~0 for a follower) and the -3 dB bandwidth.
** Class port convention: vdd vout vin ibias vss (ibias source-referenced, see metrics.yaml).
** Bindings: DUT PORT_LINE VDD VCM IBIAS CL FSTART FSTOP PPD PDK_INCLUDE.
${PDK_INCLUDE}

.param VDD=${VDD}
.param VCM=${VCM}
.param IBIAS=${IBIAS}
.param CL=${CL}

Vdd  vdd 0 dc {VDD}
Vss  vss 0 dc 0
Ibias vdd ibias dc {IBIAS}
Vin  vin 0 dc {VCM} ac 1
CLoad vout 0 {CL}

${PORT_LINE} ${DUT}

.control
  set filetype=ascii
  ac dec ${PPD} ${FSTART} ${FSTOP}
  meas ac gain_ac_db FIND vdb(vout) AT=${FSTART}
  let gtarget = gain_ac_db - 3
  meas ac f3db_hz WHEN vdb(vout)=gtarget FALL=1
  write
  quit
.endc
.end
