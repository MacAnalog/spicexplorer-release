** GENERATED by `analog-db export-raw` — DO NOT EDIT.
** Standalone lowered DUT subckt for ldo_004_basic_pmos on sky130 (sizing .param defaults + .subckt).
** Not a runnable deck on its own — include it under your own testbench:
**   .include _dut.spice
**   XDUT vdd vout vss ldo_004_basic_pmos
** Source: pdk/sky130/netlist.spice (run `analog-db generate` to refresh).
*----------------------------------------------------------*
** params: 11 free + 0 frozen knobs (sizing.yaml) · 4 tied · 0 ratio-derived (abstract/params.yaml)
.param x_dut_xmp_w=10
.param x_dut_xmp_m=100
.param x_dut_xmp_l=0.42
.param r_top=100k
.param r_bot=100k
.param vref_val=0.645
.param i_tail=200u
.param x_dut_xm1_w=42
.param x_dut_xm1_l=1
.param x_dut_xm3_w=45
.param x_dut_xm3_l=0.5
* ---- GENERATED parameter ties (abstract/params.yaml groups/ratios) ----
* Each tied symbol is defined exactly once, by its line below; rewrite that
* .param to untie just that symbol (untying = shadowing, plan D-3).
.param x_dut_xm2_w = {x_dut_xm1_w}
.param x_dut_xm2_l = {x_dut_xm1_l}
.param x_dut_xm4_w = {x_dut_xm3_w}
.param x_dut_xm4_l = {x_dut_xm3_l}
.subckt ldo_004_basic_pmos vdd vout vss
ITAIL etail vss dc {i_tail}
R1 lp_brk fb 'r_top'
R2 fb vss 'r_bot'
VLP lp_brk vout dc 0
VREF vref vss dc {vref_val}
XM1 noutm fb etail vss sky130_fd_pr__nfet_01v8 l=x_dut_xm1_l w=x_dut_xm1_w
XM2 egate vref etail vss sky130_fd_pr__nfet_01v8 l=x_dut_xm2_l w=x_dut_xm2_w
XM3 noutm noutm vdd vdd sky130_fd_pr__pfet_01v8 l=x_dut_xm3_l w=x_dut_xm3_w
XM4 egate noutm vdd vdd sky130_fd_pr__pfet_01v8 l=x_dut_xm4_l w=x_dut_xm4_w
XMP vout egate vdd vdd sky130_fd_pr__pfet_01v8 l=x_dut_xmp_l m=x_dut_xmp_m w=x_dut_xmp_w
.ends
