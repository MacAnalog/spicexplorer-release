** GENERATED by `analog-db export-raw` — DO NOT EDIT.
** circuit=vref_001_vgs  class=voltage_reference  pdk=ihp-sg13g2  testbench=line_sweep  corner=tt
** Self-contained deck: testbench + bound params + lowered DUT (.subckt vref_001_vgs).
** PDK corner libs resolve by BARE NAME on the image's ngspice sourcepath — run in a
** PDK-enabled env (the base image / api container), NOT a bare host:
**   docker run --rm -i spicexplorer-spice-base:local \
**     bash -lc 'd=$(mktemp -d) && cat > $d/c.spice && cd $d && ngspice -b c.spice' < raw/vref_001_vgs/ihp-sg13g2/line_sweep.spice
*----------------------------------------------------------*
** params: 6 free + 0 frozen knobs (sizing.yaml) · 0 tied · 0 ratio-derived (abstract/params.yaml) · 1 testbench params
** AUTHORED TEMPLATE — voltage_reference/line_sweep: line regulation over the supply.
** [VALIDATED 2026-07-16 on ihp-sg13g2 against vref_001_vgs — live ngspice, 4/4 benches pass].
** Sweeps Vdd and reports the reference %-change over the swept range referred to the nominal-supply
** value. Port convention: vdd vref vss. Bindings: DUT PORT_LINE VDD VDD_LO VDD_HI VDD_STEP PDK_INCLUDE.
.lib cornerMOSlv.lib mos_tt
.lib cornerMOShv.lib mos_tt
.temp 27

.param VDD=1.2

Vdd vdd 0 dc {VDD}
Vss vss 0 dc 0

XDUT vdd vref vss vref_001_vgs

.control
  set filetype=ascii
  dc Vdd 1.0 1.8 0.02
  meas dc v_at_lo  FIND v(vref) AT=1.0
  meas dc v_at_hi  FIND v(vref) AT=1.8
  meas dc v_at_nom FIND v(vref) AT=1.2
  let line_reg_pct = abs((v_at_hi - v_at_lo) / v_at_nom) * 100
  print line_reg_pct
  write
  quit
.endc
.param x_dut_xm0_w=2.5u
.param x_dut_xm0_l=2.0u
.param x_dut_xm0_m=1
.param x_dut_xm1_w=1.0u
.param x_dut_xm1_l=2.0u
.param x_dut_xm1_m=1
.subckt vref_001_vgs vdd vref vss
XM0 vdd vref vref vss sg13_lv_nmos l=x_dut_xm0_l m=x_dut_xm0_m w=x_dut_xm0_w
XM1 vref vref vss vss sg13_hv_nmos l=x_dut_xm1_l m=x_dut_xm1_m w=x_dut_xm1_w
.ends
.end
