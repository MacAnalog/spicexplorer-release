** GENERATED by `analog-db export-raw` — DO NOT EDIT.
** circuit=sw_002_chopper_diff  class=switch  pdk=ihp-sg13g2  testbench=tran_chop_polarity  corner=tt
** Self-contained deck: testbench + bound params + lowered DUT (.subckt sw_002_chopper_diff).
** PDK corner libs resolve by BARE NAME on the image's ngspice sourcepath — run in a
** PDK-enabled env (the base image / api container), NOT a bare host:
**   docker run --rm -i spicexplorer-spice-base:local \
**     bash -lc 'd=$(mktemp -d) && cat > $d/c.spice && cd $d && ngspice -b c.spice' < raw/sw_002_chopper_diff/ihp-sg13g2/tran_chop_polarity.spice
*----------------------------------------------------------*
** params: 4 free + 2 frozen knobs (sizing.yaml) · 18 tied · 0 ratio-derived (abstract/params.yaml) · 7 testbench params
** AUTHORED TEMPLATE — switch/tran_chop_polarity (adversarial-review follow-up: the
** modulator's defining function needs a committed gate, not commit-message prose).
** Chopper polarity-reversal proof: a DC differential input VD drives the VA pair; the
** control clock toggles at FCHOP; the VB pair (loaded resistively to VCM) must show the
** differential input FORWARD in one phase and INVERTED in the other. Measures:
**   v_fwd            differential output mid-phase-1 (clock high, straight path)
**   v_rev            differential output mid-phase-2 (clock low, cross path)
**   chop_inversion   v_rev/v_fwd — a true 4-gate modulator gives ~ -1 (sign proof +
**                    straight/cross symmetry in one number); a pass-gate placeholder
**                    (no cross path) gives ~0 (output floats/holds toward 0 via RLOAD)
**
** Assumes the differential pass-pair port order:
**   .subckt <id> va_p va_n vb_p vb_n vctl vctl_not vdd vss
** Required bindings: DUT PORT_LINE VDD VCM VD RLOAD FCHOP TEDGE TM1 TM2 TSTEP TSTOP
**                    PDK_INCLUDE.  (TM1/TM2: mid-phase-1/2 sample times, inside a
**                    settled period — e.g. 0.25/TCHOP and 0.75/TCHOP into a late cycle.)
.lib cornerMOSlv.lib mos_tt
.temp 27

.param VDD=1.2
.param VCM=0.6
.param VD=0.2
.param RLOAD=100k
.param FCHOP=5k
.param TCHOP={1/FCHOP}
.param TEDGE=200n

Vdd  vdd 0 dc {VDD}
Vss  vss 0 dc 0
Vcm  vcm 0 dc {VCM}
Vap  va_p 0 dc {VCM+VD/2}
Van  va_n 0 dc {VCM-VD/2}
Rlp  vb_p vcm {RLOAD}
Rln  vb_n vcm {RLOAD}
Vck  vctl     0 pulse(0 {VDD} 0 {TEDGE} {TEDGE} {TCHOP/2-TEDGE} {TCHOP})
Vckn vctl_not 0 pulse({VDD} 0 0 {TEDGE} {TEDGE} {TCHOP/2-TEDGE} {TCHOP})

XDUT va_p va_n vb_p vb_n vctl vctl_not vdd vss sw_002_chopper_diff

.control
  set filetype=ascii
  tran 200n 1m
  let vbd = v(vb_p) - v(vb_n)
  meas tran v_fwd FIND vbd AT=850u
  meas tran v_rev FIND vbd AT=950u
  let chop_inversion = v_rev/v_fwd
  print chop_inversion
  write
  quit
.endc
.param x_dut_xm1_w=2u
.param x_dut_xm1_l=0.13u
.param x_dut_xm2_w=2u
.param x_dut_xm2_l=0.13u
.param x_dut_xm1_m=1
.param x_dut_xm2_m=1
* ---- GENERATED parameter ties (abstract/params.yaml groups/ratios) ----
* Each tied symbol is defined exactly once, by its line below; rewrite that
* .param to untie just that symbol (untying = shadowing, plan D-3).
.param x_dut_xm3_w = {x_dut_xm1_w}
.param x_dut_xm5_w = {x_dut_xm1_w}
.param x_dut_xm7_w = {x_dut_xm1_w}
.param x_dut_xm3_l = {x_dut_xm1_l}
.param x_dut_xm5_l = {x_dut_xm1_l}
.param x_dut_xm7_l = {x_dut_xm1_l}
.param x_dut_xm3_m = {x_dut_xm1_m}
.param x_dut_xm5_m = {x_dut_xm1_m}
.param x_dut_xm7_m = {x_dut_xm1_m}
.param x_dut_xm4_w = {x_dut_xm2_w}
.param x_dut_xm6_w = {x_dut_xm2_w}
.param x_dut_xm8_w = {x_dut_xm2_w}
.param x_dut_xm4_l = {x_dut_xm2_l}
.param x_dut_xm6_l = {x_dut_xm2_l}
.param x_dut_xm8_l = {x_dut_xm2_l}
.param x_dut_xm4_m = {x_dut_xm2_m}
.param x_dut_xm6_m = {x_dut_xm2_m}
.param x_dut_xm8_m = {x_dut_xm2_m}
.subckt sw_002_chopper_diff va_p va_n vb_p vb_n vctl vctl_not vdd vss
XM1 va_p vctl vb_p vss sg13_lv_nmos l=x_dut_xm1_l m=x_dut_xm1_m w=x_dut_xm1_w
XM2 vb_p vctl_not va_p vdd sg13_lv_pmos l=x_dut_xm2_l m=x_dut_xm2_m w=x_dut_xm2_w
XM3 va_n vctl vb_n vss sg13_lv_nmos l=x_dut_xm3_l m=x_dut_xm3_m w=x_dut_xm3_w
XM4 vb_n vctl_not va_n vdd sg13_lv_pmos l=x_dut_xm4_l m=x_dut_xm4_m w=x_dut_xm4_w
XM5 va_p vctl_not vb_n vss sg13_lv_nmos l=x_dut_xm5_l m=x_dut_xm5_m w=x_dut_xm5_w
XM6 vb_n vctl va_p vdd sg13_lv_pmos l=x_dut_xm6_l m=x_dut_xm6_m w=x_dut_xm6_w
XM7 va_n vctl_not vb_p vss sg13_lv_nmos l=x_dut_xm7_l m=x_dut_xm7_m w=x_dut_xm7_w
XM8 vb_p vctl va_n vdd sg13_lv_pmos l=x_dut_xm8_l m=x_dut_xm8_m w=x_dut_xm8_w
.ends
.end
