** GENERATED by `analog-db generate` — DO NOT EDIT. Source: abstract/netlist.spice → sky130
* vref_001_vgs (emitted by spicexplorer-circuitgraph)
XM0 vdd vref vref vss sky130_fd_pr__nfet_01v8 l=x_dut_xm0_l m=x_dut_xm0_m w=x_dut_xm0_w
XM1 vref vref vss vss sky130_fd_pr__nfet_g5v0d10v5 l=x_dut_xm1_l m=x_dut_xm1_m w=x_dut_xm1_w
.end
