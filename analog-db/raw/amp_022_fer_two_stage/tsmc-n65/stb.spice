** GENERATED by `analog-db export-raw` — DO NOT EDIT.
** circuit=amp_022_fer_two_stage  class=amplifier  pdk=tsmc-n65  testbench=stb  corner=tt
** Self-contained deck: testbench + bound params + lowered DUT (.subckt amp_022_fer_two_stage).
** PDK corner libs resolve by BARE NAME on the image's ngspice sourcepath — run in a
** PDK-enabled env (the base image / api container), NOT a bare host:
**   docker run --rm -i spicexplorer-spice-base:local \
**     bash -lc 'd=$(mktemp -d) && cat > $d/c.spice && cd $d && ngspice -b c.spice' < raw/amp_022_fer_two_stage/tsmc-n65/stb.spice
*----------------------------------------------------------*
** params: 10 free + 5 frozen knobs (sizing.yaml) · 12 tied · 4 ratio-derived (abstract/params.yaml) · 4 testbench params
** AUTHORED TEMPLATE — amplifier/stb: loop-gain (stability) probe in the unity buffer.
** VIPRB is the loop-probe MARKER: a 0 V source in the feedback path (vinn <- vout). On
** the ngspice lane it is electrically a short, so the deck runs as a plain closed-loop
** AC response (ngspice has no stb analysis — eyeball check only). On the Spectre lane
** the platform's emitter translates VIPRB* -> the `iprobe` primitive and composes
** `stb stb probe=VIPRB ...`, so the TRUE loop gain lands in the stb.stb PSF:
** {meas: pm_loop|gain_margin_db|loopgain_db, out: loopGain}, or OCEAN
** phaseMargin(getData("loopGain")) via the class calculator set.
** Bindings: DUT PORT_LINE VDD VCM IBIAS CL FSTART FSTOP PPD PDK_INCLUDE.
.lib tsmc_n65_models.scs tt
.temp 27

.param VDD=1.2
.param VCM=0.6
.param IBIAS=20u
.param CL=500f

Vdd  vdd 0 dc {VDD}
Vss  vss 0 dc 0
Ibias vdd ibias dc {IBIAS}
CLoad vout 0 {CL}

Vinp vinp 0 dc {VCM} ac 1
VIPRB vinn vout dc 0

XDUT vdd vout vinp vinn ibias vss amp_022_fer_two_stage

.control
  set filetype=ascii
  ac dec 101 1k 1G
  write
  quit
.endc
.param x_dut_xmbd_w=4u
.param x_dut_xm7_w=8u
.param x_dut_xm0_w=8u
.param x_dut_xm3_w=6u
.param x_dut_xm7_l=0.4u
.param x_dut_xm0_l=0.4u
.param x_dut_xm3_l=0.4u
.param x_dut_xm2_l=0.4u
.param x_dut_xmbd_l=0.4u
.param x_dut_cc_value=2e-12
.param x_dut_xm0_m=5
.param x_dut_xm3_m=2
.param x_dut_xm2_m=24
.param x_dut_xm7_m=3
.param x_dut_xmbd_m=1
* ---- GENERATED parameter ties (abstract/params.yaml groups/ratios) ----
* Each tied symbol is defined exactly once, by its line below; rewrite that
* .param to untie just that symbol (untying = shadowing, plan D-3).
.param x_dut_xm1_w = {x_dut_xm0_w}
.param x_dut_xm1_l = {x_dut_xm0_l}
.param x_dut_xm1_m = {x_dut_xm0_m}
.param x_dut_xm4_w = {x_dut_xm3_w}
.param x_dut_xm4_l = {x_dut_xm3_l}
.param x_dut_xm2_w = {x_dut_xm3_w}
.param x_dut_xm5_w = {x_dut_xm7_w}
.param x_dut_xm6_w = {x_dut_xm7_w}
.param x_dut_xm5_l = {x_dut_xm7_l}
.param x_dut_xm6_l = {x_dut_xm7_l}
.param x_dut_xmbs_w = {x_dut_xmbd_w}
.param x_dut_xmbs_l = {x_dut_xmbd_l}
.param x_dut_xm4_m = {x_dut_xm3_m*1}
.param x_dut_xm5_m = {x_dut_xm7_m*1}
.param x_dut_xm6_m = {x_dut_xm7_m*17/3}
.param x_dut_xmbs_m = {x_dut_xmbd_m*1}
.subckt amp_022_fer_two_stage vdd vout vinp vinn ibias vss
CC b vout x_dut_cc_value
XM0 a vinn c vdd pch_lvt l=x_dut_xm0_l m=x_dut_xm0_m w=x_dut_xm0_w
XM1 b vinp c vdd pch_lvt l=x_dut_xm1_l m=x_dut_xm1_m w=x_dut_xm1_w
XM2 vout b vss vss nch_lvt l=x_dut_xm2_l m=x_dut_xm2_m w=x_dut_xm2_w
XM3 a a vss vss nch_lvt l=x_dut_xm3_l m=x_dut_xm3_m w=x_dut_xm3_w
XM4 b a vss vss nch_lvt l=x_dut_xm4_l m=x_dut_xm4_m w=x_dut_xm4_w
XM5 c pbias vdd vdd pch_lvt l=x_dut_xm5_l m=x_dut_xm5_m w=x_dut_xm5_w
XM6 vout pbias vdd vdd pch_lvt l=x_dut_xm6_l m=x_dut_xm6_m w=x_dut_xm6_w
XM7 pbias pbias vdd vdd pch_lvt l=x_dut_xm7_l m=x_dut_xm7_m w=x_dut_xm7_w
XMBD ibias ibias vss vss nch_lvt l=x_dut_xmbd_l m=x_dut_xmbd_m w=x_dut_xmbd_w
XMBS pbias ibias vss vss nch_lvt l=x_dut_xmbs_l m=x_dut_xmbs_m w=x_dut_xmbs_w
.ends
.end
