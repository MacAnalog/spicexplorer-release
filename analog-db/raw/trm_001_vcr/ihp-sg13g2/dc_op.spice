** GENERATED by `analog-db export-raw` — DO NOT EDIT.
** circuit=trm_001_vcr  class=trim  pdk=ihp-sg13g2  testbench=dc_op  corner=tt
** Self-contained deck: testbench + bound params + lowered DUT (.subckt trm_001_vcr).
** PDK corner libs resolve by BARE NAME on the image's ngspice sourcepath — run in a
** PDK-enabled env (the base image / api container), NOT a bare host:
**   docker run --rm -i spicexplorer-spice-base:local \
**     bash -lc 'd=$(mktemp -d) && cat > $d/c.spice && cd $d && ngspice -b c.spice' < raw/trm_001_vcr/ihp-sg13g2/dc_op.spice
*----------------------------------------------------------*
** AUTHORED TEMPLATE — trim/dc_op: DC operating point + supply current of a trim/cal DAC.
** [VALIDATED 2026-07-16 on ihp-sg13g2 against trm_001_vcr — live ngspice].
** Parks the trim code at zero and reports the static supply draw and the trimmed output level.
** Port convention: vdd vcode vout vss. Bindings: DUT PORT_LINE VDD PDK_INCLUDE.
.lib cornerMOSlv.lib mos_tt
.temp 27

.param VDD=1.2

Vdd vdd 0 dc {VDD}
Vss vss 0 dc 0
Vcode vcode 0 dc 0

XDUT vdd vcode vout vss trm_001_vcr

.control
  set filetype=ascii
  op
  let i_supply = abs(i(Vdd))
  let v_out = v(vout)
  print i_supply v_out
  write
  quit
.endc
.param x_dut_r0_value=200k
.param x_dut_xm0_w=2.0u
.param x_dut_xm0_l=0.5u
.param x_dut_xm0_m=1
.subckt trm_001_vcr vdd vcode vout vss
R0 vdd vout x_dut_r0_value
XM0 vout vcode vss vss sg13_lv_nmos l=x_dut_xm0_l m=x_dut_xm0_m w=x_dut_xm0_w
.ends
.end
