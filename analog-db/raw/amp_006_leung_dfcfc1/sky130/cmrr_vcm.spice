** GENERATED by `analog-db export-raw` — DO NOT EDIT.
** circuit=amp_006_leung_dfcfc1  class=amplifier  pdk=sky130  testbench=cmrr_vcm  corner=tt
** Self-contained deck: testbench + bound params + lowered DUT (.subckt amp_006_leung_dfcfc1).
** PDK corner libs resolve by BARE NAME on the image's ngspice sourcepath — run in a
** PDK-enabled env (the base image / api container), NOT a bare host:
**   docker run --rm -i spicexplorer-spice-base:local \
**     bash -lc 'd=$(mktemp -d) && cat > $d/c.spice && cd $d && ngspice -b c.spice' < raw/amp_006_leung_dfcfc1/sky130/cmrr_vcm.spice
*----------------------------------------------------------*
** params: 30 free + 0 frozen knobs (sizing.yaml) · 36 tied · 15 ratio-derived (abstract/params.yaml) · 3 testbench params
** AUTHORED TEMPLATE — amplifier/cmrr_vcm_selfbias (plan D-4/D-5): common-mode rejection
** for self-biased DUTs (no ibias port — the AnalogGym amplifiers). Identical to cmrr_vcm
** except there is no external bias source. The DUT is closed in a unity-gain buffer and the
** SAME 1 V AC rides on both inputs (Vinp ac 1, and the vinn–vout short also ac 1, so
** vinn = vout + vac); the differential input is −vout while the common mode moves by a full
** volt, giving vout ≈ (Acm/Ad)·vac = vac/CMRR and CMRR = −vdb(vout). Reported at FSTART.
** The unity-buffer DC op point is the same one the ac_open_loop_biaswrap bench already
** proves out for these DUTs, so biasing is safe.
** Bindings: DUT PORT_LINE VDD VCM CL FSTART FSTOP PPD PDK_INCLUDE.
.lib sky130.lib.spice tt
.temp 27

.param VDD=1.8
.param VCM=300m
.param CL=10p

Vdd  vdd 0 dc {VDD}          ; supply quiet — isolate the common-mode path
Vss  vss 0 dc 0
CLoad vout 0 {CL}

Vinp vinp 0 dc {VCM} ac 1    ; +1 V AC on the + input ...
Vfb  vinn vout dc 0 ac 1     ; ... and the same +1 V AC lifted onto vinn (unity buffer at DC)

XDUT vss vdd vinn vinp vout amp_006_leung_dfcfc1

.control
  set filetype=ascii
  ac dec 101 1k 1G
  let cmrr = -vdb(vout)
  meas ac cmrr_db FIND cmrr AT=1k
  write
  quit
.endc
.param CAPACITOR_0=1.59665e-11
.param CAPACITOR_1=1.04739e-12
.param CURRENT_0_BIAS=1.53908e-05
.param x_dut_xm7_l=0.774295
.param x_dut_xm7_m=4
.param x_dut_xm7_w=2.84492
.param x_dut_xm11_l=2.47588
.param x_dut_xm11_m=200
.param x_dut_xm11_w=1.50602
.param x_dut_xm12_l=1.00199
.param x_dut_xm12_m=400
.param x_dut_xm12_w=1.00825
.param x_dut_xm16_l=1.17832
.param x_dut_xm16_m=16
.param x_dut_xm16_w=2.46775
.param x_dut_xm20_l=1.56118
.param x_dut_xm15_m=4
.param x_dut_xm20_w=0.954416
.param x_dut_xm22_l=0.426155
.param x_dut_xm22_m=4
.param x_dut_xm22_w=0.861914
.param x_dut_xm24_l=0.617238
.param x_dut_xm24_m=1
.param x_dut_xm24_w=2.97971
.param x_dut_xm25_l=0.513257
.param x_dut_xm25_m=400
.param x_dut_xm25_w=2.49679
.param x_dut_xm10_l=0.798634
.param x_dut_xm10_m=100
.param x_dut_xm10_w=0.586884
* ---- GENERATED parameter ties (abstract/params.yaml groups/ratios) ----
* Each tied symbol is defined exactly once, by its line below; rewrite that
* .param to untie just that symbol (untying = shadowing, plan D-3).
.param x_dut_xm6_w = {x_dut_xm7_w}
.param x_dut_xm5_w = {x_dut_xm7_w}
.param x_dut_xm4_w = {x_dut_xm7_w}
.param x_dut_xm3_w = {x_dut_xm7_w}
.param x_dut_xm2_w = {x_dut_xm7_w}
.param x_dut_xm8_w = {x_dut_xm7_w}
.param x_dut_xm1_w = {x_dut_xm7_w}
.param x_dut_xm0_w = {x_dut_xm7_w}
.param x_dut_xm6_l = {x_dut_xm7_l}
.param x_dut_xm5_l = {x_dut_xm7_l}
.param x_dut_xm4_l = {x_dut_xm7_l}
.param x_dut_xm3_l = {x_dut_xm7_l}
.param x_dut_xm2_l = {x_dut_xm7_l}
.param x_dut_xm8_l = {x_dut_xm7_l}
.param x_dut_xm1_l = {x_dut_xm7_l}
.param x_dut_xm0_l = {x_dut_xm7_l}
.param x_dut_xm9_w = {x_dut_xm10_w}
.param x_dut_xm9_l = {x_dut_xm10_l}
.param x_dut_xm9_m = {x_dut_xm10_m}
.param x_dut_xm23_w = {x_dut_xm22_w}
.param x_dut_xm23_l = {x_dut_xm22_l}
.param x_dut_xm23_m = {x_dut_xm22_m}
.param x_dut_xm21_w = {x_dut_xm20_w}
.param x_dut_xm18_w = {x_dut_xm20_w}
.param x_dut_xm15_w = {x_dut_xm20_w}
.param x_dut_xm13_w = {x_dut_xm20_w}
.param x_dut_xm19_w = {x_dut_xm20_w}
.param x_dut_xm14_w = {x_dut_xm20_w}
.param x_dut_xm21_l = {x_dut_xm20_l}
.param x_dut_xm18_l = {x_dut_xm20_l}
.param x_dut_xm15_l = {x_dut_xm20_l}
.param x_dut_xm13_l = {x_dut_xm20_l}
.param x_dut_xm19_l = {x_dut_xm20_l}
.param x_dut_xm14_l = {x_dut_xm20_l}
.param x_dut_xm17_w = {x_dut_xm16_w}
.param x_dut_xm17_l = {x_dut_xm16_l}
.param x_dut_xm6_m = {x_dut_xm7_m*1}
.param x_dut_xm5_m = {x_dut_xm7_m*1}
.param x_dut_xm4_m = {x_dut_xm7_m*2}
.param x_dut_xm3_m = {x_dut_xm7_m*1}
.param x_dut_xm2_m = {x_dut_xm7_m*1}
.param x_dut_xm8_m = {x_dut_xm7_m*1}
.param x_dut_xm1_m = {x_dut_xm7_m*1}
.param x_dut_xm0_m = {x_dut_xm7_m*1}
.param x_dut_xm17_m = {x_dut_xm16_m*1}
.param x_dut_xm20_m = {x_dut_xm15_m*8}
.param x_dut_xm21_m = {x_dut_xm15_m*8}
.param x_dut_xm18_m = {x_dut_xm15_m*4}
.param x_dut_xm13_m = {x_dut_xm15_m*4}
.param x_dut_xm19_m = {x_dut_xm15_m*4}
.param x_dut_xm14_m = {x_dut_xm15_m*4}
.subckt amp_006_leung_dfcfc1 vss vdd vinn vinp vout
C0 net050 VOUT 'CAPACITOR_0'
C1 net049 net1 'CAPACITOR_1'
I0 net013 vss 'CURRENT_0_BIAS'
XM0 net013 net013 vdd vdd sky130_fd_pr__pfet_01v8 l=x_dut_xm0_l m=x_dut_xm0_m w=x_dut_xm0_w
XM1 VB4 net013 vdd vdd sky130_fd_pr__pfet_01v8 l=x_dut_xm1_l m=x_dut_xm1_m w=x_dut_xm1_w
XM10 net063 VINP net31 net31 sky130_fd_pr__pfet_01v8 l=x_dut_xm10_l m=x_dut_xm10_m w=x_dut_xm10_w
XM11 net043 net050 vdd vdd sky130_fd_pr__pfet_01v8 l=x_dut_xm11_l m=x_dut_xm11_m w=x_dut_xm11_w
XM12 VOUT net050 vdd vdd sky130_fd_pr__pfet_01v8 l=x_dut_xm12_l m=x_dut_xm12_m w=x_dut_xm12_w
XM13 VB4 VB3 net54 vss sky130_fd_pr__nfet_01v8 l=x_dut_xm13_l m=x_dut_xm13_m w=x_dut_xm13_w
XM14 DM_1 VB3 net56 vss sky130_fd_pr__nfet_01v8 l=x_dut_xm14_l m=x_dut_xm14_m w=x_dut_xm14_w
XM15 VB3 VB3 vss vss sky130_fd_pr__nfet_01v8 l=x_dut_xm15_l m=x_dut_xm15_m w=x_dut_xm15_w
XM16 VOUTN VB3 DM_2 vss sky130_fd_pr__nfet_01v8 l=x_dut_xm16_l m=x_dut_xm16_m w=x_dut_xm16_w
XM17 net050 VB3 net063 vss sky130_fd_pr__nfet_01v8 l=x_dut_xm17_l m=x_dut_xm17_m w=x_dut_xm17_w
XM18 net54 VB4 vss vss sky130_fd_pr__nfet_01v8 l=x_dut_xm18_l m=x_dut_xm18_m w=x_dut_xm18_w
XM19 net56 VB4 vss vss sky130_fd_pr__nfet_01v8 l=x_dut_xm19_l m=x_dut_xm19_m w=x_dut_xm19_w
XM2 DM_1 net013 vdd vdd sky130_fd_pr__pfet_01v8 l=x_dut_xm2_l m=x_dut_xm2_m w=x_dut_xm2_w
XM20 DM_2 VB4 vss vss sky130_fd_pr__nfet_01v8 l=x_dut_xm20_l m=x_dut_xm20_m w=x_dut_xm20_w
XM21 net063 VB4 vss vss sky130_fd_pr__nfet_01v8 l=x_dut_xm21_l m=x_dut_xm21_m w=x_dut_xm21_w
XM22 net043 net043 vss vss sky130_fd_pr__nfet_01v8 l=x_dut_xm22_l m=x_dut_xm22_m w=x_dut_xm22_w
XM23 net049 net043 vss vss sky130_fd_pr__nfet_01v8 l=x_dut_xm23_l m=x_dut_xm23_m w=x_dut_xm23_w
XM24 net1 net049 vss vss sky130_fd_pr__nfet_01v8 l=x_dut_xm24_l m=x_dut_xm24_m w=x_dut_xm24_w
XM25 VOUT net049 vss vss sky130_fd_pr__nfet_01v8 l=x_dut_xm25_l m=x_dut_xm25_m w=x_dut_xm25_w
XM3 VB3 net013 vdd vdd sky130_fd_pr__pfet_01v8 l=x_dut_xm3_l m=x_dut_xm3_m w=x_dut_xm3_w
XM4 net31 net013 vdd vdd sky130_fd_pr__pfet_01v8 l=x_dut_xm4_l m=x_dut_xm4_m w=x_dut_xm4_w
XM5 VOUTN VOUTN vdd vdd sky130_fd_pr__pfet_01v8 l=x_dut_xm5_l m=x_dut_xm5_m w=x_dut_xm5_w
XM6 net050 VOUTN vdd vdd sky130_fd_pr__pfet_01v8 l=x_dut_xm6_l m=x_dut_xm6_m w=x_dut_xm6_w
XM7 net049 net013 vdd vdd sky130_fd_pr__pfet_01v8 l=x_dut_xm7_l m=x_dut_xm7_m w=x_dut_xm7_w
XM8 net1 net013 vdd vdd sky130_fd_pr__pfet_01v8 l=x_dut_xm8_l m=x_dut_xm8_m w=x_dut_xm8_w
XM9 DM_2 VINN net31 net31 sky130_fd_pr__pfet_01v8 l=x_dut_xm9_l m=x_dut_xm9_m w=x_dut_xm9_w
.ends
.end
