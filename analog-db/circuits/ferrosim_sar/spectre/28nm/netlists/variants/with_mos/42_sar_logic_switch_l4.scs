// Library name: SAR_11B_ZZS
// Cell name: L4_LOGIC_SWI
// View name: schematic
// Inherited view list: spectre cmos_sch cmos.sch schematic veriloga ahdl
// pspice dspf
subckt L4_LOGIC_SWI CLKS CMPCK DCMPN DCMPP DCTRLN\<11\> DCTRLN\<10\> \
        DCTRLN\<9\> DCTRLN\<8\> DCTRLN\<7\> DCTRLN\<6\> DCTRLN\<5\> \
        DCTRLN\<4\> DCTRLN\<3\> DCTRLN\<2\> DCTRLN\<1\> DCTRLN\<0\> \
        DCTRLP\<11\> DCTRLP\<10\> DCTRLP\<9\> DCTRLP\<8\> DCTRLP\<7\> \
        DCTRLP\<6\> DCTRLP\<5\> DCTRLP\<4\> DCTRLP\<3\> DCTRLP\<2\> \
        DCTRLP\<1\> DCTRLP\<0\> DOUT\<11\> DOUT\<10\> DOUT\<9\> DOUT\<8\> \
        DOUT\<7\> DOUT\<6\> DOUT\<5\> DOUT\<4\> DOUT\<3\> DOUT\<2\> \
        DOUT\<1\> DOUT\<0\> RSTP VBOTN\<11\> VBOTN\<10\> VBOTN\<9\> \
        VBOTN\<8\> VBOTN\<7\> VBOTN\<6\> VBOTN\<5\> VBOTN\<4\> VBOTN\<3\> \
        VBOTN\<2\> VBOTN\<1\> VBOTP\<11\> VBOTP\<10\> VBOTP\<9\> \
        VBOTP\<8\> VBOTP\<7\> VBOTP\<6\> VBOTP\<5\> VBOTP\<4\> VBOTP\<3\> \
        VBOTP\<2\> VBOTP\<1\> VDD VREFN VREFP VSS
    I1 (DCTRLN\<11\> DCTRLN\<10\> DCTRLN\<9\> DCTRLN\<8\> DCTRLN\<7\> \
        DCTRLN\<6\> DCTRLN\<5\> DCTRLN\<4\> DCTRLN\<3\> DCTRLN\<2\> \
        DCTRLN\<1\> VBOTN\<11\> VBOTN\<10\> VBOTN\<9\> VBOTN\<8\> \
        VBOTN\<7\> VBOTN\<6\> VBOTN\<5\> VBOTN\<4\> VBOTN\<3\> VBOTN\<2\> \
        VBOTN\<1\> VDD VREFN VREFP VSS) L5_DAC_SWI
    I0 (DCTRLP\<11\> DCTRLP\<10\> DCTRLP\<9\> DCTRLP\<8\> DCTRLP\<7\> \
        DCTRLP\<6\> DCTRLP\<5\> DCTRLP\<4\> DCTRLP\<3\> DCTRLP\<2\> \
        DCTRLP\<1\> VBOTP\<11\> VBOTP\<10\> VBOTP\<9\> VBOTP\<8\> \
        VBOTP\<7\> VBOTP\<6\> VBOTP\<5\> VBOTP\<4\> VBOTP\<3\> VBOTP\<2\> \
        VBOTP\<1\> VDD VREFN VREFP VSS) L5_DAC_SWI
    I25 (net6 GATE STOP VDD VSS) ND2D0BWP12T30P140
    I2 (DCMPP DCMPN net2 VDD VSS) ND2D0BWP12T30P140
    I24 (net7 RDYLSB GATE VDD VSS) NR2D0BWP12T30P140
    I9 (CLKS GATE net7 VDD VSS) NR2D0BWP12T30P140
    I4 (net2 STOP net3 VDD VSS) NR2D0BWP12T30P140
    I35 (net5 DCTRLP\<11\> VDD VSS) INVD4BWP12T30P140
    I36 (net8 DCTRLN\<11\> VDD VSS) INVD4BWP12T30P140
    I5 (net3 net4 VDD VSS) BUFFD0BWP12T30P140
    I13 (net1 RSTN VDD VSS) BUFFD2BWP12T30P140
    I6 (net4 CMPCK VDD VSS) BUFFD2BWP12T30P140
    I3 (net2 VALID VDD VSS) BUFFD2BWP12T30P140
    I39\<36\> (VDD VSS) DCAP4BWP12T30P140
    I39\<35\> (VDD VSS) DCAP4BWP12T30P140
    I39\<34\> (VDD VSS) DCAP4BWP12T30P140
    I39\<33\> (VDD VSS) DCAP4BWP12T30P140
    I39\<32\> (VDD VSS) DCAP4BWP12T30P140
    I39\<31\> (VDD VSS) DCAP4BWP12T30P140
    I39\<30\> (VDD VSS) DCAP4BWP12T30P140
    I39\<29\> (VDD VSS) DCAP4BWP12T30P140
    I39\<28\> (VDD VSS) DCAP4BWP12T30P140
    I39\<27\> (VDD VSS) DCAP4BWP12T30P140
    I39\<26\> (VDD VSS) DCAP4BWP12T30P140
    I39\<25\> (VDD VSS) DCAP4BWP12T30P140
    I39\<24\> (VDD VSS) DCAP4BWP12T30P140
    I39\<23\> (VDD VSS) DCAP4BWP12T30P140
    I39\<22\> (VDD VSS) DCAP4BWP12T30P140
    I39\<21\> (VDD VSS) DCAP4BWP12T30P140
    I39\<20\> (VDD VSS) DCAP4BWP12T30P140
    I39\<19\> (VDD VSS) DCAP4BWP12T30P140
    I39\<18\> (VDD VSS) DCAP4BWP12T30P140
    I39\<17\> (VDD VSS) DCAP4BWP12T30P140
    I39\<16\> (VDD VSS) DCAP4BWP12T30P140
    I39\<15\> (VDD VSS) DCAP4BWP12T30P140
    I39\<14\> (VDD VSS) DCAP4BWP12T30P140
    I39\<13\> (VDD VSS) DCAP4BWP12T30P140
    I39\<12\> (VDD VSS) DCAP4BWP12T30P140
    I39\<11\> (VDD VSS) DCAP4BWP12T30P140
    I39\<10\> (VDD VSS) DCAP4BWP12T30P140
    I39\<9\> (VDD VSS) DCAP4BWP12T30P140
    I39\<8\> (VDD VSS) DCAP4BWP12T30P140
    I39\<7\> (VDD VSS) DCAP4BWP12T30P140
    I39\<6\> (VDD VSS) DCAP4BWP12T30P140
    I39\<5\> (VDD VSS) DCAP4BWP12T30P140
    I39\<4\> (VDD VSS) DCAP4BWP12T30P140
    I39\<3\> (VDD VSS) DCAP4BWP12T30P140
    I39\<2\> (VDD VSS) DCAP4BWP12T30P140
    I39\<1\> (VDD VSS) DCAP4BWP12T30P140
    I37\<4\> (VDD VSS) DCAP4BWP12T30P140
    I37\<3\> (VDD VSS) DCAP4BWP12T30P140
    I37\<2\> (VDD VSS) DCAP4BWP12T30P140
    I37\<1\> (VDD VSS) DCAP4BWP12T30P140
    I8 (CLKS net6 VDD VSS) INVD0BWP12T30P140
    I12 (net1 RSTP VDD VSS) INVD2BWP12T30P140
    I11 (CLKS net7 net1 VDD VSS) NR2D1BWP12T30P140
    I_LATCH_CELL\<10\> (DCMPN DCMPP DCTRLN\<10\> DNB\<10\> DCTRLP\<10\> \
        DPB\<10\> ENB_NEXT\<9\> ENB_NEXT\<10\> RSTN VALID VDD VSS) \
        L5_LATCH_CELL
    I_LATCH_CELL\<9\> (DCMPN DCMPP DCTRLN\<9\> DNB\<9\> DCTRLP\<9\> \
        DPB\<9\> ENB_NEXT\<8\> ENB_NEXT\<9\> RSTN VALID VDD VSS) \
        L5_LATCH_CELL
    I_LATCH_CELL\<8\> (DCMPN DCMPP DCTRLN\<8\> DNB\<8\> DCTRLP\<8\> \
        DPB\<8\> ENB_NEXT\<7\> ENB_NEXT\<8\> RSTN VALID VDD VSS) \
        L5_LATCH_CELL
    I_LATCH_CELL\<7\> (DCMPN DCMPP DCTRLN\<7\> DNB\<7\> DCTRLP\<7\> \
        DPB\<7\> ENB_NEXT\<6\> ENB_NEXT\<7\> RSTN VALID VDD VSS) \
        L5_LATCH_CELL
    I_LATCH_CELL\<6\> (DCMPN DCMPP DCTRLN\<6\> DNB\<6\> DCTRLP\<6\> \
        DPB\<6\> ENB_NEXT\<5\> ENB_NEXT\<6\> RSTN VALID VDD VSS) \
        L5_LATCH_CELL
    I_LATCH_CELL\<5\> (DCMPN DCMPP DCTRLN\<5\> DNB\<5\> DCTRLP\<5\> \
        DPB\<5\> ENB_NEXT\<4\> ENB_NEXT\<5\> RSTN VALID VDD VSS) \
        L5_LATCH_CELL
    I_LATCH_CELL\<4\> (DCMPN DCMPP DCTRLN\<4\> DNB\<4\> DCTRLP\<4\> \
        DPB\<4\> ENB_NEXT\<3\> ENB_NEXT\<4\> RSTN VALID VDD VSS) \
        L5_LATCH_CELL
    I_LATCH_CELL\<3\> (DCMPN DCMPP DCTRLN\<3\> DNB\<3\> DCTRLP\<3\> \
        DPB\<3\> ENB_NEXT\<2\> ENB_NEXT\<3\> RSTN VALID VDD VSS) \
        L5_LATCH_CELL
    I_LATCH_CELL\<2\> (DCMPN DCMPP DCTRLN\<2\> DNB\<2\> DCTRLP\<2\> \
        DPB\<2\> ENB_NEXT\<1\> ENB_NEXT\<2\> RSTN VALID VDD VSS) \
        L5_LATCH_CELL
    I_LATCH_CELL\<1\> (DCMPN DCMPP DCTRLN\<1\> DNB\<1\> DCTRLP\<1\> \
        DPB\<1\> ENB_NEXT\<0\> ENB_NEXT\<1\> RSTN VALID VDD VSS) \
        L5_LATCH_CELL
    I_LATCH_CELL\<11\> (DCMPP DCMPN net8 DNB\<11\> net5 DPB\<11\> \
        ENB_NEXT\<10\> RSTP RSTN VALID VDD VSS) L5_LATCH_CELL
    I_LATCH_CELL\<0\> (DCMPN DCMPP DCTRLN\<0\> DNB\<0\> DCTRLP\<0\> \
        DPB\<0\> ENB_NEXT\<0\> RDYLSB VALID VDD VSS) L5_LATCH_CELL_LSB
    I26\<11\> (DCTRLP\<11\> RSTP DOUT\<11\> VDD VSS) DFQD1BWP12T30P140
    I26\<10\> (DCTRLP\<10\> RSTP DOUT\<10\> VDD VSS) DFQD1BWP12T30P140
    I26\<9\> (DCTRLP\<9\> RSTP DOUT\<9\> VDD VSS) DFQD1BWP12T30P140
    I26\<8\> (DCTRLP\<8\> RSTP DOUT\<8\> VDD VSS) DFQD1BWP12T30P140
    I26\<7\> (DCTRLP\<7\> RSTP DOUT\<7\> VDD VSS) DFQD1BWP12T30P140
    I26\<6\> (DCTRLP\<6\> RSTP DOUT\<6\> VDD VSS) DFQD1BWP12T30P140
    I26\<5\> (DCTRLP\<5\> RSTP DOUT\<5\> VDD VSS) DFQD1BWP12T30P140
    I26\<4\> (DCTRLP\<4\> RSTP DOUT\<4\> VDD VSS) DFQD1BWP12T30P140
    I26\<3\> (DCTRLP\<3\> RSTP DOUT\<3\> VDD VSS) DFQD1BWP12T30P140
    I26\<2\> (DCTRLP\<2\> RSTP DOUT\<2\> VDD VSS) DFQD1BWP12T30P140
    I26\<1\> (DCTRLP\<1\> RSTP DOUT\<1\> VDD VSS) DFQD1BWP12T30P140
    I26\<0\> (DCTRLP\<0\> RSTP DOUT\<0\> VDD VSS) DFQD1BWP12T30P140
    I38\<10\> (VDD VSS) DCAP8BWP12T30P140
    I38\<9\> (VDD VSS) DCAP8BWP12T30P140
    I38\<8\> (VDD VSS) DCAP8BWP12T30P140
    I38\<7\> (VDD VSS) DCAP8BWP12T30P140
    I38\<6\> (VDD VSS) DCAP8BWP12T30P140
    I38\<5\> (VDD VSS) DCAP8BWP12T30P140
    I38\<4\> (VDD VSS) DCAP8BWP12T30P140
    I38\<3\> (VDD VSS) DCAP8BWP12T30P140
    I38\<2\> (VDD VSS) DCAP8BWP12T30P140
    I38\<1\> (VDD VSS) DCAP8BWP12T30P140
ends L4_LOGIC_SWI
// End of subcircuit definition.
