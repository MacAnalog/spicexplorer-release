** GENERATED by `analog-db export-raw` — DO NOT EDIT.
** circuit=ldo_007_pmos  class=ldo  pdk=ihp-sg13g2  testbench=tran_load_step  corner=tt
** Self-contained deck: testbench + bound params + lowered DUT (.subckt ldo_007_pmos).
** PDK corner libs resolve by BARE NAME on the image's ngspice sourcepath — run in a
** PDK-enabled env (the base image / api container), NOT a bare host:
**   docker run --rm -i spicexplorer-spice-base:local \
**     bash -lc 'd=$(mktemp -d) && cat > $d/c.spice && cd $d && ngspice -b c.spice' < raw/ldo_007_pmos/ihp-sg13g2/tran_load_step.spice
*----------------------------------------------------------*
** params: 16 free + 0 frozen knobs (sizing.yaml) · 6 tied · 0 ratio-derived (abstract/params.yaml) · 1 testbench params
** AUTHORED TEMPLATE — ldo/tran_load_step: fast lo->hi load step into Cout; undershoot + recovery.
** Bindings: DUT PORT_LINE VDD COUT ILOAD_LO ILOAD_HI TSTART TEDGE TPULSE TPER TSTEP TSTOP VTOL
**   PDK_INCLUDE.
.lib cornerMOSlv.lib mos_tt
.lib cornerRES.lib res_typ
.temp 27

.param VDD=1.8

Vdd  vdd 0 dc {VDD}
Vss  vss 0 dc 0
CLoad vout 0 1u
Iload vout 0 pulse(1m 10m 5u 10n 10n 20u 40u)

XDUT vdd vout vss ldo_007_pmos

.control
  set filetype=ascii
  tran 50n 30u
  meas tran vout_min  MIN  v(vout) from=5u to=30u
  meas tran vout_post FIND v(vout) AT=30u
  let v_undershoot = vout_post - vout_min
  * recovery: time after the step for v(vout) to re-enter the +/-VTOL band around its final value
  let verr = abs(v(vout) - vout_post)
  meas tran tcross WHEN verr=1m FALL=LAST
  let t_transient = tcross - 5u
  print v_undershoot t_transient
  write
  quit
.endc
.param x_dut_xmp_w=10u
.param x_dut_xmp_m=20
.param x_dut_xmp_l=0.5u
.param x_dut_xm1_w=4u
.param x_dut_xm1_l=0.5u
.param x_dut_xm3_w=4u
.param x_dut_xm3_l=0.5u
.param x_dut_xm6_w=4u
.param x_dut_xm6_l=1.0u
.param r_top=100k
.param r_bot=100k
.param c_ff=60p
.param c_comp=0.05p
.param r_z=1
.param vref_val=0.6
.param i_tail=200u
* ---- GENERATED parameter ties (abstract/params.yaml groups/ratios) ----
* Each tied symbol is defined exactly once, by its line below; rewrite that
* .param to untie just that symbol (untying = shadowing, plan D-3).
.param x_dut_xm2_w = {x_dut_xm1_w}
.param x_dut_xm2_l = {x_dut_xm1_l}
.param x_dut_xm4_w = {x_dut_xm3_w}
.param x_dut_xm4_l = {x_dut_xm3_l}
.param x_dut_xm5_w = {x_dut_xm6_w}
.param x_dut_xm5_l = {x_dut_xm6_l}
.subckt ldo_007_pmos vdd vout vss
CC ncz vout 'c_comp'
CFF vout fb 'c_ff'
IBIAS vdd ebias dc {i_tail}
R1 vout fb 'r_top'
R2 fb vss 'r_bot'
RZ egate ncz 'r_z'
VREF vref vss dc {vref_val}
XM1 noutm fb etail vss sg13_lv_nmos l=x_dut_xm1_l w=x_dut_xm1_w
XM2 egate vref etail vss sg13_lv_nmos l=x_dut_xm2_l w=x_dut_xm2_w
XM3 noutm noutm vdd vdd sg13_lv_pmos l=x_dut_xm3_l w=x_dut_xm3_w
XM4 egate noutm vdd vdd sg13_lv_pmos l=x_dut_xm4_l w=x_dut_xm4_w
XM5 etail ebias vss vss sg13_lv_nmos l=x_dut_xm5_l w=x_dut_xm5_w
XM6 ebias ebias vss vss sg13_lv_nmos l=x_dut_xm6_l w=x_dut_xm6_w
XMP vout egate vdd vdd sg13_lv_pmos l=x_dut_xmp_l m=x_dut_xmp_m w=x_dut_xmp_w
.ends
.end
