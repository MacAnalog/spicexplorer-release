** GENERATED by `analog-db export-raw` — DO NOT EDIT.
** circuit=ldo_010_capless_lowiq  class=ldo  pdk=ihp-sg13g2  testbench=loop_stability  corner=tt
** Self-contained deck: testbench + bound params + lowered DUT (.subckt ldo_010_capless_lowiq).
** PDK corner libs resolve by BARE NAME on the image's ngspice sourcepath — run in a
** PDK-enabled env (the base image / api container), NOT a bare host:
**   docker run --rm -i spicexplorer-spice-base:local \
**     bash -lc 'd=$(mktemp -d) && cat > $d/c.spice && cd $d && ngspice -b c.spice' < raw/ldo_010_capless_lowiq/ihp-sg13g2/loop_stability.spice
*----------------------------------------------------------*
** params: 33 free + 0 frozen knobs (sizing.yaml) · 0 tied · 0 ratio-derived (abstract/params.yaml) · 1 testbench params
** AUTHORED TEMPLATE — ldo/loop_stability: closed-loop output-impedance peaking (stability proxy).
** Drive an AC current of 1 A into vout; v(vout) = Zout(f). A resonant peak above the DC value =
** ringing / low phase margin. This is the honest stability metric reachable from the
** [vdd,vout,vss] ports — a true loop-gain phase margin needs an internal loop-break node (a future
** ac_loopgain probe), since this LDO's regulation loop is entirely inside the subckt.
** Bindings: DUT PORT_LINE VDD ILOAD COUT PPD FSTART FSTOP PDK_INCLUDE.
.lib cornerMOSlv.lib mos_tt
.lib cornerRES.lib res_typ
.lib cornerCAP.lib cap_typ
.temp 27

.param VDD=1.5

Vdd  vdd 0 dc {VDD}
Vss  vss 0 dc 0
Iload vout 0 dc 1m
CLoad vout 0 1p
Iac  vout 0 dc 0 ac 1

XDUT vdd vout vss ldo_010_capless_lowiq

.control
  set filetype=ascii
  ac dec 20 10 100meg
  meas ac zout_dc  FIND vdb(vout) AT=10
  meas ac zout_max MAX  vdb(vout)
  let zout_peak_db = zout_max - zout_dc
  print zout_peak_db
  write
  quit
.endc
.param vref_val=0.6
.param r_w=0.5u
.param r_fb_l=340u
.param c_ff_w=8u
.param r_bias_l=138.5u
.param x_dut_xmb0_w=1u
.param x_dut_xmb0_l=1u
.param x_dut_xmb1_w=1.39u
.param x_dut_xmbp_w=10u
.param x_dut_xmbp_l=1u
.param x_dut_xmt_w=10u
.param x_dut_xm1_w=9.53u
.param x_dut_xm1_l=0.5u
.param x_dut_xm3_w=2.95u
.param x_dut_xm3_l=1u
.param x_dut_xm5_w=2.42u
.param x_dut_xm5_l=0.5u
.param x_dut_xm6_w=5.53u
.param c_comp_w=54u
.param x_dut_xmc_w=15.76u
.param x_dut_xmc_l=0.36u
.param x_dut_xma_w=5.79u
.param x_dut_xma_l=0.5u
.param x_dut_xmcp_w=9.02u
.param x_dut_xmcp_l=0.5u
.param x_dut_xms_w=2.2u
.param x_dut_xms_l=0.95u
.param x_dut_xmp_w=10u
.param x_dut_xmp_l=0.13u
.param x_dut_xmp_m=19
.param x_dut_xmp_nf_mult=4
.param c_out_w=58u
.param c_out_m=4
.subckt ldo_010_capless_lowiq vdd vout vss
VLP lp_brk vout dc 0
VREF vref vss dc {vref_val}
XCC ea_out ea_o1 cap_cmim l=c_comp_w w=c_comp_w
XCFF lp_brk fb cap_cmim l=c_ff_w w=c_ff_w
XCOUT vout vss cap_cmim l=c_out_w m=c_out_m w=c_out_w
XM1A ea_n fb ea_tail vdd sg13_lv_pmos l=x_dut_xm1_l w={x_dut_xm1_w/2}
XM1B ea_n fb ea_tail vdd sg13_lv_pmos l=x_dut_xm1_l w={x_dut_xm1_w/2}
XM2A ea_o1 vref ea_tail vdd sg13_lv_pmos l=x_dut_xm1_l w={x_dut_xm1_w/2}
XM2B ea_o1 vref ea_tail vdd sg13_lv_pmos l=x_dut_xm1_l w={x_dut_xm1_w/2}
XM3A ea_n ea_n vss vss sg13_lv_nmos l=x_dut_xm3_l w={x_dut_xm3_w/2}
XM3B ea_n ea_n vss vss sg13_lv_nmos l=x_dut_xm3_l w={x_dut_xm3_w/2}
XM4A ea_o1 ea_n vss vss sg13_lv_nmos l=x_dut_xm3_l w={x_dut_xm3_w/2}
XM4B ea_o1 ea_n vss vss sg13_lv_nmos l=x_dut_xm3_l w={x_dut_xm3_w/2}
XM5 ea_out ea_o1 vss vss sg13_lv_nmos l=x_dut_xm5_l w=x_dut_xm5_w
XM6 ea_out pbias vdd vdd sg13_lv_pmos l=x_dut_xmbp_l w=x_dut_xm6_w
XMA x1 x1 vss vss sg13_lv_nmos l=x_dut_xma_l w=x_dut_xma_w
XMB y x1 vss vss sg13_lv_nmos l=x_dut_xma_l w=x_dut_xma_w
XMB0A nbias nbias vss vss sg13_lv_nmos l=x_dut_xmb0_l w={x_dut_xmb0_w/2}
XMB0B nbias nbias vss vss sg13_lv_nmos l=x_dut_xmb0_l w={x_dut_xmb0_w/2}
XMB1A pbias nbias vss vss sg13_lv_nmos l=x_dut_xmb0_l w={x_dut_xmb1_w/2}
XMB1B pbias nbias vss vss sg13_lv_nmos l=x_dut_xmb0_l w={x_dut_xmb1_w/2}
XMBP pbias pbias vdd vdd sg13_lv_pmos l=x_dut_xmbp_l w=x_dut_xmbp_w
XMC x1 ea_out vout vdd sg13_lv_pmos l=x_dut_xmc_l w=x_dut_xmc_w
XMCP y y vdd vdd sg13_lv_pmos l=x_dut_xmcp_l w=x_dut_xmcp_w
XMD gate y vdd vdd sg13_lv_pmos l=x_dut_xmcp_l w=x_dut_xmcp_w
XMP vout gate vdd vdd sg13_lv_pmos l=x_dut_xmp_l m={x_dut_xmp_m*x_dut_xmp_nf_mult} w={x_dut_xmp_w/x_dut_xmp_nf_mult}
XMSA gate nbias vss vss sg13_lv_nmos l=x_dut_xms_l w={x_dut_xms_w/2}
XMSB gate nbias vss vss sg13_lv_nmos l=x_dut_xms_l w={x_dut_xms_w/2}
XMT ea_tail pbias vdd vdd sg13_lv_pmos l=x_dut_xmbp_l w=x_dut_xmt_w
XR1_1 lp_brk n_r1_1 vss rhigh l={r_fb_l/8} w=r_w
XR1_2 n_r1_1 n_r1_2 vss rhigh l={r_fb_l/8} w=r_w
XR1_3 n_r1_2 n_r1_3 vss rhigh l={r_fb_l/8} w=r_w
XR1_4 n_r1_3 n_r1_4 vss rhigh l={r_fb_l/8} w=r_w
XR1_5 n_r1_4 n_r1_5 vss rhigh l={r_fb_l/8} w=r_w
XR1_6 n_r1_5 n_r1_6 vss rhigh l={r_fb_l/8} w=r_w
XR1_7 n_r1_6 n_r1_7 vss rhigh l={r_fb_l/8} w=r_w
XR1_8 n_r1_7 fb vss rhigh l={r_fb_l/8} w=r_w
XR2_1 fb n_r2_1 vss rhigh l={r_fb_l/8} w=r_w
XR2_2 n_r2_1 n_r2_2 vss rhigh l={r_fb_l/8} w=r_w
XR2_3 n_r2_2 n_r2_3 vss rhigh l={r_fb_l/8} w=r_w
XR2_4 n_r2_3 n_r2_4 vss rhigh l={r_fb_l/8} w=r_w
XR2_5 n_r2_4 n_r2_5 vss rhigh l={r_fb_l/8} w=r_w
XR2_6 n_r2_5 n_r2_6 vss rhigh l={r_fb_l/8} w=r_w
XR2_7 n_r2_6 n_r2_7 vss rhigh l={r_fb_l/8} w=r_w
XR2_8 n_r2_7 vss vss rhigh l={r_fb_l/8} w=r_w
XRB_1 vdd n_rb_1 vss rhigh l={r_bias_l/5} w=r_w
XRB_2 n_rb_1 n_rb_2 vss rhigh l={r_bias_l/5} w=r_w
XRB_3 n_rb_2 n_rb_3 vss rhigh l={r_bias_l/5} w=r_w
XRB_4 n_rb_3 n_rb_4 vss rhigh l={r_bias_l/5} w=r_w
XRB_5 n_rb_4 nbias vss rhigh l={r_bias_l/5} w=r_w
.ends
.end
