** GENERATED by `analog-db export-raw` — DO NOT EDIT.
** Standalone lowered DUT subckt for sw_001_transmission_gate_pair on ihp-sg13g2 (sizing .param defaults + .subckt).
** Not a runnable deck on its own — include it under your own testbench:
**   .include _dut.spice
**   XDUT port_a port_b vctl vctl_not vdd vss sw_001_transmission_gate_pair
** Source: pdk/ihp-sg13g2/netlist.spice (run `analog-db generate` to refresh).
*----------------------------------------------------------*
** params: 4 free + 2 frozen knobs (sizing.yaml) · 0 tied · 0 ratio-derived (abstract/params.yaml)
.param x_dut_xm1_w=2u
.param x_dut_xm1_l=0.13u
.param x_dut_xm2_w=2u
.param x_dut_xm2_l=0.13u
.param x_dut_xm1_m=1
.param x_dut_xm2_m=1
.subckt sw_001_transmission_gate_pair port_a port_b vctl vctl_not vdd vss
XM1 port_a vctl port_b vss sg13_lv_nmos l=x_dut_xm1_l m=x_dut_xm1_m w=x_dut_xm1_w
XM2 port_b vctl_not port_a vdd sg13_lv_pmos l=x_dut_xm2_l m=x_dut_xm2_m w=x_dut_xm2_w
.ends
