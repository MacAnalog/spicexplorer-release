** GENERATED by `analog-db export-raw` — DO NOT EDIT.
** Standalone lowered DUT subckt for amp_025_hsu_classab_ota on gf180mcu (sizing .param defaults + .subckt).
** Not a runnable deck on its own — include it under your own testbench:
**   .include _dut.spice
**   XDUT vinp vinn voutp voutn vdd vss amp_025_hsu_classab_ota
** Source: pdk/gf180mcu/netlist.spice (run `analog-db generate` to refresh).
*----------------------------------------------------------*
** params: 37 free + 13 frozen knobs (sizing.yaml) · 40 tied · 0 ratio-derived (abstract/params.yaml)
.param x_dut_xm1_w=7.405900617179218e-05
.param x_dut_xm1_l=1.4942219109077382e-06
.param x_dut_xm2_w=4.224769892751694e-05
.param x_dut_xm2_l=7.836252010033421e-07
.param x_dut_xm4_w=4.433207090443811e-05
.param x_dut_xm4_l=1.8882963820193335e-06
.param x_dut_xm6_w=6.725601408797579e-05
.param x_dut_xm7_w=7.994902016037676e-05
.param x_dut_xm7_l=4.0171227085261276e-06
.param x_dut_xm10_w=9.154569342390096e-05
.param x_dut_xm10_l=4.425675437680103e-07
.param x_dut_xm12_w=6.376119922680826e-05
.param x_dut_xm12_l=5.1601981813763615e-06
.param x_dut_xm14_w=3.175210344952914e-05
.param x_dut_xm14_l=2.9456322861989035e-06
.param x_dut_xm15_w=1.3303173547807155e-05
.param x_dut_xm15_l=4.957421066690619e-06
.param x_dut_xm16_w=7.272355654376196e-05
.param x_dut_xm16_l=3.2801948971919796e-06
.param x_dut_xm17_w=4.219211972147813e-05
.param x_dut_xm17_l=3.6844329159981194e-06
.param x_dut_xm18_w=8.119835138066467e-05
.param x_dut_xm18_l=8.345381157988775e-07
.param x_dut_xm19_w=7.871381657408037e-05
.param x_dut_xm19_l=1.167370557193746e-06
.param x_dut_c1_value=7.70358689652628e-12
.param x_dut_r1_value=151727.76379597475
.param x_dut_rmp_value=80250132.35155667
.param gm_val=100u
.param rout_val=743494741.5878987
.param rin_val=4372027780056.602
.param cout_val=6.438256926093228e-12
.param cin_val=9.961581907473704e-13
.param vb1=2.2
.param vb2=1.9
.param vb3=1.3
.param vcmfb_ref=1.65
.param x_dut_xm1_m=1
.param x_dut_xm2_m=1
.param x_dut_xm4_m=1
.param x_dut_xm6_m=1
.param x_dut_xm7_m=1
.param x_dut_xm10_m=1
.param x_dut_xm12_m=1
.param x_dut_xm14_m=1
.param x_dut_xm15_m=1
.param x_dut_xm16_m=1
.param x_dut_xm17_m=1
.param x_dut_xm18_m=1
.param x_dut_xm19_m=1
* ---- GENERATED parameter ties (abstract/params.yaml groups/ratios) ----
* Each tied symbol is defined exactly once, by its line below; rewrite that
* .param to untie just that symbol (untying = shadowing, plan D-3).
.param x_dut_xm3_w = {x_dut_xm2_w}
.param x_dut_xm3_l = {x_dut_xm2_l}
.param x_dut_xm3_m = {x_dut_xm2_m}
.param x_dut_xm5_w = {x_dut_xm4_w}
.param x_dut_xm5_l = {x_dut_xm4_l}
.param x_dut_xm5_m = {x_dut_xm4_m}
.param x_dut_xm8_l = {x_dut_xm4_l}
.param x_dut_xm6_l = {x_dut_xm5_l}
.param x_dut_xm8_w = {x_dut_xm6_w}
.param x_dut_xm8_m = {x_dut_xm6_m}
.param x_dut_xm9_w = {x_dut_xm7_w}
.param x_dut_xm9_l = {x_dut_xm7_l}
.param x_dut_xm9_m = {x_dut_xm7_m}
.param x_dut_xm11_w = {x_dut_xm10_w}
.param x_dut_xm11_l = {x_dut_xm10_l}
.param x_dut_xm11_m = {x_dut_xm10_m}
.param x_dut_xm13_w = {x_dut_xm12_w}
.param x_dut_xm13_l = {x_dut_xm12_l}
.param x_dut_xm13_m = {x_dut_xm12_m}
.param x_dut_xm20_w = {x_dut_xm14_w}
.param x_dut_xm20_l = {x_dut_xm14_l}
.param x_dut_xm20_m = {x_dut_xm14_m}
.param x_dut_xm21_w = {x_dut_xm15_w}
.param x_dut_xm21_l = {x_dut_xm15_l}
.param x_dut_xm21_m = {x_dut_xm15_m}
.param x_dut_xm22_w = {x_dut_xm16_w}
.param x_dut_xm22_l = {x_dut_xm16_l}
.param x_dut_xm22_m = {x_dut_xm16_m}
.param x_dut_xm23_w = {x_dut_xm17_w}
.param x_dut_xm23_l = {x_dut_xm17_l}
.param x_dut_xm23_m = {x_dut_xm17_m}
.param x_dut_xm24_w = {x_dut_xm18_w}
.param x_dut_xm24_l = {x_dut_xm18_l}
.param x_dut_xm24_m = {x_dut_xm18_m}
.param x_dut_xm25_w = {x_dut_xm19_w}
.param x_dut_xm25_l = {x_dut_xm19_l}
.param x_dut_xm25_m = {x_dut_xm19_m}
.param x_dut_c2_value = {x_dut_c1_value}
.param x_dut_r2_value = {x_dut_r1_value}
.param x_dut_rmn_value = {x_dut_rmp_value}
.subckt amp_025_hsu_classab_ota vinp vinn voutp voutn vdd vss
C1 abm_p zc_p 'x_dut_c1_value'
C2 abm_n zc_n 'x_dut_c2_value'
CIN cm_det vcmfb_ref 'cin_val'
COUT vss vcmfb 'cout_val'
GM vss vcmfb vcmfb_ref cm_det {gm_val}
R1 zc_p drv_p 'x_dut_r1_value'
R2 drv_n zc_n 'x_dut_r2_value'
RIN cm_det vcmfb_ref 'rin_val'
RMN voutn cm_det 'x_dut_rmn_value'
RMP cm_det voutp 'x_dut_rmp_value'
ROUT vss vcmfb 'rout_val'
VB1 vb1 vss dc {vb1}
VB2 vb2 vss dc {vb2}
VB3 vb3 vss dc {vb3}
VCMFB_REF vcmfb_ref vss dc {vcmfb_ref}
XM1 tail vb1 vdd vdd pfet_03v3 l=x_dut_xm1_l m=x_dut_xm1_m w=x_dut_xm1_w
XM10 drv_n vb2 psrc_n vdd pfet_03v3 l=x_dut_xm10_l m=x_dut_xm10_m w=x_dut_xm10_w
XM11 drv_p vb2 psrc_p vdd pfet_03v3 l=x_dut_xm11_l m=x_dut_xm11_m w=x_dut_xm11_w
XM12 psrc_n vcmfb vdd vdd pfet_03v3 l=x_dut_xm12_l m=x_dut_xm12_m w=x_dut_xm12_w
XM13 psrc_p vcmfb vdd vdd pfet_03v3 l=x_dut_xm13_l m=x_dut_xm13_m w=x_dut_xm13_w
XM14 gnf_p vb1 vdd vdd pfet_03v3 l=x_dut_xm14_l m=x_dut_xm14_m w=x_dut_xm14_w
XM15 gnf_p gnf_p abm_p vss nfet_03v3 l=x_dut_xm15_l m=x_dut_xm15_m w=x_dut_xm15_w
XM16 vdd gnf_p voutp vss nfet_03v3 l=x_dut_xm16_l m=x_dut_xm16_m w=x_dut_xm16_w
XM17 gpf_p gpf_p abm_p vdd pfet_03v3 l=x_dut_xm17_l m=x_dut_xm17_m w=x_dut_xm17_w
XM18 vss gpf_p voutp vdd pfet_03v3 l=x_dut_xm18_l m=x_dut_xm18_m w=x_dut_xm18_w
XM19 gpf_p drv_p vss vss nfet_03v3 l=x_dut_xm19_l m=x_dut_xm19_m w=x_dut_xm19_w
XM2 mir_p vinn tail vdd pfet_03v3 l=x_dut_xm2_l m=x_dut_xm2_m w=x_dut_xm2_w
XM20 gnf_n vb1 vdd vdd pfet_03v3 l=x_dut_xm20_l m=x_dut_xm20_m w=x_dut_xm20_w
XM21 gnf_n gnf_n abm_n vss nfet_03v3 l=x_dut_xm21_l m=x_dut_xm21_m w=x_dut_xm21_w
XM22 vdd gnf_n voutn vss nfet_03v3 l=x_dut_xm22_l m=x_dut_xm22_m w=x_dut_xm22_w
XM23 gpf_n gpf_n abm_n vdd pfet_03v3 l=x_dut_xm23_l m=x_dut_xm23_m w=x_dut_xm23_w
XM24 vss gpf_n voutn vdd pfet_03v3 l=x_dut_xm24_l m=x_dut_xm24_m w=x_dut_xm24_w
XM25 gpf_n drv_n vss vss nfet_03v3 l=x_dut_xm25_l m=x_dut_xm25_m w=x_dut_xm25_w
XM3 mir_n vinp tail vdd pfet_03v3 l=x_dut_xm3_l m=x_dut_xm3_m w=x_dut_xm3_w
XM4 mir_p mir_p vss vss nfet_03v3 l=x_dut_xm4_l m=x_dut_xm4_m w=x_dut_xm4_w
XM5 mir_n mir_n vss vss nfet_03v3 l=x_dut_xm5_l m=x_dut_xm5_m w=x_dut_xm5_w
XM6 csrc_n mir_n vss vss nfet_03v3 l=x_dut_xm6_l m=x_dut_xm6_m w=x_dut_xm6_w
XM7 drv_n vb3 csrc_n vss nfet_03v3 l=x_dut_xm7_l m=x_dut_xm7_m w=x_dut_xm7_w
XM8 csrc_p mir_p vss vss nfet_03v3 l=x_dut_xm8_l m=x_dut_xm8_m w=x_dut_xm8_w
XM9 drv_p vb3 csrc_p vss nfet_03v3 l=x_dut_xm9_l m=x_dut_xm9_m w=x_dut_xm9_w
.ends
