** GENERATED by `analog-db export-raw` — DO NOT EDIT.
** circuit=ldo_007_pmos  class=ldo  pdk=sky130  testbench=psrr  corner=tt
** Self-contained deck: testbench + bound params + lowered DUT (.subckt ldo_007_pmos).
** PDK corner libs resolve by BARE NAME on the image's ngspice sourcepath — run in a
** PDK-enabled env (the base image / api container), NOT a bare host:
**   docker run --rm -i spicexplorer-spice-base:local \
**     bash -lc 'd=$(mktemp -d) && cat > $d/c.spice && cd $d && ngspice -b c.spice' < raw/ldo_007_pmos/sky130/psrr.spice
*----------------------------------------------------------*
** params: 16 free + 0 frozen knobs (sizing.yaml) · 6 tied · 0 ratio-derived (abstract/params.yaml) · 1 testbench params
** AUTHORED TEMPLATE — ldo/psrr: AC supply rejection (Vdd -> Vout), closed loop.
** Inject AC=1 on the supply; psrr_vdd_db = -vdb(vout) (output rejection in dB). The feedback loop
** stays naturally closed (vout feeds the internal divider), so no loop-break trick is needed.
** Bindings: DUT PORT_LINE VDD ILOAD COUT PPD FSTART FSTOP FMEAS PDK_INCLUDE.
.lib sky130.lib.spice tt
.temp 27

.param VDD=1.8

Vdd  vdd 0 dc {VDD} ac 1
Vss  vss 0 dc 0
Iload vout 0 dc 1m
CLoad vout 0 1u

XDUT vdd vout vss ldo_007_pmos

.control
  set filetype=ascii
  ac dec 20 10 10meg
  meas ac vout_db FIND vdb(vout) AT=1k
  let psrr_vdd_db = 0 - vout_db
  print psrr_vdd_db
  write
  quit
.endc
.param x_dut_xmp_w=50
.param x_dut_xmp_m=48
.param x_dut_xmp_l=0.5
.param x_dut_xm1_w=40
.param x_dut_xm1_l=0.5
.param x_dut_xm3_w=12
.param x_dut_xm3_l=0.5
.param x_dut_xm6_w=4
.param x_dut_xm6_l=1.0
.param r_top=50k
.param r_bot=70k
.param c_ff=30p
.param c_comp=0.05p
.param r_z=1
.param vref_val=0.7
.param i_tail=50u
* ---- GENERATED parameter ties (abstract/params.yaml groups/ratios) ----
* Each tied symbol is defined exactly once, by its line below; rewrite that
* .param to untie just that symbol (untying = shadowing, plan D-3).
.param x_dut_xm2_w = {x_dut_xm1_w}
.param x_dut_xm2_l = {x_dut_xm1_l}
.param x_dut_xm4_w = {x_dut_xm3_w}
.param x_dut_xm4_l = {x_dut_xm3_l}
.param x_dut_xm5_w = {x_dut_xm6_w}
.param x_dut_xm5_l = {x_dut_xm6_l}
.subckt ldo_007_pmos vdd vout vss
CC ncz vout 'c_comp'
CFF lp_brk fb 'c_ff'
IBIAS vdd ebias dc {i_tail}
R1 lp_brk fb 'r_top'
R2 fb vss 'r_bot'
RZ egate ncz 'r_z'
VLP lp_brk vout dc 0
VREF vref vss dc {vref_val}
XM1 noutm fb etail vss sky130_fd_pr__nfet_01v8 l=x_dut_xm1_l w=x_dut_xm1_w
XM2 egate vref etail vss sky130_fd_pr__nfet_01v8 l=x_dut_xm2_l w=x_dut_xm2_w
XM3 noutm noutm vdd vdd sky130_fd_pr__pfet_01v8 l=x_dut_xm3_l w=x_dut_xm3_w
XM4 egate noutm vdd vdd sky130_fd_pr__pfet_01v8 l=x_dut_xm4_l w=x_dut_xm4_w
XM5 etail ebias vss vss sky130_fd_pr__nfet_01v8 l=x_dut_xm5_l w=x_dut_xm5_w
XM6 ebias ebias vss vss sky130_fd_pr__nfet_01v8 l=x_dut_xm6_l w=x_dut_xm6_w
XMP vout egate vdd vdd sky130_fd_pr__pfet_01v8 l=x_dut_xmp_l m=x_dut_xmp_m w=x_dut_xmp_w
.ends
.end
