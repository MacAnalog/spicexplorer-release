** GENERATED by `analog-db export-raw` — DO NOT EDIT.
** circuit=amp_004_folded_cascode  class=amplifier  pdk=sky130  testbench=tran_step  corner=tt
** Self-contained deck: testbench + bound params + lowered DUT (.subckt amp_004_folded_cascode).
** PDK corner libs resolve by BARE NAME on the image's ngspice sourcepath — run in a
** PDK-enabled env (the base image / api container), NOT a bare host:
**   docker run --rm -i spicexplorer-spice-base:local \
**     bash -lc 'd=$(mktemp -d) && cat > $d/c.spice && cd $d && ngspice -b c.spice' < raw/amp_004_folded_cascode/sky130/tran_step.spice
*----------------------------------------------------------*
** params: 16 free + 21 frozen knobs (sizing.yaml) · 21 tied · 0 ratio-derived (abstract/params.yaml) · 5 testbench params
** AUTHORED TEMPLATE — universal/tran_step (plan D-4): unity-gain step → slew + settling.
** Bindings: DUT PORT_LINE VDD VCM IBIAS CL
**   VSTEP TSTEP TSTOP PDK_INCLUDE.
.lib sky130.lib.spice tt
.temp 27

.param VDD=1.8
.param VCM=0.9
.param IBIAS=-34u
.param CL=10p

Vdd  vdd 0 dc {VDD}
Vss  vss 0 dc 0
Ibias vdd ibias dc {IBIAS}
CLoad vout 0 {CL}

* unity-gain follower: vinn shorted to vout (0 V source = ideal feedback wire)
.param VSTEP=0.2
Vinp vinp 0 dc {VCM} pulse({VCM} {VCM+VSTEP} 2u 1n 1n 1 1)
Vfb  vinn vout dc 0

XDUT vinn vinp vout vdd ibias vss amp_004_folded_cascode

.control
  set filetype=ascii
  tran 2n 10u
  * settle to the FINAL value, not the input — a follower's systematic offset would
  * otherwise keep |vout - vinp| outside a tight tolerance band forever.
  meas tran vfinal FIND v(vout) AT=10u
  let verr = abs(v(vout) - vfinal)
  meas tran tcross WHEN verr=2m FALL=LAST
  let t_settle = tcross - 2u
  print t_settle
  write
  quit
.endc
.param x_dut_xm1_w=5
.param x_dut_xm1_l=0.5
.param x_dut_xm13_w=5
.param x_dut_xm13_l=2
.param x_dut_xm6_w=5
.param x_dut_xm6_l=0.5
.param x_dut_xm7_w=5
.param x_dut_xm7_l=0.5
.param x_dut_xm9_w=5
.param x_dut_xm9_l=2
.param x_dut_xm11_w=5
.param x_dut_xm11_l=2
.param x_dut_xm12_w=5
.param x_dut_xm12_l=2
.param x_dut_vb1=0.94
.param x_dut_vb2=0.48
.param x_dut_xm1_ng=1
.param x_dut_xm13_ng=1
.param x_dut_xm6_ng=1
.param x_dut_xm7_ng=1
.param x_dut_xm9_ng=1
.param x_dut_xm11_ng=1
.param x_dut_xm12_ng=1
.param x_dut_xm4_m=6
.param x_dut_xm1_m=32
.param x_dut_xm2_m=32
.param x_dut_xm3_m=6
.param x_dut_xm11_m=24
.param x_dut_xm0_m=24
.param x_dut_xm6_m=4
.param x_dut_xm5_m=4
.param x_dut_xm7_m=12
.param x_dut_xm8_m=12
.param x_dut_xm9_m=8
.param x_dut_xm10_m=8
.param x_dut_xm12_m=24
.param x_dut_xm13_m=6
* ---- GENERATED parameter ties (abstract/params.yaml groups/ratios) ----
* Each tied symbol is defined exactly once, by its line below; rewrite that
* .param to untie just that symbol (untying = shadowing, plan D-3).
.param x_dut_xm4_w = {x_dut_xm13_w}
.param x_dut_xm3_w = {x_dut_xm13_w}
.param x_dut_xm4_l = {x_dut_xm13_l}
.param x_dut_xm3_l = {x_dut_xm13_l}
.param x_dut_xm4_ng = {x_dut_xm13_ng}
.param x_dut_xm3_ng = {x_dut_xm13_ng}
.param x_dut_xm2_w = {x_dut_xm1_w}
.param x_dut_xm2_l = {x_dut_xm1_l}
.param x_dut_xm2_ng = {x_dut_xm1_ng}
.param x_dut_xm0_w = {x_dut_xm11_w}
.param x_dut_xm0_l = {x_dut_xm11_l}
.param x_dut_xm0_ng = {x_dut_xm11_ng}
.param x_dut_xm5_w = {x_dut_xm6_w}
.param x_dut_xm5_l = {x_dut_xm6_l}
.param x_dut_xm5_ng = {x_dut_xm6_ng}
.param x_dut_xm8_w = {x_dut_xm7_w}
.param x_dut_xm8_l = {x_dut_xm7_l}
.param x_dut_xm8_ng = {x_dut_xm7_ng}
.param x_dut_xm10_w = {x_dut_xm9_w}
.param x_dut_xm10_l = {x_dut_xm9_l}
.param x_dut_xm10_ng = {x_dut_xm9_ng}
.subckt amp_004_folded_cascode vinn vinp vout vdd ibias vss
V1 vb1 vss x_dut_vb1
V2 vb2 vss x_dut_vb2
XM0 tail ibias vdd vdd sky130_fd_pr__pfet_01v8 l=x_dut_xm0_l m=x_dut_xm0_m nf=x_dut_xm0_ng w=x_dut_xm0_w
XM1 foldp vinp tail vdd sky130_fd_pr__pfet_01v8 l=x_dut_xm1_l m=x_dut_xm1_m nf=x_dut_xm1_ng w=x_dut_xm1_w
XM10 s10 cascp vdd vdd sky130_fd_pr__pfet_01v8 l=x_dut_xm10_l m=x_dut_xm10_m nf=x_dut_xm10_ng w=x_dut_xm10_w
XM11 ibias ibias vdd vdd sky130_fd_pr__pfet_01v8 l=x_dut_xm11_l m=x_dut_xm11_m nf=x_dut_xm11_ng w=x_dut_xm11_w
XM12 nbias ibias vdd vdd sky130_fd_pr__pfet_01v8 l=x_dut_xm12_l m=x_dut_xm12_m nf=x_dut_xm12_ng w=x_dut_xm12_w
XM13 nbias nbias vss vss sky130_fd_pr__nfet_01v8 l=x_dut_xm13_l m=x_dut_xm13_m nf=x_dut_xm13_ng w=x_dut_xm13_w
XM2 foldn vinn tail vdd sky130_fd_pr__pfet_01v8 l=x_dut_xm2_l m=x_dut_xm2_m nf=x_dut_xm2_ng w=x_dut_xm2_w
XM3 foldp nbias vss vss sky130_fd_pr__nfet_01v8 l=x_dut_xm3_l m=x_dut_xm3_m nf=x_dut_xm3_ng w=x_dut_xm3_w
XM4 foldn nbias vss vss sky130_fd_pr__nfet_01v8 l=x_dut_xm4_l m=x_dut_xm4_m nf=x_dut_xm4_ng w=x_dut_xm4_w
XM5 cascp vb1 foldp vss sky130_fd_pr__nfet_01v8 l=x_dut_xm5_l m=x_dut_xm5_m nf=x_dut_xm5_ng w=x_dut_xm5_w
XM6 vout vb1 foldn vss sky130_fd_pr__nfet_01v8 l=x_dut_xm6_l m=x_dut_xm6_m nf=x_dut_xm6_ng w=x_dut_xm6_w
XM7 cascp vb2 s9 vdd sky130_fd_pr__pfet_01v8 l=x_dut_xm7_l m=x_dut_xm7_m nf=x_dut_xm7_ng w=x_dut_xm7_w
XM8 vout vb2 s10 vdd sky130_fd_pr__pfet_01v8 l=x_dut_xm8_l m=x_dut_xm8_m nf=x_dut_xm8_ng w=x_dut_xm8_w
XM9 s9 cascp vdd vdd sky130_fd_pr__pfet_01v8 l=x_dut_xm9_l m=x_dut_xm9_m nf=x_dut_xm9_ng w=x_dut_xm9_w
.ends
.end
