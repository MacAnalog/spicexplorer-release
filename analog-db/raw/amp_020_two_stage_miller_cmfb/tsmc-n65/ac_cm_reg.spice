** GENERATED by `analog-db export-raw` — DO NOT EDIT.
** circuit=amp_020_two_stage_miller_cmfb  class=amplifier  pdk=tsmc-n65  testbench=ac_cm_reg  corner=tt
** Self-contained deck: testbench + bound params + lowered DUT (.subckt amp_020_two_stage_miller_cmfb).
** PDK corner libs resolve by BARE NAME on the image's ngspice sourcepath — run in a
** PDK-enabled env (the base image / api container), NOT a bare host:
**   docker run --rm -i spicexplorer-spice-base:local \
**     bash -lc 'd=$(mktemp -d) && cat > $d/c.spice && cd $d && ngspice -b c.spice' < raw/amp_020_two_stage_miller_cmfb/tsmc-n65/ac_cm_reg.spice
*----------------------------------------------------------*
** params: 18 free + 10 frozen knobs (sizing.yaml) · 13 tied · 0 ratio-derived (abstract/params.yaml) · 3 testbench params
** AUTHORED TEMPLATE — amplifier/ac_cm_reg (CM-loop health, frequency domain).
** Closed-loop COMMON-MODE output impedance: a unit AC common-mode current (0.5 A per
** side) is injected into both outputs; vocm/(1 A) = |Zcm(f)|. The CM feedback loop
** suppresses Zcm in-band, so:
**   zcm_lf_ohm     low-frequency Zcm — the CM stiffness the servo achieves
**   zcm_peak_ohm   the sweep maximum
**   cm_peaking_db  20*log10(peak/lf) — impedance peaking; a large value flags an
**                  underdamped CM loop (the external signature of poor CM phase margin)
** HONESTY NOTE: the internal CM loop gain/phase (T_cm, PM_cm) cannot be probed from a
** bench without breaking the loop inside the DUT — that is a composition-time
** measurement (insert a VIPRB/stb probe in the CMFB path of a composed variant). This
** bench measures the closed-loop observables that T_cm determines.
**
** Assumes a self-biased, differential-output DUT with a CM control loop:
**   .subckt <id> vinp vinn voutp voutn vdd vss
** Required bindings: DUT PORT_LINE VDD VCM CL FSTART FSTOP PPD PDK_INCLUDE.
.lib tsmc_n65_models.scs tt
.temp 27

.param VDD=1.5
.param VCM=0.8
.param CL=50f

Vdd  vdd 0 dc {VDD}
Vss  vss 0 dc 0
CLoadp voutp 0 {CL}
CLoadn voutn 0 {CL}
Vcm  vcm 0 dc {VCM}
Vinp vinp vcm dc 0
Vinn vinn vcm dc 0
* unit common-mode current injection (0.5 A AC per side -> 1 A total CM)
Icmp 0 voutp dc 0 ac 0.5
Icmn 0 voutn dc 0 ac 0.5

XDUT vinp vinn voutp voutn vdd vss amp_020_two_stage_miller_cmfb

.control
  set filetype=ascii
  ac dec 41 100 1G
  let zcm = mag((v(voutp)+v(voutn))/2)
  meas ac zcm_lf_ohm FIND zcm AT=100
  meas ac zcm_pk MAX zcm
  * MAX meas lines carry an `at=` suffix the result parser skips - re-print clean
  let zcm_peak_ohm = zcm_pk
  let cm_peaking_db = 20*log10(zcm_pk/zcm_lf_ohm)
  print zcm_peak_ohm cm_peaking_db
  write
  quit
.endc
.param x_dut_xm1_w=2u
.param x_dut_xm1_l=0.5u
.param x_dut_xm3_w=2u
.param x_dut_xm3_l=0.5u
.param x_dut_xm5_w=10.8u
.param x_dut_xm5_l=0.5u
.param x_dut_xm7_w=4u
.param x_dut_xm7_l=0.5u
.param x_dut_xm6_w=2u
.param x_dut_xm6_l=0.5u
.param x_dut_xm8_w=2u
.param x_dut_xm8_l=0.5u
.param i_bias=50u
.param x_dut_r1_value=2k
.param x_dut_c1_value=1p
.param x_dut_r3_value=5k
.param x_dut_r5_value=5k
.param x_dut_c3_value=0.5p
.param x_dut_xm1_m=1
.param x_dut_xm2_m=1
.param x_dut_xm3_m=1
.param x_dut_xm4_m=1
.param x_dut_xm5_m=1
.param x_dut_xm9_m=1
.param x_dut_xm7_m=1
.param x_dut_xm10_m=1
.param x_dut_xm6_m=1
.param x_dut_xm8_m=1
* ---- GENERATED parameter ties (abstract/params.yaml groups/ratios) ----
* Each tied symbol is defined exactly once, by its line below; rewrite that
* .param to untie just that symbol (untying = shadowing, plan D-3).
.param x_dut_xm2_w = {x_dut_xm1_w}
.param x_dut_xm2_l = {x_dut_xm1_l}
.param x_dut_xm4_w = {x_dut_xm3_w}
.param x_dut_xm4_l = {x_dut_xm3_l}
.param x_dut_xm9_w = {x_dut_xm5_w}
.param x_dut_xm9_l = {x_dut_xm5_l}
.param x_dut_xm10_w = {x_dut_xm7_w}
.param x_dut_xm10_l = {x_dut_xm7_l}
.param x_dut_r2_value = {x_dut_r1_value}
.param x_dut_c2_value = {x_dut_c1_value}
.param x_dut_r4_value = {x_dut_r3_value}
.param x_dut_c4_value = {x_dut_c3_value}
.param x_dut_r6_value = {x_dut_r5_value}
.subckt amp_020_two_stage_miller_cmfb vinp vinn voutp voutn vdd vss
C1 mill_p voutp 'x_dut_c1_value'
C2 mill_n voutn 'x_dut_c2_value'
C3 cmz_p stg1p 'x_dut_c3_value'
C4 stg1n cmz_n 'x_dut_c4_value'
IBIAS vdd ref dc {i_bias}
R1 stg1p mill_p 'x_dut_r1_value'
R2 stg1n mill_n 'x_dut_r2_value'
R3 cmfb stg1p 'x_dut_r3_value'
R4 stg1n cmfb 'x_dut_r4_value'
R5 cmfb cmz_p 'x_dut_r5_value'
R6 cmz_n cmfb 'x_dut_r6_value'
XM1 stg1p vinp tail vss nch_lvt l=x_dut_xm1_l m=x_dut_xm1_m w=x_dut_xm1_w
XM10 voutn ref vss vss nch_lvt l=x_dut_xm10_l m=x_dut_xm10_m w=x_dut_xm10_w
XM2 stg1n vinn tail vss nch_lvt l=x_dut_xm2_l m=x_dut_xm2_m w=x_dut_xm2_w
XM3 stg1p cmfb vdd vdd pch_lvt l=x_dut_xm3_l m=x_dut_xm3_m w=x_dut_xm3_w
XM4 stg1n cmfb vdd vdd pch_lvt l=x_dut_xm4_l m=x_dut_xm4_m w=x_dut_xm4_w
XM5 voutp stg1p vdd vdd pch_lvt l=x_dut_xm5_l m=x_dut_xm5_m w=x_dut_xm5_w
XM6 ref ref vss vss nch_lvt l=x_dut_xm6_l m=x_dut_xm6_m w=x_dut_xm6_w
XM7 voutp ref vss vss nch_lvt l=x_dut_xm7_l m=x_dut_xm7_m w=x_dut_xm7_w
XM8 tail ref vss vss nch_lvt l=x_dut_xm8_l m=x_dut_xm8_m w=x_dut_xm8_w
XM9 voutn stg1n vdd vdd pch_lvt l=x_dut_xm9_l m=x_dut_xm9_m w=x_dut_xm9_w
.ends
.end
