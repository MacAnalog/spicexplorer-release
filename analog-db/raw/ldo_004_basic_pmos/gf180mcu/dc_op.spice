** GENERATED by `analog-db export-raw` — DO NOT EDIT.
** circuit=ldo_004_basic_pmos  class=ldo  pdk=gf180mcu  testbench=dc_op  corner=tt
** Self-contained deck: testbench + bound params + lowered DUT (.subckt ldo_004_basic_pmos).
** PDK corner libs resolve by BARE NAME on the image's ngspice sourcepath — run in a
** PDK-enabled env (the base image / api container), NOT a bare host:
**   docker run --rm -i spicexplorer-spice-base:local \
**     bash -lc 'd=$(mktemp -d) && cat > $d/c.spice && cd $d && ngspice -b c.spice' < raw/ldo_004_basic_pmos/gf180mcu/dc_op.spice
*----------------------------------------------------------*
** params: 11 free + 0 frozen knobs (sizing.yaml) · 4 tied · 0 ratio-derived (abstract/params.yaml) · 1 testbench params
** AUTHORED TEMPLATE — ldo/dc_op: DC operating point for a regulator.
** Superset of universal/dc_op: also reports the regulated output v(vout). The DUT generates its
** own reference + bias internally, so the testbench only drives vdd/vss (no load = quiescent).
** Bindings: DUT PORT_LINE VDD PDK_INCLUDE.
.include design.ngspice
.lib sm141064.ngspice noise_corner
.lib sm141064.ngspice nfet_03v3_t
.lib sm141064.ngspice pfet_03v3_t
.lib sm141064.ngspice fets_mm
.lib sm141064.ngspice res_typical
.lib sm141064.ngspice mimcap_typical
.lib sm141064.ngspice cap_mim
.temp 27

.param VDD=1.8

Vdd  vdd 0 dc {VDD}
Vss  vss 0 dc 0

XDUT vdd vout vss ldo_004_basic_pmos

.control
  set filetype=ascii
  op
  let i_supply = abs(i(Vdd))
  let vout_dc = v(vout)
  print i_supply vout_dc
  write
  quit
.endc
.param x_dut_xmp_w=10u
.param x_dut_xmp_m=100
.param x_dut_xmp_l=0.3u
.param r_top=100k
.param r_bot=100k
.param vref_val=0.65
.param i_tail=200u
.param x_dut_xm1_w=46u
.param x_dut_xm1_l=0.5u
.param x_dut_xm3_w=50u
.param x_dut_xm3_l=0.5u
* ---- GENERATED parameter ties (abstract/params.yaml groups/ratios) ----
* Each tied symbol is defined exactly once, by its line below; rewrite that
* .param to untie just that symbol (untying = shadowing, plan D-3).
.param x_dut_xm2_w = {x_dut_xm1_w}
.param x_dut_xm2_l = {x_dut_xm1_l}
.param x_dut_xm4_w = {x_dut_xm3_w}
.param x_dut_xm4_l = {x_dut_xm3_l}
.subckt ldo_004_basic_pmos vdd vout vss
ITAIL etail vss dc {i_tail}
R1 lp_brk fb 'r_top'
R2 fb vss 'r_bot'
VLP lp_brk vout dc 0
VREF vref vss dc {vref_val}
XM1 noutm fb etail vss nfet_03v3 l=x_dut_xm1_l w=x_dut_xm1_w
XM2 egate vref etail vss nfet_03v3 l=x_dut_xm2_l w=x_dut_xm2_w
XM3 noutm noutm vdd vdd pfet_03v3 l=x_dut_xm3_l w=x_dut_xm3_w
XM4 egate noutm vdd vdd pfet_03v3 l=x_dut_xm4_l w=x_dut_xm4_w
XMP vout egate vdd vdd pfet_03v3 l=x_dut_xmp_l m=x_dut_xmp_m w=x_dut_xmp_w
.ends
.end
