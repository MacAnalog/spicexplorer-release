** GENERATED by `analog-db generate` — DO NOT EDIT. Source: abstract/netlist.spice → gf180mcu
* amp_016_song_dacfc (emitted by spicexplorer-circuitgraph)
C0 VOUT net70 'CAPACITOR_0'
C2 net4 vss 'CAPACITOR_1'
I0 net013 vss 'CURRENT_0_BIAS'
XM0 net013 net013 vdd vdd pfet_03v3 l=x_dut_xm0_l m=x_dut_xm0_m w=x_dut_xm0_w
XM1 VB4 net013 vdd vdd pfet_03v3 l=x_dut_xm1_l m=x_dut_xm1_m w=x_dut_xm1_w
XM10 net043 net4 vdd vdd pfet_03v3 l=x_dut_xm10_l m=x_dut_xm10_m w=x_dut_xm10_w
XM11 VOUT net4 vdd vdd pfet_03v3 l=x_dut_xm11_l m=x_dut_xm11_m w=x_dut_xm11_w
XM12 VB4 VB3 net54 vss nfet_03v3 l=x_dut_xm12_l m=x_dut_xm12_m w=x_dut_xm12_w
XM13 DM_1 VB3 net56 vss nfet_03v3 l=x_dut_xm13_l m=x_dut_xm13_m w=x_dut_xm13_w
XM14 VB3 VB3 vss vss nfet_03v3 l=x_dut_xm14_l m=x_dut_xm14_m w=x_dut_xm14_w
XM15 VOUTN VB3 DM_2 vss nfet_03v3 l=x_dut_xm15_l m=x_dut_xm15_m w=x_dut_xm15_w
XM16 net4 VB3 net063 vss nfet_03v3 l=x_dut_xm16_l m=x_dut_xm16_m w=x_dut_xm16_w
XM17 net54 VB4 vss vss nfet_03v3 l=x_dut_xm17_l m=x_dut_xm17_m w=x_dut_xm17_w
XM18 net56 VB4 vss vss nfet_03v3 l=x_dut_xm18_l m=x_dut_xm18_m w=x_dut_xm18_w
XM19 DM_2 VB4 vss vss nfet_03v3 l=x_dut_xm19_l m=x_dut_xm19_m w=x_dut_xm19_w
XM2 DM_1 DM_1 vdd vdd pfet_03v3 l=x_dut_xm2_l m=x_dut_xm2_m w=x_dut_xm2_w
XM20 net063 VB4 vss vss nfet_03v3 l=x_dut_xm20_l m=x_dut_xm20_m w=x_dut_xm20_w
XM21 net043 net043 vss vss nfet_03v3 l=x_dut_xm21_l m=x_dut_xm21_m w=x_dut_xm21_w
XM22 net049 net043 vss vss nfet_03v3 l=x_dut_xm22_l m=x_dut_xm22_m w=x_dut_xm22_w
XM23 VOUT net049 vss vss nfet_03v3 l=x_dut_xm23_l m=x_dut_xm23_m w=x_dut_xm23_w
XM3 VB3 net013 vdd vdd pfet_03v3 l=x_dut_xm3_l m=x_dut_xm3_m w=x_dut_xm3_w
XM4 net31 net013 vdd vdd pfet_03v3 l=x_dut_xm4_l m=x_dut_xm4_m w=x_dut_xm4_w
XM5 net5 VOUTN vdd vdd pfet_03v3 l=x_dut_xm5_l m=x_dut_xm5_m w=x_dut_xm5_w
XM57 net043 VINN net1 net1 pfet_03v3 l=x_dut_xm57_l m=x_dut_xm57_m w=x_dut_xm57_w
XM58 net049 VINP net1 net1 pfet_03v3 l=x_dut_xm58_l m=x_dut_xm58_m w=x_dut_xm58_w
XM59 net1 net013 vdd vdd pfet_03v3 l=x_dut_xm59_l m=x_dut_xm59_m w=x_dut_xm59_w
XM6 net050 VOUTN vdd vdd pfet_03v3 l=x_dut_xm6_l m=x_dut_xm6_m w=x_dut_xm6_w
XM60 VOUTN DM_1 net5 vdd pfet_03v3 l=x_dut_xm60_l m=x_dut_xm60_m w=x_dut_xm60_w
XM61 net4 DM_1 net050 vdd pfet_03v3 l=x_dut_xm61_l m=x_dut_xm61_m w=x_dut_xm61_w
XM62 VOUTN DM_1 net3 vdd pfet_03v3 l=x_dut_xm62_l m=x_dut_xm62_m w=x_dut_xm62_w
XM63 net70 DM_1 net2 vdd pfet_03v3 l=x_dut_xm63_l m=x_dut_xm63_m w=x_dut_xm63_w
XM64 net85 VB4 vss vss nfet_03v3 l=x_dut_xm64_l m=x_dut_xm64_m w=x_dut_xm64_w
XM65 net69 VB4 vss vss nfet_03v3 l=x_dut_xm65_l m=x_dut_xm65_m w=x_dut_xm65_w
XM68 net2 net70 vdd vdd pfet_03v3 l=x_dut_xm68_l m=x_dut_xm68_m w=x_dut_xm68_w
XM69 net3 net70 vdd vdd pfet_03v3 l=x_dut_xm69_l m=x_dut_xm69_m w=x_dut_xm69_w
XM7 net049 VOUTN vdd vdd pfet_03v3 l=x_dut_xm7_l m=x_dut_xm7_m w=x_dut_xm7_w
XM70 net70 VB3 net69 vss nfet_03v3 l=x_dut_xm70_l m=x_dut_xm70_m w=x_dut_xm70_w
XM71 VOUTN VB3 net85 vss nfet_03v3 l=x_dut_xm71_l m=x_dut_xm71_m w=x_dut_xm71_w
XM8 DM_2 VINN net31 net31 pfet_03v3 l=x_dut_xm8_l m=x_dut_xm8_m w=x_dut_xm8_w
XM9 net063 VINP net31 net31 pfet_03v3 l=x_dut_xm9_l m=x_dut_xm9_m w=x_dut_xm9_w
.end
