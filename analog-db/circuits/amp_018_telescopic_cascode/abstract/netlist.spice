** Abstract telescopic (cascode) OTA — NMOS input pair + NMOS cascodes, PMOS mirror load
** + PMOS cascodes, NMOS tail with mirror reference, ideal cascode gate-bias sources.
** AUTHORED source of truth (plan D-2). PDK-neutral model tokens; XM* subckt-instance cards.
** Param names preserved from the NEWCAS-optimized design (X_DUT_*, lowercased) so the
** optimizer projection + sizing.yaml + the legacy testbenches stay name-compatible.
** NOTE: the legacy standalone DUT's XM4c had l=X_DUT_M3PCM4C_L — a stale typo never defined
** anywhere; the embedded testbench copies (the simulated truth) use X_DUT_M3CM4C_L for both
** PMOS cascodes, and so does this abstract (see _shared/MIGRATION.md).
** PDK-impl details dropped per the clean-core rule: enable/power-down network (XMpd*),
** decoupling devices (XMdecoup*), Vmeas ammeters (tail/ibias reconnected directly).
** Subckt port order (= circuit.yaml ports): vdd vout vinp vinn ibias vss
**.subckt amp_018_telescopic_cascode vdd vout vinp vinn ibias vss
XM1  d1     vinp    tail vss nmos w=x_dut_xm1_w   l=x_dut_xm1_l   m=x_dut_xm1_m
XM2  d2     vinn    tail vss nmos w=x_dut_xm2_w   l=x_dut_xm2_l   m=x_dut_xm2_m
XM1c gate_p casc_n  d1   vss nmos w=x_dut_xm1c_w l=x_dut_xm1c_l m=x_dut_xm1c_m
XM2c vout   casc_n  d2   vss nmos w=x_dut_xm2c_w l=x_dut_xm2c_l m=x_dut_xm2c_m
XM3  s3     gate_p  vdd  vdd pmos w=x_dut_xm3_w   l=x_dut_xm3_l   m=x_dut_xm3_m
XM4  s4     gate_p  vdd  vdd pmos w=x_dut_xm4_w   l=x_dut_xm4_l   m=x_dut_xm4_m
XM3c gate_p gate_pc s3   vdd pmos w=x_dut_xm3c_w l=x_dut_xm3c_l m=x_dut_xm3c_m
XM4c vout   gate_pc s4   vdd pmos w=x_dut_xm4c_w l=x_dut_xm4c_l m=x_dut_xm4c_m
XM5  tail   ibias   vss  vss nmos w=x_dut_xm5_w     l=x_dut_xm5_l     ng=x_dut_xm5_ng m=x_dut_xm5_m
XM6  ibias  ibias   vss  vss nmos w=x_dut_xm6_w     l=x_dut_xm6_l     m=x_dut_xm6_m
V1 vdd gate_pc x_dut_v_bias_2
V2 casc_n tail x_dut_v_bias_1
**.ends
.end
