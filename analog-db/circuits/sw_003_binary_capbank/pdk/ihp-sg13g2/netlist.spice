** GENERATED by `analog-db generate` — DO NOT EDIT. Source: abstract/netlist.spice → ihp-sg13g2
* sw_003_binary_capbank (emitted by spicexplorer-circuitgraph)
C1 vout vinp 'Cu' m=x_dut_c1_m
C2 vout bot0 'Cu' m=x_dut_c2_m
C3 vout bot1 'Cu' m=x_dut_c3_m
C4 vout bot2 'Cu' m=x_dut_c4_m
XM1 vinp V_D0 bot0 VSS sg13_lv_nmos l=x_dut_xm1_l m=x_dut_xm1_m w=x_dut_xm1_w
XM10 bot2 V_D2_NOT vinp VDD sg13_lv_pmos l=x_dut_xm10_l m=x_dut_xm10_m w=x_dut_xm10_w
XM11 VCM V_D2_NOT bot2 VSS sg13_lv_nmos l=x_dut_xm11_l m=x_dut_xm11_m w=x_dut_xm11_w
XM12 bot2 V_D2 VCM VDD sg13_lv_pmos l=x_dut_xm12_l m=x_dut_xm12_m w=x_dut_xm12_w
XM2 bot0 V_D0_NOT vinp VDD sg13_lv_pmos l=x_dut_xm2_l m=x_dut_xm2_m w=x_dut_xm2_w
XM3 VCM V_D0_NOT bot0 VSS sg13_lv_nmos l=x_dut_xm3_l m=x_dut_xm3_m w=x_dut_xm3_w
XM4 bot0 V_D0 VCM VDD sg13_lv_pmos l=x_dut_xm4_l m=x_dut_xm4_m w=x_dut_xm4_w
XM5 vinp V_D1 bot1 VSS sg13_lv_nmos l=x_dut_xm5_l m=x_dut_xm5_m w=x_dut_xm5_w
XM6 bot1 V_D1_NOT vinp VDD sg13_lv_pmos l=x_dut_xm6_l m=x_dut_xm6_m w=x_dut_xm6_w
XM7 VCM V_D1_NOT bot1 VSS sg13_lv_nmos l=x_dut_xm7_l m=x_dut_xm7_m w=x_dut_xm7_w
XM8 bot1 V_D1 VCM VDD sg13_lv_pmos l=x_dut_xm8_l m=x_dut_xm8_m w=x_dut_xm8_w
XM9 vinp V_D2 bot2 VSS sg13_lv_nmos l=x_dut_xm9_l m=x_dut_xm9_m w=x_dut_xm9_w
.end
