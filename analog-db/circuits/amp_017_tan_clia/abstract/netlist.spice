** amp_017_tan_clia — AnalogGym import, PDK-neutral abstract (plan Phase 5).
** sky130 device tokens → nmos/pmos; ports gnda→vss, vdda→vdd; role-encoded
** design-variable symbols (MOSFET_*_<role>_<type>) + their arithmetic preserved.
** Source: CODA-Team/AnalogGym (BSD-3-Clause). Subckt port order: vss vdd vinn vinp vout.
**.subckt amp_017_tan_clia vss vdd vinn vinp vout
xm73 net5 DM_1 vdd vdd pmos l=x_dut_xm73_l w=x_dut_xm73_w m=x_dut_xm73_m
xm70 net3 net050 vdd vdd pmos l=x_dut_xm70_l w=x_dut_xm70_w m=x_dut_xm70_m
xm2 DM_1 DM_1 vdd vdd pmos l=x_dut_xm2_l w=x_dut_xm2_w m=x_dut_xm2_m
xm68 VOUT net050 vdd vdd pmos l=x_dut_xm68_l w=x_dut_xm68_w m=x_dut_xm68_m
xm6 net050 VOUTN vdd vdd pmos l=x_dut_xm6_l w=x_dut_xm6_w m=x_dut_xm6_m
xm5 VOUTN VOUTN vdd vdd pmos l=x_dut_xm5_l w=x_dut_xm5_w m=x_dut_xm5_m
xm9 net8 VINP net31 net31 pmos l=x_dut_xm9_l w=x_dut_xm9_w m=x_dut_xm9_m
xm8 DM_2 VINN net31 net31 pmos l=x_dut_xm8_l w=x_dut_xm8_w m=x_dut_xm8_m
xm4 net31 net1 vdd vdd pmos l=x_dut_xm4_l w=x_dut_xm4_w m=x_dut_xm4_m
xm3 VB3 net1 vdd vdd pmos l=x_dut_xm3_l w=x_dut_xm3_w m=x_dut_xm3_m
xm1 VB4 net1 vdd vdd pmos l=x_dut_xm1_l w=x_dut_xm1_w m=x_dut_xm1_m
xm0 net1 net1 vdd vdd pmos l=x_dut_xm0_l w=x_dut_xm0_w m=x_dut_xm0_m
xm72 net5 net3 vss vss nmos l=x_dut_xm72_l w=x_dut_xm72_w m=x_dut_xm72_m
xm61 net3 VB4 vss vss nmos l=x_dut_xm61_l w=x_dut_xm61_w m=x_dut_xm61_m
xm71 net3 net3 vss vss nmos l=x_dut_xm71_l w=x_dut_xm71_w m=x_dut_xm71_m
xm19 DM_2 VB4 vss vss nmos l=x_dut_xm19_l w=x_dut_xm19_w m=x_dut_xm19_m
xm15 VOUTN VB3 DM_2 vss nmos l=x_dut_xm15_l w=x_dut_xm15_w m=x_dut_xm15_m
xm20 net8 VB4 vss vss nmos l=x_dut_xm20_l w=x_dut_xm20_w m=x_dut_xm20_m
xm16 net050 VB3 net8 vss nmos l=x_dut_xm16_l w=x_dut_xm16_w m=x_dut_xm16_m
xm18 net7 VB4 vss vss nmos l=x_dut_xm18_l w=x_dut_xm18_w m=x_dut_xm18_m
xm12 VB4 VB3 net6 vss nmos l=x_dut_xm12_l w=x_dut_xm12_w m=x_dut_xm12_m
xm13 DM_1 VB3 net7 vss nmos l=x_dut_xm13_l w=x_dut_xm13_w m=x_dut_xm13_m
xm17 net6 VB4 vss vss nmos l=x_dut_xm17_l w=x_dut_xm17_w m=x_dut_xm17_m
xm69 VOUT net5 vss vss nmos l=x_dut_xm69_l w=x_dut_xm69_w m=x_dut_xm69_m
xm14 VB3 VB3 vss vss nmos l=x_dut_xm14_l w=x_dut_xm14_w m=x_dut_xm14_m
I0 net1 vss 'CURRENT_0_BIAS'
C1 net8 VOUT 'CAPACITOR_1'
C0 net2 vss 'CAPACITOR_0'
R0 net5 net2 'RESISTOR_0'
**.ends Tan_CLIA_Pin_3
.end
