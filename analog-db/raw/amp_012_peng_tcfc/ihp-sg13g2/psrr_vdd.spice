** GENERATED by `analog-db export-raw` — DO NOT EDIT.
** circuit=amp_012_peng_tcfc  class=amplifier  pdk=ihp-sg13g2  testbench=psrr_vdd  corner=tt
** Self-contained deck: testbench + bound params + lowered DUT (.subckt amp_012_peng_tcfc).
** PDK corner libs resolve by BARE NAME on the image's ngspice sourcepath — run in a
** PDK-enabled env (the base image / api container), NOT a bare host:
**   docker run --rm -i spicexplorer-spice-base:local \
**     bash -lc 'd=$(mktemp -d) && cat > $d/c.spice && cd $d && ngspice -b c.spice' < raw/amp_012_peng_tcfc/ihp-sg13g2/psrr_vdd.spice
*----------------------------------------------------------*
** params: 24 free + 0 frozen knobs (sizing.yaml) · 52 tied · 23 ratio-derived (abstract/params.yaml) · 3 testbench params
** AUTHORED TEMPLATE — amplifier/psrr_vdd_selfbias (plan D-4/D-5): positive-supply rejection
** for self-biased DUTs (no ibias port — the AnalogGym amplifiers). Identical to psrr_vdd
** except there is no external bias source. The DUT is closed in a unity-gain buffer (vinn
** shorted to vout, vinp held at VCM with NO ac) and the supply Vdd carries a 1 V AC ripple;
** with the signal input quiet, every AC volt at vout is supply feed-through, so
** PSRR+ = −20·log10|vout/vdd| = −vdb(vout). Reported at FSTART (the DC-band floor).
** The unity-buffer DC op point is the same one the ac_open_loop_biaswrap bench already
** proves out for these DUTs (Lfb shorts vout→vinn at DC), so biasing is safe.
** Bindings: DUT PORT_LINE VDD VCM CL FSTART FSTOP PPD PDK_INCLUDE.
.lib cornerMOSlv.lib mos_tt
.temp 27

.param VDD=1.8
.param VCM=240m
.param CL=150p

Vdd  vdd 0 dc {VDD} ac 1     ; 1 V supply-ripple stimulus
Vss  vss 0 dc 0
CLoad vout 0 {CL}

Vinp vinp 0 dc {VCM}         ; signal input held quiet (no ac) — isolate the supply path
Vfb  vinn vout dc 0          ; unity-gain buffer: vinn shorted to vout

XDUT vss vdd vinn vinp vout amp_012_peng_tcfc

.control
  set filetype=ascii
  ac dec 101 1k 1G
  let psrr = -vdb(vout)
  meas ac psrr_vdd_db FIND psrr AT=1k
  write
  quit
.endc
.param CAPACITOR_0=1.8719584694171476e-12
.param CAPACITOR_1=2.5460642554730274e-12
.param CURRENT_0_BIAS=1.2984942841619427e-06
.param x_dut_xm66_l=4.93834968309184e-06
.param x_dut_xm65_m=4
.param x_dut_xm66_w=3.639279460843864e-07
.param x_dut_xm10_l=7.48172986805076e-07
.param x_dut_xm10_m=4
.param x_dut_xm10_w=7.828746124040156e-06
.param x_dut_xm11_l=5.422078967582453e-07
.param x_dut_xm11_m=4
.param x_dut_xm11_w=9.055586564941477e-06
.param x_dut_xm19_l=4.312024823684264e-07
.param x_dut_xm14_m=4
.param x_dut_xm19_w=1.706276839105315e-06
.param x_dut_xm23_l=6.133141401805846e-07
.param x_dut_xm23_m=4
.param x_dut_xm23_w=2.7926678654690997e-06
.param x_dut_xm70_l=9.142486402054605e-06
.param x_dut_xm70_m=4
.param x_dut_xm70_w=4.646218630089021e-06
.param x_dut_xm9_l=2.063372547860109e-06
.param x_dut_xm9_m=4
.param x_dut_xm9_w=5.50205214041051e-06
* ---- GENERATED parameter ties (abstract/params.yaml groups/ratios) ----
* Each tied symbol is defined exactly once, by its line below; rewrite that
* .param to untie just that symbol (untying = shadowing, plan D-3).
.param x_dut_xm7_w = {x_dut_xm66_w}
.param x_dut_xm57_w = {x_dut_xm66_w}
.param x_dut_xm65_w = {x_dut_xm66_w}
.param x_dut_xm6_w = {x_dut_xm66_w}
.param x_dut_xm5_w = {x_dut_xm66_w}
.param x_dut_xm4_w = {x_dut_xm66_w}
.param x_dut_xm62_w = {x_dut_xm66_w}
.param x_dut_xm3_w = {x_dut_xm66_w}
.param x_dut_xm61_w = {x_dut_xm66_w}
.param x_dut_xm2_w = {x_dut_xm66_w}
.param x_dut_xm58_w = {x_dut_xm66_w}
.param x_dut_xm1_w = {x_dut_xm66_w}
.param x_dut_xm0_w = {x_dut_xm66_w}
.param x_dut_xm7_l = {x_dut_xm66_l}
.param x_dut_xm57_l = {x_dut_xm66_l}
.param x_dut_xm65_l = {x_dut_xm66_l}
.param x_dut_xm6_l = {x_dut_xm66_l}
.param x_dut_xm5_l = {x_dut_xm66_l}
.param x_dut_xm4_l = {x_dut_xm66_l}
.param x_dut_xm62_l = {x_dut_xm66_l}
.param x_dut_xm3_l = {x_dut_xm66_l}
.param x_dut_xm61_l = {x_dut_xm66_l}
.param x_dut_xm2_l = {x_dut_xm66_l}
.param x_dut_xm58_l = {x_dut_xm66_l}
.param x_dut_xm1_l = {x_dut_xm66_l}
.param x_dut_xm0_l = {x_dut_xm66_l}
.param x_dut_xm8_w = {x_dut_xm9_w}
.param x_dut_xm8_l = {x_dut_xm9_l}
.param x_dut_xm8_m = {x_dut_xm9_m}
.param x_dut_xm69_w = {x_dut_xm70_w}
.param x_dut_xm69_l = {x_dut_xm70_l}
.param x_dut_xm69_m = {x_dut_xm70_m}
.param x_dut_xm15_w = {x_dut_xm19_w}
.param x_dut_xm20_w = {x_dut_xm19_w}
.param x_dut_xm16_w = {x_dut_xm19_w}
.param x_dut_xm17_w = {x_dut_xm19_w}
.param x_dut_xm14_w = {x_dut_xm19_w}
.param x_dut_xm12_w = {x_dut_xm19_w}
.param x_dut_xm18_w = {x_dut_xm19_w}
.param x_dut_xm13_w = {x_dut_xm19_w}
.param x_dut_xm64_w = {x_dut_xm19_w}
.param x_dut_xm63_w = {x_dut_xm19_w}
.param x_dut_xm15_l = {x_dut_xm19_l}
.param x_dut_xm20_l = {x_dut_xm19_l}
.param x_dut_xm16_l = {x_dut_xm19_l}
.param x_dut_xm17_l = {x_dut_xm19_l}
.param x_dut_xm14_l = {x_dut_xm19_l}
.param x_dut_xm12_l = {x_dut_xm19_l}
.param x_dut_xm18_l = {x_dut_xm19_l}
.param x_dut_xm13_l = {x_dut_xm19_l}
.param x_dut_xm64_l = {x_dut_xm19_l}
.param x_dut_xm63_l = {x_dut_xm19_l}
.param x_dut_xm66_m = {x_dut_xm65_m*48}
.param x_dut_xm7_m = {x_dut_xm65_m*48}
.param x_dut_xm57_m = {x_dut_xm65_m*4}
.param x_dut_xm6_m = {x_dut_xm65_m*4}
.param x_dut_xm5_m = {x_dut_xm65_m*4}
.param x_dut_xm4_m = {x_dut_xm65_m*8}
.param x_dut_xm62_m = {x_dut_xm65_m*4}
.param x_dut_xm3_m = {x_dut_xm65_m*4}
.param x_dut_xm61_m = {x_dut_xm65_m*4}
.param x_dut_xm2_m = {x_dut_xm65_m*4}
.param x_dut_xm58_m = {x_dut_xm65_m*4}
.param x_dut_xm1_m = {x_dut_xm65_m*4}
.param x_dut_xm0_m = {x_dut_xm65_m*4}
.param x_dut_xm19_m = {x_dut_xm14_m*8}
.param x_dut_xm15_m = {x_dut_xm14_m*8}
.param x_dut_xm20_m = {x_dut_xm14_m*8}
.param x_dut_xm16_m = {x_dut_xm14_m*8}
.param x_dut_xm17_m = {x_dut_xm14_m*4}
.param x_dut_xm12_m = {x_dut_xm14_m*4}
.param x_dut_xm18_m = {x_dut_xm14_m*4}
.param x_dut_xm13_m = {x_dut_xm14_m*4}
.param x_dut_xm64_m = {x_dut_xm14_m*4}
.param x_dut_xm63_m = {x_dut_xm14_m*4}
.subckt amp_012_peng_tcfc vss vdd vinn vinp vout
C0 VOUTP VOUT 'CAPACITOR_0'
C1 net049 VOUT 'CAPACITOR_1'
I0 VB1 vss 'CURRENT_0_BIAS'
XM0 net2 VB1 vdd vdd sg13_lv_pmos l=x_dut_xm0_l m=x_dut_xm0_m w=x_dut_xm0_w
XM1 net3 VB1 vdd vdd sg13_lv_pmos l=x_dut_xm1_l m=x_dut_xm1_m w=x_dut_xm1_w
XM10 net043 VOUTP vdd vdd sg13_lv_pmos l=x_dut_xm10_l m=x_dut_xm10_m w=x_dut_xm10_w
XM11 VOUT VOUTP vdd vdd sg13_lv_pmos l=x_dut_xm11_l m=x_dut_xm11_m w=x_dut_xm11_w
XM12 VB4 VB3 net54 vss sg13_lv_nmos l=x_dut_xm12_l m=x_dut_xm12_m w=x_dut_xm12_w
XM13 net7 VB3 net56 vss sg13_lv_nmos l=x_dut_xm13_l m=x_dut_xm13_m w=x_dut_xm13_w
XM14 VB3 VB3 vss vss sg13_lv_nmos l=x_dut_xm14_l m=x_dut_xm14_m w=x_dut_xm14_w
XM15 VOUTN VB3 DM_2 vss sg13_lv_nmos l=x_dut_xm15_l m=x_dut_xm15_m w=x_dut_xm15_w
XM16 VOUTP VB3 net063 vss sg13_lv_nmos l=x_dut_xm16_l m=x_dut_xm16_m w=x_dut_xm16_w
XM17 net54 VB4 vss vss sg13_lv_nmos l=x_dut_xm17_l m=x_dut_xm17_m w=x_dut_xm17_w
XM18 net56 VB4 vss vss sg13_lv_nmos l=x_dut_xm18_l m=x_dut_xm18_m w=x_dut_xm18_w
XM19 DM_2 VB4 vss vss sg13_lv_nmos l=x_dut_xm19_l m=x_dut_xm19_m w=x_dut_xm19_w
XM2 net6 VB1 vdd vdd sg13_lv_pmos l=x_dut_xm2_l m=x_dut_xm2_m w=x_dut_xm2_w
XM20 net063 VB4 vss vss sg13_lv_nmos l=x_dut_xm20_l m=x_dut_xm20_m w=x_dut_xm20_w
XM23 VOUT net10 vss vss sg13_lv_nmos l=x_dut_xm23_l m=x_dut_xm23_m w=x_dut_xm23_w
XM3 net8 VB1 vdd vdd sg13_lv_pmos l=x_dut_xm3_l m=x_dut_xm3_m w=x_dut_xm3_w
XM4 net31 VB1 vdd vdd sg13_lv_pmos l=x_dut_xm4_l m=x_dut_xm4_m w=x_dut_xm4_w
XM5 VOUTN VOUTN vdd vdd sg13_lv_pmos l=x_dut_xm5_l m=x_dut_xm5_m w=x_dut_xm5_w
XM57 VB1 VB2 net2 vdd sg13_lv_pmos l=x_dut_xm57_l m=x_dut_xm57_m w=x_dut_xm57_w
XM58 VB4 VB2 net3 vdd sg13_lv_pmos l=x_dut_xm58_l m=x_dut_xm58_m w=x_dut_xm58_w
XM6 VOUTP VOUTN vdd vdd sg13_lv_pmos l=x_dut_xm6_l m=x_dut_xm6_m w=x_dut_xm6_w
XM61 net7 VB2 net6 vdd sg13_lv_pmos l=x_dut_xm61_l m=x_dut_xm61_m w=x_dut_xm61_w
XM62 VB3 VB2 net8 vdd sg13_lv_pmos l=x_dut_xm62_l m=x_dut_xm62_m w=x_dut_xm62_w
XM63 VB2 VB3 net9 vss sg13_lv_nmos l=x_dut_xm63_l m=x_dut_xm63_m w=x_dut_xm63_w
XM64 net9 VB4 vss vss sg13_lv_nmos l=x_dut_xm64_l m=x_dut_xm64_m w=x_dut_xm64_w
XM65 VB2 VB2 vdd vdd sg13_lv_pmos l=x_dut_xm65_l m=x_dut_xm65_m w=x_dut_xm65_w
XM66 net10 VB2 net049 vdd sg13_lv_pmos l=x_dut_xm66_l m=x_dut_xm66_m w=x_dut_xm66_w
XM69 net10 net043 vss vss sg13_lv_nmos l=x_dut_xm69_l m=x_dut_xm69_m w=x_dut_xm69_w
XM7 net049 VB1 vdd vdd sg13_lv_pmos l=x_dut_xm7_l m=x_dut_xm7_m w=x_dut_xm7_w
XM70 net043 net043 vss vss sg13_lv_nmos l=x_dut_xm70_l m=x_dut_xm70_m w=x_dut_xm70_w
XM8 DM_2 VINN net31 net31 sg13_lv_pmos l=x_dut_xm8_l m=x_dut_xm8_m w=x_dut_xm8_w
XM9 net063 VINP net31 net31 sg13_lv_pmos l=x_dut_xm9_l m=x_dut_xm9_m w=x_dut_xm9_w
.ends
.end
