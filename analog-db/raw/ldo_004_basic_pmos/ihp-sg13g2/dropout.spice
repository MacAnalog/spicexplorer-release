** GENERATED by `analog-db export-raw` — DO NOT EDIT.
** circuit=ldo_004_basic_pmos  class=ldo  pdk=ihp-sg13g2  testbench=dropout  corner=tt
** Self-contained deck: testbench + bound params + lowered DUT (.subckt ldo_004_basic_pmos).
** PDK corner libs resolve by BARE NAME on the image's ngspice sourcepath — run in a
** PDK-enabled env (the base image / api container), NOT a bare host:
**   docker run --rm -i spicexplorer-spice-base:local \
**     bash -lc 'd=$(mktemp -d) && cat > $d/c.spice && cd $d && ngspice -b c.spice' < raw/ldo_004_basic_pmos/ihp-sg13g2/dropout.spice
*----------------------------------------------------------*
** params: 11 free + 0 frozen knobs (sizing.yaml) · 4 tied · 0 ratio-derived (abstract/params.yaml) · 0 testbench params
** AUTHORED TEMPLATE — ldo/dropout: sweep Vin upward at heavy load; Vin - Vout at the
** regulation threshold. As Vin rises out of dropout, v(vout) climbs to its regulated target;
** dropout = (Vin at which v(vout) first reaches VOUT_THRESH) - VOUT_THRESH.
** Bindings: DUT PORT_LINE ILOAD VDD_START VDD_STOP VDD_STEP VOUT_THRESH PDK_INCLUDE.
.lib cornerMOSlv.lib mos_tt
.lib cornerRES.lib res_typ
.temp 27

Vdd  vdd 0 dc 1.0
Vss  vss 0 dc 0
Iload vout 0 dc 1m

XDUT vdd vout vss ldo_004_basic_pmos

.control
  set filetype=ascii
  dc Vdd 1.0 1.8 0.01
  meas dc vin_at WHEN v(vout)=1.2 RISE=1
  let v_dropout = vin_at - 1.2
  print v_dropout
  write
  quit
.endc
.param x_dut_xmp_w=10u
.param x_dut_xmp_m=20
.param x_dut_xmp_l=0.5u
.param r_top=100k
.param r_bot=100k
.param vref_val=0.6
.param i_tail=200u
.param x_dut_xm1_w=4u
.param x_dut_xm1_l=0.5u
.param x_dut_xm3_w=4u
.param x_dut_xm3_l=0.5u
* ---- GENERATED parameter ties (abstract/params.yaml groups/ratios) ----
* Each tied symbol is defined exactly once, by its line below; rewrite that
* .param to untie just that symbol (untying = shadowing, plan D-3).
.param x_dut_xm2_w = {x_dut_xm1_w}
.param x_dut_xm2_l = {x_dut_xm1_l}
.param x_dut_xm4_w = {x_dut_xm3_w}
.param x_dut_xm4_l = {x_dut_xm3_l}
.subckt ldo_004_basic_pmos vdd vout vss
ITAIL etail vss dc {i_tail}
R1 vout fb 'r_top'
R2 fb vss 'r_bot'
VREF vref vss dc {vref_val}
XM1 noutm fb etail vss sg13_lv_nmos l=x_dut_xm1_l w=x_dut_xm1_w
XM2 egate vref etail vss sg13_lv_nmos l=x_dut_xm2_l w=x_dut_xm2_w
XM3 noutm noutm vdd vdd sg13_lv_pmos l=x_dut_xm3_l w=x_dut_xm3_w
XM4 egate noutm vdd vdd sg13_lv_pmos l=x_dut_xm4_l w=x_dut_xm4_w
XMP vout egate vdd vdd sg13_lv_pmos l=x_dut_xmp_l m=x_dut_xmp_m w=x_dut_xmp_w
.ends
.end
