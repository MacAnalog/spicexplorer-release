** sch_path: high_swing_cascode_current_mirror.sch
**.subckt high_swing_cascode_current_mirror iout iin VSS iin2
*.iopin iout
*.iopin iin
*.iopin VSS
*.iopin iin2
XM1 iin2 iin2 VSS VSS sg13_lv_nmos w=0.15u l=0.13u ng=1 m=1
XM2 net1 iin2 VSS VSS sg13_lv_nmos w=0.15u l=0.13u ng=1 m=1
XM3 iout iin net1 VSS sg13_lv_nmos w=0.15u l=0.13u ng=1 m=1
XM4 iin iin VSS VSS sg13_lv_nmos w=0.15u l=0.13u ng=1 m=1
**.ends
.end
