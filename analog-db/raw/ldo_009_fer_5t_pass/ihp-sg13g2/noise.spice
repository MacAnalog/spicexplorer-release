** GENERATED by `analog-db export-raw` — DO NOT EDIT.
** circuit=ldo_009_fer_5t_pass  class=ldo  pdk=ihp-sg13g2  testbench=noise  corner=tt
** Self-contained deck: testbench + bound params + lowered DUT (.subckt ldo_009_fer_5t_pass).
** PDK corner libs resolve by BARE NAME on the image's ngspice sourcepath — run in a
** PDK-enabled env (the base image / api container), NOT a bare host:
**   docker run --rm -i spicexplorer-spice-base:local \
**     bash -lc 'd=$(mktemp -d) && cat > $d/c.spice && cd $d && ngspice -b c.spice' < raw/ldo_009_fer_5t_pass/ihp-sg13g2/noise.spice
*----------------------------------------------------------*
** params: 12 free + 9 frozen knobs (sizing.yaml) · 6 tied · 0 ratio-derived (abstract/params.yaml) · 1 testbench params
** AUTHORED TEMPLATE — ldo/noise: closed-loop output noise, integrated over a band.
** Methodology from the LDO literature benches vendored at circuits/ldo_004_basic_pmos/reference/
** ltspice/Noise_6p38..42.asc (`.noise v(vout)` + integrated output noise). ngspice's `.noise`
** needs an independent source as its "input"; the supply Vdd serves (the DUT's reference is
** internal to the 3-port subckt), so only the OUTPUT-referred noise is meaningful here:
** vn_out_rms = sqrt(onoise_total) over FSTART..FSTOP.
** Bindings: DUT PORT_LINE VDD ILOAD COUT FSTART FSTOP PPD PDK_INCLUDE.
.lib cornerMOSlv.lib mos_tt
.temp 27

.param VDD=1.8

Vdd  vdd 0 dc {VDD} ac 1
Vss  vss 0 dc 0
Iload vout 0 dc 1m
CLoad vout 0 1u

XDUT vdd vout vss ldo_009_fer_5t_pass

.control
  set filetype=ascii
  noise v(vout) Vdd dec 10 10 10meg
  let vn_out_rms = sqrt(onoise_total)
  print onoise_total vn_out_rms
  write
  quit
.endc
.param x_dut_xmnb_w=4u
.param x_dut_xmnb_l=0.4u
.param x_dut_xmip_w=8u
.param x_dut_xmip_l=0.2u
.param x_dut_xmld_w=4u
.param x_dut_xmld_l=0.4u
.param x_dut_xmp_w=8u
.param x_dut_xmp_l=0.2u
.param x_cmil=2e-12
.param x_cout=50e-12
.param x_rbleed=1e5
.param x_rref=10000
.param x_vref_val=0.9
.param x_ibias_val=20e-6
.param x_dut_xmnb_m=1
.param x_dut_xmnt_m=2
.param x_dut_xmip_m=2
.param x_dut_xmin_m=2
.param x_dut_xmld_m=1
.param x_dut_xmlm_m=1
.param x_dut_xmp_m=20
* ---- GENERATED parameter ties (abstract/params.yaml groups/ratios) ----
* Each tied symbol is defined exactly once, by its line below; rewrite that
* .param to untie just that symbol (untying = shadowing, plan D-3).
.param x_dut_xmnt_w = {x_dut_xmnb_w}
.param x_dut_xmnt_l = {x_dut_xmnb_l}
.param x_dut_xmin_w = {x_dut_xmip_w}
.param x_dut_xmin_l = {x_dut_xmip_l}
.param x_dut_xmlm_w = {x_dut_xmld_w}
.param x_dut_xmlm_l = {x_dut_xmld_l}
.subckt ldo_009_fer_5t_pass vdd vout vss
CMIL vout otao x_cmil
COUT vout vss x_cout
IBI vdd nbias dc {x_ibias_val}
RBLD vout vss x_rbleed
RREF ref0 vref x_rref
VREF ref0 vss dc {x_vref_val}
XMIN otao vref tail vss sg13_lv_nmos l=x_dut_xmin_l m=x_dut_xmin_m w=x_dut_xmin_w
XMIP otax vout tail vss sg13_lv_nmos l=x_dut_xmip_l m=x_dut_xmip_m w=x_dut_xmip_w
XMLD otax otax vdd vdd sg13_lv_pmos l=x_dut_xmld_l m=x_dut_xmld_m w=x_dut_xmld_w
XMLM otao otax vdd vdd sg13_lv_pmos l=x_dut_xmlm_l m=x_dut_xmlm_m w=x_dut_xmlm_w
XMNB nbias nbias vss vss sg13_lv_nmos l=x_dut_xmnb_l m=x_dut_xmnb_m w=x_dut_xmnb_w
XMNT tail nbias vss vss sg13_lv_nmos l=x_dut_xmnt_l m=x_dut_xmnt_m w=x_dut_xmnt_w
XMP vout otao vdd vdd sg13_lv_pmos l=x_dut_xmp_l m=x_dut_xmp_m w=x_dut_xmp_w
.ends
.end
