** GENERATED by `analog-db export-raw` — DO NOT EDIT.
** circuit=sw_001_transmission_gate_pair  class=switch  pdk=ihp-sg13g2  testbench=tran_chargeinj  corner=tt
** Self-contained deck: testbench + bound params + lowered DUT (.subckt sw_001_transmission_gate_pair).
** PDK corner libs resolve by BARE NAME on the image's ngspice sourcepath — run in a
** PDK-enabled env (the base image / api container), NOT a bare host:
**   docker run --rm -i spicexplorer-spice-base:local \
**     bash -lc 'd=$(mktemp -d) && cat > $d/c.spice && cd $d && ngspice -b c.spice' < raw/sw_001_transmission_gate_pair/ihp-sg13g2/tran_chargeinj.spice
*----------------------------------------------------------*
** params: 4 free + 2 frozen knobs (sizing.yaml) · 0 tied · 0 ratio-derived (abstract/params.yaml) · 3 testbench params
** AUTHORED TEMPLATE — switch/tran_chargeinj (plan_hierarchical_composition P3).
** Charge-injection pedestal: with the switch ON, the hold cap on port_b tracks the
** source VCM on port_a; at TOFF the switch opens (1 ns edges) and the channel charge +
** clock feedthrough leave a pedestal on the hold cap. q_inj_v = v(port_b) after opening
** minus the held VCM (measured at TB before / TA after the edge); i_leak = the average
** current drawn from the source into the open switch over the tail of the run.
**
** Assumes the transmission-gate port order:
**   .subckt <id> port_a port_b vctl vctl_not vdd vss
** Required bindings: DUT PORT_LINE VDD VCM CHOLD TOFF TB TA TSTEP TSTOP PDK_INCLUDE.
.lib cornerMOSlv.lib mos_tt
.temp 27

.param VDD=1.2
.param VCM=0.6
.param CHOLD=1p

Vdd  vdd 0 dc {VDD}
Vss  vss 0 dc 0
Vsrc port_a 0 dc {VCM}
Chold port_b 0 {CHOLD}
Vctl  vctl 0 pulse({VDD} 0 1u 1n 1n 1 2)
Vctln vctl_not 0 pulse(0 {VDD} 1u 1n 1n 1 2)

XDUT port_a port_b vctl vctl_not vdd vss sw_001_transmission_gate_pair

.control
  set filetype=ascii
  tran 1n 3u
  meas tran vheld FIND v(port_b) AT=0.9u
  meas tran vafter FIND v(port_b) AT=1.5u
  let q_inj_v = vafter - vheld
  meas tran i_leak AVG i(Vsrc) from=1.5u to=3u
  * AVG meas lines carry `from=/to=` suffixes the result parser skips - re-print clean
  print q_inj_v i_leak
  write
  quit
.endc
.param x_dut_xm1_w=2u
.param x_dut_xm1_l=0.13u
.param x_dut_xm2_w=2u
.param x_dut_xm2_l=0.13u
.param x_dut_xm1_m=1
.param x_dut_xm2_m=1
.subckt sw_001_transmission_gate_pair port_a port_b vctl vctl_not vdd vss
XM1 port_a vctl port_b vss sg13_lv_nmos l=x_dut_xm1_l m=x_dut_xm1_m w=x_dut_xm1_w
XM2 port_b vctl_not port_a vdd sg13_lv_pmos l=x_dut_xm2_l m=x_dut_xm2_m w=x_dut_xm2_w
.ends
.end
