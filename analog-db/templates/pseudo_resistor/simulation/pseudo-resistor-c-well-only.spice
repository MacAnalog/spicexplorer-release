** sch_path: pseudo-resistor-c-well-only.sch
**.subckt pseudo-resistor-c-well-only port_A port_B
*.ipin port_A
*.ipin port_B
XM1 port_B port_B net1 net1 sg13_lv_pmos w=0.15u l=0.13u ng=1 m=1
XM2 port_A port_A net1 net1 sg13_lv_pmos w=0.15u l=0.13u ng=1 m=1
**.ends
.end
