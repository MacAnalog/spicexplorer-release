// Open-loop main characterization: DC op, differential AC (gain/GBW/PM),
// output-referred + input-referred noise, DC transfer sweep (gain linearity
// and output swing).
simulator lang=spectre
global 0
parameters VSUP=0.9 VCM=0.45 IB=20u CL=1p acdm=1 accm=0 acvdd=0 vid=0

include "${PDK_ROOT}/models/spectre/toplevel.scs" section=TOP_TT
include "ota_fd2s.scs"
include "tb_openloop.scs"

simulatorOptions options psfversion="1.4.0" temp=27 tnom=27 scalem=1.0 \
    scale=1.0 gmin=1e-12 rforce=1 maxnotes=5 maxwarns=5 digits=5 cols=80 \
    pivrel=1e-3 checklimitdest=psf

dcOp dc write="spectre.dc" maxiters=150 maxsteps=10000 annotate=status
dcOpInfo info what=oppoint where=rawfile

ac ac start=1 stop=10G dec=20 annotate=status

noise (OUTP OUTN) noise start=10 stop=1G dec=10 iprobe=v_ip annotate=status

dcswp dc param=vid start=-5m stop=5m step=10u maxiters=150 annotate=status

element info what=inst where=rawfile
designParamVals info what=parameters where=rawfile

save OUTP OUTN INP INN v_vdd:p \
    x_ota.o1a x_ota.o1b x_ota.vcmfb x_ota.vsen x_ota.vbp x_ota.vcp \
    x_ota.vcn x_ota.tail x_ota.fp x_ota.fn
saveOptions options save=selected
