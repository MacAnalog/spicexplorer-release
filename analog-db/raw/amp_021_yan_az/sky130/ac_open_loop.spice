** GENERATED by `analog-db export-raw` — DO NOT EDIT.
** circuit=amp_021_yan_az  class=amplifier  pdk=sky130  testbench=ac_open_loop  corner=tt
** Self-contained deck: testbench + bound params + lowered DUT (.subckt amp_021_yan_az).
** PDK corner libs resolve by BARE NAME on the image's ngspice sourcepath — run in a
** PDK-enabled env (the base image / api container), NOT a bare host:
**   docker run --rm -i spicexplorer-spice-base:local \
**     bash -lc 'd=$(mktemp -d) && cat > $d/c.spice && cd $d && ngspice -b c.spice' < raw/amp_021_yan_az/sky130/ac_open_loop.spice
*----------------------------------------------------------*
** params: 36 free + 0 frozen knobs (sizing.yaml) · 27 tied · 6 ratio-derived (abstract/params.yaml) · 3 testbench params
** AUTHORED TEMPLATE — amplifier/ac_open_loop_biaswrap (plan D-4; the AnalogGym bias-wrap).
** Open-loop gain measured in closed-loop bias (analoggym-amplifiers skill §5): a 1 TH inductor
** DC-shorts the output back to the inverting input — setting the high-gain operating point —
** while a 1 TF cap AC-opens that feedback and injects the AC input. This is the only way a
** high-gain 3-stage amp biases stably while still exposing its open-loop AC response.
**
** Assumes the AnalogGym canonical DUT port order (self-biased; NO ibias port):
**   .subckt <id> vss vdd vinn vinp vout
** Bindings: DUT VDD VCM CL FSTART FSTOP PPD PDK_INCLUDE.
** FIXED 2026-07-20: this template used to hardcode `X1 0 vdd opout_dc opin opout amp_021_yan_az`,
** which silently assumed the AnalogGym port order [vss vdd vinn vinp vout] and MIS-WIRED any
** DUT declaring a different order (e.g. the amplifier-class [vdd vout vinp vinn vss] swaps
** vdd<->vss). It now uses XDUT vss vdd vinn vinp vout with canonical node names, exactly like the
** *_biaswrap_ibias sibling. For the AnalogGym DUTs this is a no-op: their vss port binds to
** node `vss`, which `Vss vss 0 dc 0` ties to ground just as the old direct-to-0 wiring did.
.lib sky130.lib.spice tt
.temp 27

.param VDD=1.8
.param VCM=300m
.param CL=10p

Vdd  vdd 0 dc {VDD}
Vss  vss 0 dc 0
Vcm  vinp 0 dc {VCM}          ; common-mode bias on the non-inverting input
Vac  sigin 0 dc 0 ac 1        ; AC stimulus
Lfb  vout vinn 1T        ; 1 TH: DC short (bias), AC open
Cin  vinn sigin 1T        ; 1 TF: DC open, AC inject into the inverting node
CLoad vout 0 {CL}

XDUT vss vdd vinn vinp vout amp_021_yan_az
.control
  set filetype=ascii
  ac dec 50 1e-4 1G
  meas ac dcgain FIND vdb(vout) AT=1e-4
  meas ac ugf    WHEN vdb(vout)=0 FALL=1
  let phc = cph(vout)*180/3.14159265
  let ph  = 180 + phc - phc[0]
  meas ac pm     FIND ph WHEN vdb(vout)=0 FALL=1
  * STABILITY GUARDS (2026-08-18, tcas-2026 E-041). `pm` above is a Bode margin and a Bode margin
  * assumes the open loop has no right-half-plane poles. Multistage amps with internal
  * compensation loops (Peng IAC / TCFC and kin) can lose that at a random sizing: the small-
  * signal response then shows phase LEAD instead of lag, `pm` reads 140-585 deg, and the sizing
  * oscillates rail-to-rail in the closed-loop step bench (301/301 such "feasible" sizings did).
  * Finer PPD does not change it (checked at 50/200/1000): the unwrap is right, the premise is
  * wrong. Two additive readings so a reader (or an optimizer spec) can see it without a tran:
  *   pm_min  worst phase distance to -180 deg anywhere |A| > 0 dB (equals pm when the phase is
  *           monotone; <= 0 when the phase touches -180 while the gain is still above unity)
  *   gm      gain margin at the first -180 deg crossing, -999 when the phase never gets there
  * `pm` itself is unchanged. Neither guard replaces the closed-loop step: a sizing with RHP
  * poles can pass both (pm 178, pm_min 22, gm +72 measured on one) and still oscillate. The
  * settling bench (tran_step) is the stability verdict; keep it scored.
  * (masks use `<=` and `1 - mask` only -- see the `>` parser gotcha in stb.spice.)
  let gdb    = vdb(vout)
  let mb     = (gdb <= 0)
  let ma     = 1 - mb
  let pm_min = minimum(ph*ma + 999*mb)
  * |A| never above 0 dB -> no band to take a minimum over -> the NEGATIVE sentinel, so a
  * min-bound spec fails instead of sailing past (stb.spice, 'THE SEED MUST NOT BE A MEASUREMENT')
  let mok    = (pm_min <= 998)
  let pm_min = pm_min*mok + (-999)*(1 - mok)
  let ngdb   = 0 - gdb
  let gm     = -999
  meas ac gm FIND ngdb WHEN ph=0 CROSS=1
  print pm_min gm
  write
  quit
.endc
.param CAPACITOR_0=3.45888e-12
.param CAPACITOR_1=3.05077e-12
.param CURRENT_1_BIAS=1.34338e-05
.param x_dut_xm67_l=1.28048
.param x_dut_xm67_m=4
.param x_dut_xm67_w=0.812585
.param x_dut_xm11_l=0.419916
.param x_dut_xm11_m=4
.param x_dut_xm11_w=1.30344
.param x_dut_xm13_l=2.71927
.param x_dut_xm13_m=4
.param x_dut_xm13_w=1.84336
.param x_dut_xm14_l=1.90073
.param x_dut_xm14_m=4
.param x_dut_xm14_w=2.72096
.param x_dut_xm16_l=0.389321
.param x_dut_xm16_m=4
.param x_dut_xm16_w=2.25303
.param x_dut_xm18_l=1.66626
.param x_dut_xm18_m=4
.param x_dut_xm18_w=1.04925
.param x_dut_xm19_l=0.828047
.param x_dut_xm19_m=4
.param x_dut_xm19_w=0.746562
.param x_dut_xm22_l=0.778286
.param x_dut_xm22_m=4
.param x_dut_xm22_w=2.3741
.param x_dut_xm23_l=0.47607
.param x_dut_xm23_m=4
.param x_dut_xm23_w=1.20732
.param x_dut_xm10_l=0.524625
.param x_dut_xm10_m=4
.param x_dut_xm10_w=0.826477
.param RESISTOR_0=269735
.param RESISTOR_1=31632.8
.param RESISTOR_2=223442
* ---- GENERATED parameter ties (abstract/params.yaml groups/ratios) ----
* Each tied symbol is defined exactly once, by its line below; rewrite that
* .param to untie just that symbol (untying = shadowing, plan D-3).
.param x_dut_xm3_w = {x_dut_xm67_w}
.param x_dut_xm5_w = {x_dut_xm67_w}
.param x_dut_xm4_w = {x_dut_xm67_w}
.param x_dut_xm2_w = {x_dut_xm67_w}
.param x_dut_xm1_w = {x_dut_xm67_w}
.param x_dut_xm0_w = {x_dut_xm67_w}
.param x_dut_xm3_l = {x_dut_xm67_l}
.param x_dut_xm5_l = {x_dut_xm67_l}
.param x_dut_xm4_l = {x_dut_xm67_l}
.param x_dut_xm2_l = {x_dut_xm67_l}
.param x_dut_xm1_l = {x_dut_xm67_l}
.param x_dut_xm0_l = {x_dut_xm67_l}
.param x_dut_xm9_w = {x_dut_xm10_w}
.param x_dut_xm9_l = {x_dut_xm10_l}
.param x_dut_xm9_m = {x_dut_xm10_m}
.param x_dut_xm17_w = {x_dut_xm16_w}
.param x_dut_xm17_l = {x_dut_xm16_l}
.param x_dut_xm17_m = {x_dut_xm16_m}
.param x_dut_xm20_w = {x_dut_xm19_w}
.param x_dut_xm21_w = {x_dut_xm19_w}
.param x_dut_xm20_l = {x_dut_xm19_l}
.param x_dut_xm21_l = {x_dut_xm19_l}
.param x_dut_xm20_m = {x_dut_xm19_m}
.param x_dut_xm21_m = {x_dut_xm19_m}
.param x_dut_xm15_w = {x_dut_xm14_w}
.param x_dut_xm15_l = {x_dut_xm14_l}
.param x_dut_xm15_m = {x_dut_xm14_m}
.param x_dut_xm3_m = {x_dut_xm67_m*4}
.param x_dut_xm5_m = {x_dut_xm67_m*1}
.param x_dut_xm4_m = {x_dut_xm67_m*1}
.param x_dut_xm2_m = {x_dut_xm67_m*2}
.param x_dut_xm1_m = {x_dut_xm67_m*1}
.param x_dut_xm0_m = {x_dut_xm67_m*1}
.subckt amp_021_yan_az vss vdd vinn vinp vout
C0 net063 VOUT 'CAPACITOR_1'
C1 net051 vss 'CAPACITOR_0'
I0 VB1 vss 'CURRENT_1_BIAS'
R0 net078 net077 'RESISTOR_1'
R1 net078 net082 'RESISTOR_2'
R2 net094 net051 'RESISTOR_0'
XM0 VB1 VB1 vdd vdd sky130_fd_pr__pfet_01v8 l=x_dut_xm0_l m=x_dut_xm0_m w=x_dut_xm0_w
XM1 VB4 VB1 vdd vdd sky130_fd_pr__pfet_01v8 l=x_dut_xm1_l m=x_dut_xm1_m w=x_dut_xm1_w
XM10 net063 VINP net019 net019 sky130_fd_pr__pfet_01v8 l=x_dut_xm10_l m=x_dut_xm10_m w=x_dut_xm10_w
XM11 net094 net050 vdd vdd sky130_fd_pr__pfet_01v8 l=x_dut_xm11_l m=x_dut_xm11_m w=x_dut_xm11_w
XM13 VOUT net050 vdd vdd sky130_fd_pr__pfet_01v8 l=x_dut_xm13_l m=x_dut_xm13_m w=x_dut_xm13_w
XM14 VOUTN net077 DM_2 vss sky130_fd_pr__nfet_01v8 l=x_dut_xm14_l m=x_dut_xm14_m w=x_dut_xm14_w
XM15 net050 net082 net063 vss sky130_fd_pr__nfet_01v8 l=x_dut_xm15_l m=x_dut_xm15_m w=x_dut_xm15_w
XM16 net077 DM_2 vss vss sky130_fd_pr__nfet_01v8 l=x_dut_xm16_l m=x_dut_xm16_m w=x_dut_xm16_w
XM17 net082 net063 vss vss sky130_fd_pr__nfet_01v8 l=x_dut_xm17_l m=x_dut_xm17_m w=x_dut_xm17_w
XM18 VOUT net057 vss vss sky130_fd_pr__nfet_01v8 l=x_dut_xm18_l m=x_dut_xm18_m w=x_dut_xm18_w
XM19 VB4 VB4 vss vss sky130_fd_pr__nfet_01v8 l=x_dut_xm19_l m=x_dut_xm19_m w=x_dut_xm19_w
XM2 net019 VB1 vdd vdd sky130_fd_pr__pfet_01v8 l=x_dut_xm2_l m=x_dut_xm2_m w=x_dut_xm2_w
XM20 DM_2 VB4 vss vss sky130_fd_pr__nfet_01v8 l=x_dut_xm20_l m=x_dut_xm20_m w=x_dut_xm20_w
XM21 net063 VB4 vss vss sky130_fd_pr__nfet_01v8 l=x_dut_xm21_l m=x_dut_xm21_m w=x_dut_xm21_w
XM22 net094 net051 vss vss sky130_fd_pr__nfet_01v8 l=x_dut_xm22_l m=x_dut_xm22_m w=x_dut_xm22_w
XM23 net057 net094 vss vss sky130_fd_pr__nfet_01v8 l=x_dut_xm23_l m=x_dut_xm23_m w=x_dut_xm23_w
XM3 net078 VB1 vdd vdd sky130_fd_pr__pfet_01v8 l=x_dut_xm3_l m=x_dut_xm3_m w=x_dut_xm3_w
XM4 VOUTN VOUTN vdd vdd sky130_fd_pr__pfet_01v8 l=x_dut_xm4_l m=x_dut_xm4_m w=x_dut_xm4_w
XM5 net050 VOUTN vdd vdd sky130_fd_pr__pfet_01v8 l=x_dut_xm5_l m=x_dut_xm5_m w=x_dut_xm5_w
XM67 net057 VOUTN vdd vdd sky130_fd_pr__pfet_01v8 l=x_dut_xm67_l m=x_dut_xm67_m w=x_dut_xm67_w
XM9 DM_2 VINN net019 net019 sky130_fd_pr__pfet_01v8 l=x_dut_xm9_l m=x_dut_xm9_m w=x_dut_xm9_w
.ends
.end
