** GENERATED by `analog-db export-raw` — DO NOT EDIT.
** circuit=tsn_001_ptat_2t  class=temp_sensor  pdk=gf180mcu  testbench=temp_sweep  corner=tt
** Self-contained deck: testbench + bound params + lowered DUT (.subckt tsn_001_ptat_2t).
** PDK corner libs resolve by BARE NAME on the image's ngspice sourcepath — run in a
** PDK-enabled env (the base image / api container), NOT a bare host:
**   docker run --rm -i spicexplorer-spice-base:local \
**     bash -lc 'd=$(mktemp -d) && cat > $d/c.spice && cd $d && ngspice -b c.spice' < raw/tsn_001_ptat_2t/gf180mcu/temp_sweep.spice
*----------------------------------------------------------*
** params: 6 free + 0 frozen knobs (sizing.yaml) · 0 tied · 0 ratio-derived (abstract/params.yaml) · 1 testbench params
** AUTHORED TEMPLATE — temp_sensor/temp_sweep (plan D-4): temperature sweep of a PTAT sensor.
** Sweeps the ambient temperature and extracts the output slope (dVout/dT, the sensor resolution),
** the 25 degC output, and the box-method spread (Vmax-Vmin)/Vavg/range over the range.
** Bindings: DUT PORT_LINE VDD, TSTART TSTOP TSTEP TLO THI, PDK_INCLUDE.
.include design.ngspice
.lib sm141064.ngspice noise_corner
.lib sm141064.ngspice nfet_03v3_t
.lib sm141064.ngspice pfet_03v3_t
.lib sm141064.ngspice fets_mm
.lib sm141064.ngspice res_typical
.lib sm141064.ngspice mimcap_typical
.lib sm141064.ngspice cap_mim
.temp 27

.param VDD=1.2

Vdd  vdd 0 dc {VDD}
Vss  vss 0 dc 0

XDUT vdd vout vss tsn_001_ptat_2t

.control
  set filetype=ascii
  dc temp -20 120 5
  meas dc v_out_25c FIND v(vout) AT=25
  meas dc v_lo  FIND v(vout) AT=-20
  meas dc v_hi  FIND v(vout) AT=120
  meas dc vmax  MAX v(vout) FROM=-20 TO=120
  meas dc vmin  MIN v(vout) FROM=-20 TO=120
  meas dc vavg  AVG v(vout) FROM=-20 TO=120
  let sens_v_per_c = (v_hi - v_lo) / (120 - (-20))
  print sens_v_per_c
  let tc_box_ppm = (vmax - vmin) / vavg / (120 - (-20)) * 1e6
  print tc_box_ppm
  write
  quit
.endc
.param x_dut_xm0_w=8u
.param x_dut_xm0_l=0.28u
.param x_dut_xm0_m=8
.param x_dut_xm1_w=4u
.param x_dut_xm1_l=1u
.param x_dut_xm1_m=8
.subckt tsn_001_ptat_2t vdd vout vss
XM0 vdd vout vout vss nfet_03v3 l=x_dut_xm0_l m=x_dut_xm0_m w=x_dut_xm0_w
XM1 vout vout vss vss nfet_03v3 l=x_dut_xm1_l m=x_dut_xm1_m w=x_dut_xm1_w
.ends
.end
