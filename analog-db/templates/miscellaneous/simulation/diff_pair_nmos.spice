** sch_path: diff_pair_nmos.sch
**.subckt diff_pair_nmos vinp vinn CM_tail drain_n drain_p VSS
*.ipin vinp
*.ipin vinn
*.ipin CM_tail
*.ipin drain_n
*.ipin drain_p
*.ipin VSS
XM1 drain_p vinp CM_tail VSS sg13_lv_nmos w=0.15u l=0.13u ng=1 m=1
XM2 drain_n vinn CM_tail VSS sg13_lv_nmos w=0.15u l=0.13u ng=1 m=1
**.ends
.end
