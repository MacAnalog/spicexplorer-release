** GENERATED by `analog-db export-raw` — DO NOT EDIT.
** circuit=ldo_008_fer_mirror_ota  class=ldo  pdk=ihp-sg13g2  testbench=dropout  corner=tt
** Self-contained deck: testbench + bound params + lowered DUT (.subckt ldo_008_fer_mirror_ota).
** PDK corner libs resolve by BARE NAME on the image's ngspice sourcepath — run in a
** PDK-enabled env (the base image / api container), NOT a bare host:
**   docker run --rm -i spicexplorer-spice-base:local \
**     bash -lc 'd=$(mktemp -d) && cat > $d/c.spice && cd $d && ngspice -b c.spice' < raw/ldo_008_fer_mirror_ota/ihp-sg13g2/dropout.spice
*----------------------------------------------------------*
** params: 11 free + 9 frozen knobs (sizing.yaml) · 7 tied · 0 ratio-derived (abstract/params.yaml) · 0 testbench params
** AUTHORED TEMPLATE — ldo/dropout: the smallest (Vin - Vout) at which the regulator still
** REGULATES, under heavy load. Vin is swept upward and dropout is read at the first point where
** the output is genuinely in regulation.
**
** REWRITTEN 2026-07-21. The previous form was
**     meas dc vin_at WHEN v(vout)=1.1 RISE=1
**     let v_dropout = vin_at - 1.1
** i.e. purely "when does vout first rise past a threshold". That cannot tell REGULATION from a
** DEAD PASS DEVICE, and it fails in the worst possible direction — optimistically. When the loop
** is not working the pass transistor sits fully on, so vout simply follows vin; vout then crosses
** VOUT_THRESH at vin ~ VOUT_THRESH and the bench reports a dropout of ~0. A completely broken
** regulator scores a PERFECT dropout number.
**
** That is not hypothetical: it green-lit a real candidate here. A resistor-biased variant of
** ldo_005_buffered_ref reported dropout 0.090 V (against 0.490 V for the working design) while
** actually RAILING below ~3.1 V — vout was 2.59 V at vin 2.6 V. Only line_reg (1.185 V) caught it.
** This is the same class of defect as the amplifier ICMR bench measuring rail coincidence instead
** of tracking, and it takes the same cure: an ACTIVITY criterion alongside the level test.
**
** In regulation now requires BOTH:
**   * the output is at its target:      |vout - VOUT_NOM| <= VREG_TOL
**   * the output is not following vin:  |dvout/dvin| <= REG_SLOPE_MAX
** A regulating LDO has dvout/dvin ~ line-regulation slope (1e-3 or less); a railed one has ~1, so
** the slope test separates them cleanly no matter where the level test happens to land.
**
** Bindings: DUT PORT_LINE ILOAD VDD_START VDD_STOP VDD_STEP VOUT_NOM VREG_TOL REG_SLOPE_MAX
**           PDK_INCLUDE.
** VOUT_NOM defaults to the datasheet's default_conditions.vout typical value; VREG_TOL and
** REG_SLOPE_MAX have defaults in assemble.py, so existing circuits need no edits. The legacy
** VOUT_THRESH binding is no longer used — a threshold alone is exactly what was wrong.
.lib cornerMOSlv.lib mos_tt
.temp 27

Vdd  vdd 0 dc 1.0
Vss  vss 0 dc 0
Iload vout 0 dc 1m

XDUT vdd vout vss ldo_008_fer_mirror_ota

.control
  set filetype=ascii
  dc Vdd 1.0 1.8 0.01
  let vo    = v(vout)
  let vsw   = v(vdd)
  let dvo   = deriv(vo)
  let dvi   = deriv(vsw)
  let slope = dvo / dvi
  let inreg = (abs(vo - 1.2) <= 0.05) & (abs(slope) <= 0.1)
  let npts  = length(inreg)
  let k     = 0
  let found = 0
  let vin_at = 0
  let vout_at = 0
  while k < npts
    if found < 0.5
      if inreg[k] > 0.5
        let vin_at  = vsw[k]
        let vout_at = vo[k]
        let found   = 1
      end
    end
    let k = k + 1
  end
  * NaN rather than a fabricated number when the sweep never reaches regulation — an honest
  * "this circuit does not regulate anywhere in the swept range".
  if found < 0.5
    let v_dropout = 0/0
  else
    let v_dropout = vin_at - vout_at
  end
  print vin_at vout_at v_dropout
  write
  quit
.endc
.param x_dut_xmnb_w=8u
.param x_dut_xmnb_l=0.5u
.param x_dut_xmdr_w=6u
.param x_dut_xmdr_l=0.3u
.param x_dut_xmld_w=8u
.param x_dut_xmld_l=0.5u
.param x_dut_xmp_w=8u
.param x_dut_xmp_l=0.2u
.param x_rcomp=2000
.param x_ccomp=160e-12
.param x_dut_rt_value=9000
.param x_vref_val=0.6
.param x_ibias_val=20e-6
.param x_dut_xmnb_m=1
.param x_dut_xmnt_m=4
.param x_dut_xmdr_m=4
.param x_dut_xmdf_m=4
.param x_dut_xmld_m=4
.param x_dut_xmlm_m=4
.param x_dut_xmp_m=60
* ---- GENERATED parameter ties (abstract/params.yaml groups/ratios) ----
* Each tied symbol is defined exactly once, by its line below; rewrite that
* .param to untie just that symbol (untying = shadowing, plan D-3).
.param x_dut_xmnt_w = {x_dut_xmnb_w}
.param x_dut_xmnt_l = {x_dut_xmnb_l}
.param x_dut_xmdf_w = {x_dut_xmdr_w}
.param x_dut_xmdf_l = {x_dut_xmdr_l}
.param x_dut_xmlm_w = {x_dut_xmld_w}
.param x_dut_xmlm_l = {x_dut_xmld_l}
.param x_dut_rb_value = {x_dut_rt_value}
.subckt ldo_008_fer_mirror_ota vdd vout vss
CC czero vout x_ccomp
IBI vdd nbias dc {x_ibias_val}
RB fb vss x_dut_rb_value
RC egate czero x_rcomp
RT vout fb x_dut_rt_value
VREF vref vss dc {x_vref_val}
XMDF ldiode fb tail vss sg13_lv_nmos l=x_dut_xmdf_l m=x_dut_xmdf_m w=x_dut_xmdf_w
XMDR egate vref tail vss sg13_lv_nmos l=x_dut_xmdr_l m=x_dut_xmdr_m w=x_dut_xmdr_w
XMLD ldiode ldiode vdd vdd sg13_lv_pmos l=x_dut_xmld_l m=x_dut_xmld_m w=x_dut_xmld_w
XMLM egate ldiode vdd vdd sg13_lv_pmos l=x_dut_xmlm_l m=x_dut_xmlm_m w=x_dut_xmlm_w
XMNB nbias nbias vss vss sg13_lv_nmos l=x_dut_xmnb_l m=x_dut_xmnb_m w=x_dut_xmnb_w
XMNT tail nbias vss vss sg13_lv_nmos l=x_dut_xmnt_l m=x_dut_xmnt_m w=x_dut_xmnt_w
XMP vout egate vdd vdd sg13_lv_pmos l=x_dut_xmp_l m=x_dut_xmp_m w=x_dut_xmp_w
.ends
.end
