** GENERATED by `analog-db generate` — DO NOT EDIT. Source: abstract/netlist.spice → gf180mcu
* cmp_001_hyst_diffpair (emitted by spicexplorer-circuitgraph)
RHN n1 hn x_dut_rhn_value
RHP n1 hp x_dut_rhp_value
RT tail vss x_rtail
XMB1N b1 n1 vss vss nfet_03v3 l=x_dut_xmb1n_l m=x_dut_xmb1n_m w=x_dut_xmb1n_w
XMB1P b1 n1 vdd vdd pfet_03v3 l=x_dut_xmb1p_l m=x_dut_xmb1p_m w=x_dut_xmb1p_w
XMB2N b2 b1 vss vss nfet_03v3 l=x_dut_xmb2n_l m=x_dut_xmb2n_m w=x_dut_xmb2n_w
XMB2P b2 b1 vdd vdd pfet_03v3 l=x_dut_xmb2p_l m=x_dut_xmb2p_m w=x_dut_xmb2p_w
XMB3N vout b2 vss vss nfet_03v3 l=x_dut_xmb3n_l m=x_dut_xmb3n_m w=x_dut_xmb3n_w
XMB3P vout b2 vdd vdd pfet_03v3 l=x_dut_xmb3p_l m=x_dut_xmb3p_m w=x_dut_xmb3p_w
XMHN hn vout vss vss nfet_03v3 l=x_dut_xmhn_l m=x_dut_xmhn_m w=x_dut_xmhn_w
XMHP hp vout vdd vdd pfet_03v3 l=x_dut_xmhp_l m=x_dut_xmhp_m w=x_dut_xmhp_w
XMIN n2 vinn tail vss nfet_03v3 l=x_dut_xmin_l m=x_dut_xmin_m w=x_dut_xmin_w
XMIP n1 vinp tail vss nfet_03v3 l=x_dut_xmip_l m=x_dut_xmip_m w=x_dut_xmip_w
XMPLD n2 n2 vdd vdd pfet_03v3 l=x_dut_xmpld_l m=x_dut_xmpld_m w=x_dut_xmpld_w
XMPLM n1 n2 vdd vdd pfet_03v3 l=x_dut_xmplm_l m=x_dut_xmplm_m w=x_dut_xmplm_w
.end
