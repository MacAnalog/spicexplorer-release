** Abstract 2-bit current-mode PAM-4 DAC driver (Inac et al., EuMIC 2022) — PDK-neutral topology.
** AUTHORED source of truth (plan D-2), ported from the EIC-designer `lumped-broadband-driver`
** verified reference (16/16 requirements, dual sign-off) and the agentic IHP SG13G2 port
** (drawings/pam4-driver-2-bit-dac-HBT/ported-netlists/dut/dut_pam4.spice).
**
** Topology: fully differential 2-bit binary-weighted current-mode DAC. LSB = 1 differential
** cascode gain cell (L0); MSB = 2 identical cells in parallel (M0, M1). Each cell is a
** differential pair (npn Nx) with capacitive emitter degeneration (R_E bridged by C_deg for
** inductorless peaking) driving a common-base cascode, current-summing into shared collector
** loads. The paper's binary DAC weight (MSB = 2x LSB) is realized by cell COUNT, not sizing.
**
** Bias-port VCCS convention (the key optimizer affordance): each cell's tail is an ideal VCCS
** `Gtail t 0 <bias> 0 1m` — 1 mA per volt on the `blsb`/`bmsb` port. So the per-cell tail
** current in mA equals the port voltage, and the tail is a plain scalar knob the testbench sets
** with a DC source (x_dut_itail_ma). One DUT netlist therefore serves the ramped-tran, .op and
** .ac testbenches unchanged.
**
** Device model: the HBTs are `X`-prefixed subckt instances of the IHP `npn13G2` VBIC card, which
** circuitgraph treats as SUBCKT black boxes (it has no BJT device type — the CMOS-only leaf-tool
** gap 4.4). There is a single PDK and no neutral->PDK model retarget for a bipolar primitive, so
** the model name `npn13G2` is written directly here (not a neutral `npn`); the abstract and the
** lowered ihp-sg13g2 netlist are therefore the same topology.
** Sizing knobs (x_dut_*) are declared in pdk/ihp-sg13g2/sizing.yaml; defaults = the EIC golden.
** Subckt port order (= circuit.yaml ports): lsbp lsbn msbp msbn outp outn vcc vcasc vcmb blsb bmsb
**.subckt drv_001_pam4_sige_dac lsbp lsbn msbp msbn outp outn vcc vcasc vcmb blsb bmsb
* --- LSB cell L0 (1x) ---
XQ1L0 c1L0 lsbp e1L0 0 npn13G2 Nx=x_dut_nx
XQ2L0 c2L0 lsbn e2L0 0 npn13G2 Nx=x_dut_nx
XQ3L0 outp vcasc c1L0 0 npn13G2 Nx=x_dut_nx
XQ4L0 outn vcasc c2L0 0 npn13G2 Nx=x_dut_nx
RE1L0 e1L0 tlsb0 {x_dut_re}
RE2L0 e2L0 tlsb0 {x_dut_re}
CdegL0 e1L0 e2L0 {x_dut_cdeg_ff*1f}
GtailL0 tlsb0 0 blsb 0 1m
* --- MSB cell M0 (of 2x) ---
XQ1M0 c1M0 msbp e1M0 0 npn13G2 Nx=x_dut_nx
XQ2M0 c2M0 msbn e2M0 0 npn13G2 Nx=x_dut_nx
XQ3M0 outp vcasc c1M0 0 npn13G2 Nx=x_dut_nx
XQ4M0 outn vcasc c2M0 0 npn13G2 Nx=x_dut_nx
RE1M0 e1M0 tmsb0 {x_dut_re}
RE2M0 e2M0 tmsb0 {x_dut_re}
CdegM0 e1M0 e2M0 {x_dut_cdeg_ff*1f}
GtailM0 tmsb0 0 bmsb 0 1m
* --- MSB cell M1 (of 2x) ---
XQ1M1 c1M1 msbp e1M1 0 npn13G2 Nx=x_dut_nx
XQ2M1 c2M1 msbn e2M1 0 npn13G2 Nx=x_dut_nx
XQ3M1 outp vcasc c1M1 0 npn13G2 Nx=x_dut_nx
XQ4M1 outn vcasc c2M1 0 npn13G2 Nx=x_dut_nx
RE1M1 e1M1 tmsb1 {x_dut_re}
RE2M1 e2M1 tmsb1 {x_dut_re}
CdegM1 e1M1 e2M1 {x_dut_cdeg_ff*1f}
GtailM1 tmsb1 0 bmsb 0 1m
* --- shared collector loads + base terminations (50 ohm/side references) ---
Rcp outp vcc {x_dut_rc}
Rcn outn vcc {x_dut_rc}
Rblsbp lsbp vcmb {x_dut_rb}
Rblsbn lsbn vcmb {x_dut_rb}
Rbmsbp msbp vcmb {x_dut_rb}
Rbmsbn msbn vcmb {x_dut_rb}
**.ends
.end
