** GENERATED by `analog-db export-raw` — DO NOT EDIT.
** circuit=amp_001_5t  class=amplifier  pdk=ihp-sg13g2  testbench=cmrr_vcm  corner=tt
** Self-contained deck: testbench + bound params + lowered DUT (.subckt amp_001_5t).
** PDK corner libs resolve by BARE NAME on the image's ngspice sourcepath — run in a
** PDK-enabled env (the base image / api container), NOT a bare host:
**   docker run --rm -i spicexplorer-spice-base:local \
**     bash -lc 'd=$(mktemp -d) && cat > $d/c.spice && cd $d && ngspice -b c.spice' < raw/amp_001_5t/ihp-sg13g2/cmrr_vcm.spice
*----------------------------------------------------------*
** params: 8 free + 4 frozen knobs (sizing.yaml) · 6 tied · 0 ratio-derived (abstract/params.yaml) · 4 testbench params
** AUTHORED TEMPLATE — amplifier/cmrr_vcm (plan D-4/D-5): common-mode rejection.
** The DUT is closed in a unity-gain buffer and the SAME 1 V AC rides on both inputs:
** Vinp carries ac 1, and the vinn–vout short (Vfb) also carries ac 1, so vinn = vout + vac.
** The differential input is then vinp − vinn = −vout while the common mode moves by a full
** volt; solving vout = Ad·(−vout) + Acm·vac gives vout ≈ (Acm/Ad)·vac = vac/CMRR, so
** CMRR = −20·log10|vout| = −vdb(vout) (vac = 1). Reported at FSTART (the DC-band floor).
** Bindings: DUT PORT_LINE VDD VCM IBIAS CL FSTART FSTOP PPD PDK_INCLUDE.
.lib cornerMOSlv.lib mos_tt
.temp 27

.param VDD=1.5
.param VCM=0.8
.param IBIAS=20u
.param CL=50f

Vdd  vdd 0 dc {VDD}          ; supply quiet — isolate the common-mode path
Vss  vss 0 dc 0
Ibias vdd ibias dc {IBIAS}
CLoad vout 0 {CL}

Vinp vinp 0 dc {VCM} ac 1    ; +1 V AC on the + input ...
Vfb  vinn vout dc 0 ac 1     ; ... and the same +1 V AC lifted onto vinn (unity buffer at DC)

XDUT vdd vout vinp vinn ibias vss amp_001_5t

.control
  set filetype=ascii
  ac dec 101 1k 1G
  let cmrr = -vdb(vout)
  meas ac cmrr_db FIND cmrr AT=1k
  write
  quit
.endc
.param x_dut_xm1_w=10.0u
.param x_dut_xm1_l=10.0u
.param x_dut_xm3_w=10.0u
.param x_dut_xm3_l=7.0u
.param x_dut_xm5_w=3.8u
.param x_dut_xm5_l=1.0u
.param x_dut_xm6_w=3.8u
.param x_dut_xm6_l=1.0u
.param x_dut_xm1_m=1
.param x_dut_xm3_m=1
.param x_dut_xm5_m=1
.param x_dut_xm6_m=1
* ---- GENERATED parameter ties (abstract/params.yaml groups/ratios) ----
* Each tied symbol is defined exactly once, by its line below; rewrite that
* .param to untie just that symbol (untying = shadowing, plan D-3).
.param x_dut_xm2_w = {x_dut_xm1_w}
.param x_dut_xm2_l = {x_dut_xm1_l}
.param x_dut_xm2_m = {x_dut_xm1_m}
.param x_dut_xm4_w = {x_dut_xm3_w}
.param x_dut_xm4_l = {x_dut_xm3_l}
.param x_dut_xm4_m = {x_dut_xm3_m}
.subckt amp_001_5t vdd vout vinp vinn ibias vss
XM1 outm vinp tail vss sg13_lv_nmos l=x_dut_xm1_l m=x_dut_xm1_m w=x_dut_xm1_w
XM2 vout vinn tail vss sg13_lv_nmos l=x_dut_xm2_l m=x_dut_xm2_m w=x_dut_xm2_w
XM3 outm outm vdd vdd sg13_lv_pmos l=x_dut_xm3_l m=x_dut_xm3_m w=x_dut_xm3_w
XM4 vout outm vdd vdd sg13_lv_pmos l=x_dut_xm4_l m=x_dut_xm4_m w=x_dut_xm4_w
XM5 tail ibias vss vss sg13_lv_nmos l=x_dut_xm5_l m=x_dut_xm5_m w=x_dut_xm5_w
XM6 ibias ibias vss vss sg13_lv_nmos l=x_dut_xm6_l m=x_dut_xm6_m w=x_dut_xm6_w
.ends
.end
