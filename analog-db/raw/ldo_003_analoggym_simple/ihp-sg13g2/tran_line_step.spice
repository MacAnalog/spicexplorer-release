** GENERATED by `analog-db export-raw` — DO NOT EDIT.
** circuit=ldo_003_analoggym_simple  class=ldo  pdk=ihp-sg13g2  testbench=tran_line_step  corner=tt
** Self-contained deck: testbench + bound params + lowered DUT (.subckt ldo_003_analoggym_simple).
** PDK corner libs resolve by BARE NAME on the image's ngspice sourcepath — run in a
** PDK-enabled env (the base image / api container), NOT a bare host:
**   docker run --rm -i spicexplorer-spice-base:local \
**     bash -lc 'd=$(mktemp -d) && cat > $d/c.spice && cd $d && ngspice -b c.spice' < raw/ldo_003_analoggym_simple/ihp-sg13g2/tran_line_step.spice
*----------------------------------------------------------*
** params: 14 free + 0 frozen knobs (sizing.yaml) · 4 tied · 0 ratio-derived (abstract/params.yaml) · 0 testbench params
** AUTHORED TEMPLATE — ldo/tran_line_step: fast lo->hi->lo supply step at fixed load;
** peak-to-peak output deviation. The time-domain complement of line_regulation's DC sweep,
** following the vendored "Line Transient" benches (circuits/ldo_004_basic_pmos/reference/ltspice/
** Line Transient_6p27..28.asc): the p2p window spans both supply edges, so v_line_pp includes
** the transient spikes AND any DC line-regulation shift between the two rails — keep both
** rails above the dropout knee.
** Bindings: DUT PORT_LINE VDD_LO VDD_HI ILOAD COUT TSTART TEDGE TPULSE TPER TSTEP TSTOP
**   PDK_INCLUDE.
.lib cornerMOShv.lib mos_tt
.lib cornerRES.lib res_typ
.temp 27

Vdd  vdd 0 pulse(1.95 2.15 5u 100n 100n 20u 50u)
Vss  vss 0 dc 0
Iload vout 0 dc 10m
CLoad vout 0 50p

XDUT vdd vout vss ldo_003_analoggym_simple

.control
  set filetype=ascii
  tran 10n 45u
  meas tran vout_max MAX v(vout) from=5u to=45u
  meas tran vout_min MIN v(vout) from=5u to=45u
  let v_line_pp = vout_max - vout_min
  print v_line_pp
  write
  quit
.endc
.param x_dut_xm1_w=160u
.param x_dut_xm1_l=0.45u
.param x_dut_xm4_w=160u
.param x_dut_xm4_l=0.45u
.param x_dut_xm5_w=30u
.param x_dut_xm5_l=1u
.param x_dut_xmp_w=20u
.param x_dut_xmp_l=0.4u
.param x_dut_xmp_m=180
.param r_z=500
.param c_comp=60p
.param vref_val=1.8
.param vb_val=1.0
.param r_bleed=27k
* ---- GENERATED parameter ties (abstract/params.yaml groups/ratios) ----
* Each tied symbol is defined exactly once, by its line below; rewrite that
* .param to untie just that symbol (untying = shadowing, plan D-3).
.param x_dut_xm2_w = {x_dut_xm1_w}
.param x_dut_xm2_l = {x_dut_xm1_l}
.param x_dut_xm3_w = {x_dut_xm4_w}
.param x_dut_xm3_l = {x_dut_xm4_l}
.subckt ldo_003_analoggym_simple vdd vout vss
CC ncz vout 'c_comp'
RZ ncz ngate 'r_z'
R_BLEED vout vss 'r_bleed'
VB vb vss dc {vb_val}
VREF vref vss dc {vref_val}
XM1 ndiode vout ntail vss sg13_hv_nmos l=x_dut_xm1_l w=x_dut_xm1_w
XM2 ngate vref ntail vss sg13_hv_nmos l=x_dut_xm2_l w=x_dut_xm2_w
XM3 ngate ndiode vdd vdd sg13_hv_pmos l=x_dut_xm3_l w=x_dut_xm3_w
XM4 ndiode ndiode vdd vdd sg13_hv_pmos l=x_dut_xm4_l w=x_dut_xm4_w
XM5 ntail vb vss vss sg13_hv_nmos l=x_dut_xm5_l w=x_dut_xm5_w
XMP vout ngate vdd vdd sg13_hv_pmos l=x_dut_xmp_l m=x_dut_xmp_m w=x_dut_xmp_w
.ends
.end
