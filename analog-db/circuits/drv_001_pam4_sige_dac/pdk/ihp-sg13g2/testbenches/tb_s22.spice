* TB[drv_001] output return loss S22 (.op/.ac, ngspice-45)
* Emits: s22_50g_db. Output port driven through the 50 ohm/side reference (the load Rl* is REPLACED
* by the measurement source, as in the paper's VNA convention); Zout = Vout/Iout, 2*Z0 = 100 ohm.
.param x_dut_nx=3 x_dut_re=2.5 x_dut_cdeg_ff=20 x_dut_rc=50 x_dut_rb=50
.param x_dut_vcasc=3.25 x_dut_vcm_in=1.9 x_dut_itail_ma=16 x_dut_vcc=4
Vcc   vcc   0 DC {x_dut_vcc}
Vcasc vcasc 0 DC {x_dut_vcasc}
Vcmb  vcmb  0 DC {x_dut_vcm_in}
Vblsb blsb  0 DC {x_dut_itail_ma}
Vbmsb bmsb  0 DC {x_dut_itail_ma}
XDUT lsbp lsbn msbp msbn outp outn vcc vcasc vcmb blsb bmsb drv_001_pam4_sige_dac
Vslsbp slsbp 0 DC {x_dut_vcm_in}
Vslsbn slsbn 0 DC {x_dut_vcm_in}
Rslsbp slsbp lsbp 50
Rslsbn slsbn lsbn 50
Vsmsbp smsbp 0 DC {x_dut_vcm_in}
Vsmsbn smsbn 0 DC {x_dut_vcm_in}
Rsmsbp smsbp msbp 50
Rsmsbn smsbn msbn 50
Vsop sop 0 DC {x_dut_vcc} AC 0.5
Vson son 0 DC {x_dut_vcc} AC -0.5
Rsop sop outp 50
Rson son outn 50
.include dut.spice
.lib "cornerHBT.lib" hbt_typ
.options gmin=1e-12 reltol=1e-3
.control
op
ac dec 20 1e8 1e11
let vodiff = v(outp)-v(outn)
let vsrc  = v(sop)-v(son)
let iout  = (vsrc - vodiff)/100
let zout  = vodiff/iout
let s22db = db((zout-100)/(zout+100))
meas ac s22_50g_db find s22db at=50e9
print s22_50g_db
.endc
.GLOBAL GND
.end
