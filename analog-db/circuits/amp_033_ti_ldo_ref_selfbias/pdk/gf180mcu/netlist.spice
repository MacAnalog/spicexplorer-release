** GENERATED by `analog-db generate` — DO NOT EDIT. Source: abstract/netlist.spice → gf180mcu
* amp_033_ti_ldo_ref_selfbias (emitted by spicexplorer-circuitgraph)
CC ncz vout 'c_comp'
RZ nb ncz 'r_z'
XM1 na vinn tail vss nfet_06v0 l=x_dut_xm1_l w=x_dut_xm1_w
XM2 nb vinp tail vss nfet_06v0 l=x_dut_xm2_l w=x_dut_xm2_w
XM3 na na vdd vdd pfet_06v0 l=x_dut_xm3_l w=x_dut_xm3_w
XM4 nb na vdd vdd pfet_06v0 l=x_dut_xm4_l w=x_dut_xm4_w
XM5 vout nb vdd vdd pfet_06v0 l=x_dut_xm5_l w=x_dut_xm5_w
XMB0 ibias ibias vss vss nfet_06v0 l=x_dut_xmb0_l w=x_dut_xmb0_w
XMBC tail ibias vss vss nfet_06v0 l=x_dut_xmbc_l m=x_dut_xmbc_m w=x_dut_xmbc_w
XMBO vout ibias vss vss nfet_06v0 l=x_dut_xmbo_l m=x_dut_xmbo_m w=x_dut_xmbo_w
XMBP ibias ibias vdd vdd pfet_06v0 l=x_dut_xmbp_l w=x_dut_xmbp_w
.end
