** GENERATED by `analog-db export-raw` — DO NOT EDIT.
** circuit=amp_029_two_stage_miller_comp  class=amplifier  pdk=tsmc-n65  testbench=dc_op  corner=tt
** Self-contained deck: testbench + bound params + lowered DUT (.subckt amp_029_two_stage_miller_comp).
** PDK corner libs resolve by BARE NAME on the image's ngspice sourcepath — run in a
** PDK-enabled env (the base image / api container), NOT a bare host:
**   docker run --rm -i spicexplorer-spice-base:local \
**     bash -lc 'd=$(mktemp -d) && cat > $d/c.spice && cd $d && ngspice -b c.spice' < raw/amp_029_two_stage_miller_comp/tsmc-n65/dc_op.spice
*----------------------------------------------------------*
** params: 14 free + 6 frozen knobs (sizing.yaml) · 16 tied · 0 ratio-derived (abstract/params.yaml) · 2 testbench params
** AUTHORED TEMPLATE — amplifier/dc_op_diff (self-biased, differential-output DC op point).
** DC operating point for a DUT with no external ibias port and a true differential output
** (voutp/voutn): supply current + the achieved output offset/common-mode. Matched inputs
** (vinp=vinn=VCM) into a symmetric FD topology give a well-defined offset regardless of
** open-loop gain (see ac_open_loop_diff.spice) — no bias-wrap/loop-closing needed. The
** output COMMON MODE (vocm) is a sizing concern (stage-2 pull-up vs. pull-down balance),
** which is exactly what this analysis exists to surface.
**
** Assumes a self-biased, differential-output DUT port order:
**   .subckt <id> vinp vinn voutp voutn vdd vss
** Required bindings: DUT PORT_LINE VDD VCM PDK_INCLUDE.
.lib tsmc_n65_models.scs tt
.temp 27

.param VDD=1.2
.param VCM=0.6

Vdd  vdd 0 dc {VDD}
Vss  vss 0 dc 0
Vcm  vcm 0 dc {VCM}
Vinp vinp vcm dc 0
Vinn vinn vcm dc 0

XDUT vinp vinn voutp voutn vdd vss amp_029_two_stage_miller_comp

.control
  set filetype=ascii
  op
  let i_supply = abs(i(Vdd))
  * vos = output offset (voutp - voutn at matched inputs, ideally ~0)
  let vos = v(voutp) - v(voutn)
  * vocm = achieved output common mode (diagnostic — not a formal datasheet metric)
  let vocm = (v(voutp) + v(voutn))/2
  print i_supply vos vocm
  write
  quit
.endc
.param x_dut_xm1_w=5e-06
.param x_dut_xm1_l=5e-07
.param x_dut_xm3_w=5e-06
.param x_dut_xm3_l=2e-06
.param x_dut_xm5_w=4e-05
.param x_dut_xm5_l=2e-06
.param x_dut_xm6_w=3.5e-06
.param x_dut_xm6_l=2e-06
.param x_dut_xm7_w=1.05e-05
.param x_dut_xm8_w=3.5e-06
.param x_dut_r1_value=8000.0
.param x_dut_c1_value=3e-12
.param i_bias=2e-05
.param vbl=0.7744
.param x_dut_xm1_m=1
.param x_dut_xm3_m=1
.param x_dut_xm5_m=1
.param x_dut_xm6_m=1
.param x_dut_xm7_m=1
.param x_dut_xm8_m=1
* ---- GENERATED parameter ties (abstract/params.yaml groups/ratios) ----
* Each tied symbol is defined exactly once, by its line below; rewrite that
* .param to untie just that symbol (untying = shadowing, plan D-3).
.param x_dut_xm10_l = {x_dut_xm6_l}
.param x_dut_xm7_l = {x_dut_xm6_l}
.param x_dut_xm8_l = {x_dut_xm6_l}
.param x_dut_xm2_w = {x_dut_xm1_w}
.param x_dut_xm2_l = {x_dut_xm1_l}
.param x_dut_xm2_m = {x_dut_xm1_m}
.param x_dut_xm4_w = {x_dut_xm3_w}
.param x_dut_xm4_l = {x_dut_xm3_l}
.param x_dut_xm4_m = {x_dut_xm3_m}
.param x_dut_xm9_w = {x_dut_xm5_w}
.param x_dut_xm9_l = {x_dut_xm5_l}
.param x_dut_xm9_m = {x_dut_xm5_m}
.param x_dut_xm10_w = {x_dut_xm7_w}
.param x_dut_xm10_m = {x_dut_xm7_m}
.param x_dut_r2_value = {x_dut_r1_value}
.param x_dut_c2_value = {x_dut_c1_value}
.subckt amp_029_two_stage_miller_comp vinp vinn voutp voutn vdd vss
C1 mill_p voutp 'x_dut_c1_value'
C2 mill_n voutn 'x_dut_c2_value'
IBIAS vdd ref dc {i_bias}
R1 stg1p mill_p 'x_dut_r1_value'
R2 stg1n mill_n 'x_dut_r2_value'
VBL vbl vss dc {vbl}
XM1 stg1p vinp tail vss nch_lvt l=x_dut_xm1_l m=x_dut_xm1_m w=x_dut_xm1_w
XM10 voutn ref vss vss nch_lvt l=x_dut_xm10_l m=x_dut_xm10_m w=x_dut_xm10_w
XM2 stg1n vinn tail vss nch_lvt l=x_dut_xm2_l m=x_dut_xm2_m w=x_dut_xm2_w
XM3 stg1p vbl vdd vdd pch_lvt l=x_dut_xm3_l m=x_dut_xm3_m w=x_dut_xm3_w
XM4 stg1n vbl vdd vdd pch_lvt l=x_dut_xm4_l m=x_dut_xm4_m w=x_dut_xm4_w
XM5 voutp stg1p vdd vdd pch_lvt l=x_dut_xm5_l m=x_dut_xm5_m w=x_dut_xm5_w
XM6 ref ref vss vss nch_lvt l=x_dut_xm6_l m=x_dut_xm6_m w=x_dut_xm6_w
XM7 voutp ref vss vss nch_lvt l=x_dut_xm7_l m=x_dut_xm7_m w=x_dut_xm7_w
XM8 tail ref vss vss nch_lvt l=x_dut_xm8_l m=x_dut_xm8_m w=x_dut_xm8_w
XM9 voutn stg1n vdd vdd pch_lvt l=x_dut_xm9_l m=x_dut_xm9_m w=x_dut_xm9_w
.ends
.end
