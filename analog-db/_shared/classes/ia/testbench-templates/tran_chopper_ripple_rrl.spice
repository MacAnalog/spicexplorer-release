** AUTHORED TEMPLATE — ia/tran_chopper_ripple_rrl (plan_hierarchical_composition P4; the
** tran_chopper_ripple bench for a CCIA WITH a composed ripple-reduction loop: adds the
** two-phase SC clock pair clk_phi_1/clk_phi_2 (exact complements at 2*FCHOP, phi_1 in phase
** with the chop clocks — the tran_rrl_sense convention; the RRL demod clock is wired
** to clk_chout INSIDE the composite). Same three measures, so v_ripple_pp is directly
** comparable RRL-on vs the RRL-less sibling (ia_002/ia_003), PLUS the RRL's own
** headline: v_ripple0_pp, the ZERO-INPUT output ripple in window A (the up-modulated
** offset the RRL nulls — input-independent, so window A is its honest home). Choose
** T1/windows LATE enough for the RRL integrator to settle (ms-scale at typical
** sizings), not just the diff loop.
** Base template (ia/tran_chopper_ripple P3; the
** CLOCKED bench family for the chopper subfamily — plan S4.6 "ia - chopper": a static
** .ac/.noise on the frozen network is the wrong analysis for these figures).
** One combined clocked transient: all chopper clock pairs run at FCHOP; the differential
** input is 0 until T1 (window A -> chopped output offset + ripple), then steps to VIN_DC
** (window B -> chopped closed-loop gain). Measures, all in-deck:
**   v_ripple_pp   peak-to-peak differential output ripple in the settled window B
**   gain_cl       (avgB - avgA)/VIN_DC — the chopped closed-loop gain
**   vos_residual  window-A output average, input-referred through gain_cl
** Windows WA0..WA1 (before T1) and WB0..WB1 (before TSTOP) MUST each span an integer
** number of chop periods, settled after the respective input change.
**
** Assumes the chopper-IA port convention (extra clock pairs are driven even if a given
** DUT omits some — extra driven nets are harmless):
**   .subckt <id> vinp vinn voutp voutn vref clk_chin clk_chin_not clk_chfb clk_chfb_not
**                clk_chout clk_chout_not [clk_chpf clk_chpf_not] clk_phi_1 clk_phi_2 vdd vss
** Required bindings: DUT PORT_LINE VDD VCM CL FCHOP TEDGE VIN_DC T1 WA0 WA1 WB0 WB1
**                    TSTEP TSTOP TMAX PDK_INCLUDE.  TMAX = max internal step: the SC
**                    network needs ~200n or the solver steps over TG conduction and
**                    dies (TSTEP is only the print interval).
${PDK_INCLUDE}

.param VDD=${VDD}
.param VCM=${VCM}
.param CL=${CL}
.param FCHOP=${FCHOP}
.param TCHOP={1/FCHOP}
.param TEDGE=${TEDGE}
.param VIN_DC=${VIN_DC}

Vdd  vdd 0 dc {VDD}
Vss  vss 0 dc 0
CLoadp voutp 0 {CL}
CLoadn voutn 0 {CL}
Vref vref 0 dc {VCM}
Vcm  vcm 0 dc {VCM}
* differential input: 0 in window A, VIN_DC from T1 (window B)
Vinp vinp vcm pulse(0 {VIN_DC} ${T1} 1n 1n 1 2)
Vinn vinn vcm dc 0

* chopper clocks: complementary pairs, all phases aligned at FCHOP
Vck_in_a  clk_chin      0 pulse(0 {VDD} 0 {TEDGE} {TEDGE} {TCHOP/2-TEDGE} {TCHOP})
Vck_in_b  clk_chin_not  0 pulse({VDD} 0 0 {TEDGE} {TEDGE} {TCHOP/2-TEDGE} {TCHOP})
Vck_fb_a  clk_chfb      0 pulse(0 {VDD} 0 {TEDGE} {TEDGE} {TCHOP/2-TEDGE} {TCHOP})
Vck_fb_b  clk_chfb_not  0 pulse({VDD} 0 0 {TEDGE} {TEDGE} {TCHOP/2-TEDGE} {TCHOP})
Vck_out_a clk_chout     0 pulse(0 {VDD} 0 {TEDGE} {TEDGE} {TCHOP/2-TEDGE} {TCHOP})
Vck_out_b clk_chout_not 0 pulse({VDD} 0 0 {TEDGE} {TEDGE} {TCHOP/2-TEDGE} {TCHOP})
Vck_pf_a  clk_chpf      0 pulse(0 {VDD} 0 {TEDGE} {TEDGE} {TCHOP/2-TEDGE} {TCHOP})
Vck_pf_b  clk_chpf_not  0 pulse({VDD} 0 0 {TEDGE} {TEDGE} {TCHOP/2-TEDGE} {TCHOP})
* two-phase SC clock for the composed RRL integrator (exact complements, in phase) —
* without these the RRL's SC switch gates float and the ripple-reduction loop is INERT
Vphi1 clk_phi_1 0 pulse(0 {VDD} 0 {TEDGE} {TEDGE} {TCHOP/4-TEDGE} {TCHOP/2})
Vphi2 clk_phi_2 0 pulse({VDD} 0 0 {TEDGE} {TEDGE} {TCHOP/4-TEDGE} {TCHOP/2})

${PORT_LINE} ${DUT}

.control
  set filetype=ascii
  tran ${TSTEP} ${TSTOP} 0 ${TMAX}
  let vd = v(voutp) - v(voutn)
  meas tran vavga AVG vd from=${WA0} to=${WA1}
  meas tran vavgb AVG vd from=${WB0} to=${WB1}
  meas tran vdmax MAX vd from=${WB0} to=${WB1}
  meas tran vdmin MIN vd from=${WB0} to=${WB1}
  meas tran vdmax0 MAX vd from=${WA0} to=${WA1}
  meas tran vdmin0 MIN vd from=${WA0} to=${WA1}
  let v_ripple_pp = vdmax - vdmin
  let v_ripple0_pp = vdmax0 - vdmin0
  let gain_cl = (vavgb - vavga)/${VIN_DC}
  let vos_residual = vavga/gain_cl
  print v_ripple_pp v_ripple0_pp gain_cl vos_residual
  write
  quit
.endc
.end
