** AUTHORED TEMPLATE — trim/dc_code_sweep: static trim-code transfer + linearity.
** Sweeps the trim control Vcode across its range (each CODE_STEP increment is one "code") and
** extracts, from the swept transfer v(vout): the full-scale range, the average LSB step, peak INL
** (deviation from the endpoint line, in LSB), and a monotonicity flag (all step signs equal).
** Port convention: vdd vcode vout vss. Bindings: DUT PORT_LINE VDD CODE_LO CODE_HI CODE_STEP PDK_INCLUDE.
${PDK_INCLUDE}

.param VDD=${VDD}

Vdd vdd 0 dc {VDD}
Vss vss 0 dc 0
Vcode vcode 0 dc 0

${PORT_LINE} ${DUT}

.control
  set filetype=ascii
  dc Vcode ${CODE_LO} ${CODE_HI} ${CODE_STEP}
  let np = length(v(vout))
  let out_lo = v(vout)[0]
  let out_hi = v(vout)[np-1]
  let full_range = abs(out_hi - out_lo)
  let lsb = (out_hi - out_lo) / (np - 1)
  let lsb_step = abs(lsb)
  * INL = peak deviation from the endpoint straight line, in LSB
  let ideal = out_lo + lsb * vector(np)
  let inl_v = (v(vout) - ideal) / lsb
  let inl_lsb = maximum(abs(inl_v))
  * monotonic = 1 when the transfer never reverses beyond 2% of its steepest slope (a robust
  * check that tolerates deriv sign-noise in the flat end regions of the sweep)
  let dv = deriv(v(vout))
  let slope = max(abs(minimum(dv)), abs(maximum(dv)))
  let monotonic = (maximum(dv) le 0.02 * slope) | (minimum(dv) ge -0.02 * slope)
  print full_range lsb_step inl_lsb monotonic
  write
  quit
.endc
.end
