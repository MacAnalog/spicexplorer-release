** GENERATED by `analog-db export-raw` — DO NOT EDIT.
** circuit=amp_030_miller_cmfb_composite  class=amplifier  pdk=tsmc-n65  testbench=psrr_vdd  corner=tt
** Self-contained deck: testbench + bound params + lowered DUT (.subckt amp_030_miller_cmfb_composite).
** PDK corner libs resolve by BARE NAME on the image's ngspice sourcepath — run in a
** PDK-enabled env (the base image / api container), NOT a bare host:
**   docker run --rm -i spicexplorer-spice-base:local \
**     bash -lc 'd=$(mktemp -d) && cat > $d/c.spice && cd $d && ngspice -b c.spice' < raw/amp_030_miller_cmfb_composite/tsmc-n65/psrr_vdd.spice
*----------------------------------------------------------*
** params: 21 free + 6 frozen knobs (sizing.yaml) · 17 tied · 0 ratio-derived (abstract/params.yaml) · 3 testbench params
** AUTHORED TEMPLATE — amplifier/psrr_vdd_diff: positive-supply rejection of a fully-
** differential (self-biased, voutp/voutn) DUT, in the same CM-pinned differential
** unity-feedback network stb_diff uses.
**
** CONFIGURATION (see stb_diff.spice for the full why). The differential loop is closed by two
** ideal VCVSs, fbn/fbp = VCM +/- (voutp-voutn)/2, feeding the inputs through quiet 0 V sources;
** the input CM is pinned at VCM and the DC operating point is the matched-inputs-at-VCM point
** of dc_op_diff/ac_open_loop_diff. No CM loop is closed by the bench — the output CM is left to
** the DUT's own CMFB; small-signal, so it works regardless of CMFB quality.
**
** STIMULUS + MATH (the exact FD analog of psrr_vdd.spice). The supply Vdd carries a 1 V AC
** ripple and every input is AC-quiet, so all AC at the output is supply feed-through. With
** A_vd = the supply -> differential-output gain and the loop holding vin_d = -vout_d:
**     vout_d = A_vd*vac + Add*vin_d  =>  vout_d = A_vd/(1+Add) * vac,
** the closed-loop (buffer-application) differential supply feed-through, so
** psrr_vdd_db = -20*log10|vout_d| (vac = 1), read at FSTART (the DC-band floor) — the same
** loop-suppressed figure the SE bench reports for the unity buffer.
**
** SOLVER-RESOLUTION CEILING (why the 1e-15 floor exists — same argument as cmrr_vcm_diff, in
** full there). On a perfectly symmetric netlist the supply disturbs both half-circuits
** identically, the TRUE A_vd of the deck is zero, and the solved vout_d is matrix round-off
** (~1e-16 of the ~1 V node signals). The `+ 1e-15` magnitude floor caps the reportable figure
** at 300 dB and keeps -db() finite; a psrr_vdd_db at or near 300 means "beyond what the solver
** can resolve on a symmetric netlist", NOT a physical rejection (real PSRR- and PSRR+ of FD
** silicon are mismatch-set). Treat anything above ~200 dB as unresolved-by-construction.
**
** psrr_cm_db — the SECONDARY, always-physical figure. The OUTPUT-CM response to the same
** ripple, vocm = (voutp+voutn)/2, psrr_cm_db = -db|vocm|: the supply rejection of the cell's
** CM path (CMFB loop included). It is finite even on a perfect netlist — supply ripple feeds
** the CM of both branches with the same sign, nothing cancels — so it is the number that
** actually discriminates between FD cells whose differential figure saturates the solver.
** (Not a canonical datasheet metric; it rides the scoreboard entry's analyses block.)
**
** DIFFERENTIAL-GAIN CORRECTION (downstream, scoreboard.record). psrr_cm_db here is the RAW CM
** supply residual -db|vocm|, NOT yet a rejection FIGURE. PSRR is (differential gain)/(supply
** gain), so the physical FD PSRR+ adds the differential open-loop gain back:
** psrr_cm_corr_db = dc_gain_db + psrr_cm_db (the SE unity-buffer psrr_vdd_db folds this in via
** its closed loop; the FD CM path does not, so the term is added when the scoreboard entry is
** assembled). psrr_cm_corr_db is the figure the paper prints.
**
** Bindings: DUT PORT_LINE VDD VCM CL FSTART FSTOP PPD PDK_INCLUDE.
.lib tsmc_n65_models.scs tt
.temp 27

.param VDD=1.2
.param VCM=0.6
.param CL=10p

Vdd  vdd 0 dc {VDD} ac 1     ; 1 V supply-ripple stimulus
Vss  vss 0 dc 0
CLoadp voutp 0 {CL}
CLoadn voutn 0 {CL}

* differential unity feedback, CM pinned at VCM (see stb_diff.spice); inputs AC-quiet —
* isolate the supply path
Vcm  vcm 0 dc {VCM}
Efbn fbn vcm voutp voutn 0.5
Efbp fbp vcm voutp voutn -0.5
Vfbn vinn fbn dc 0
Vfbp vinp fbp dc 0

XDUT vinp vinn voutp voutn vdd vss amp_030_miller_cmfb_composite

.control
  set filetype=ascii
  ac dec 101 1k 1G
  let vodm = v(voutp) - v(voutn)
  let vocm = (v(voutp) + v(voutn))/2
  * 1e-15 magnitude floor: caps the figure at 300 dB = "beyond solver resolution" (see header);
  * also keeps -db() finite on a bit-symmetric netlist whose true response is exactly 0.
  let psrr   = -db(mag(vodm) + 1e-15)
  let psrrcm = -db(mag(vocm) + 1e-15)
  meas ac psrr_vdd_db FIND psrr   AT=1k
  meas ac psrr_cm_db  FIND psrrcm AT=1k
  write
  quit
.endc
.param x_dut_xm1_core_w=5e-06
.param x_dut_xm1_core_l=5e-07
.param x_dut_xm3_core_w=5e-06
.param x_dut_xm3_core_l=2e-06
.param x_dut_xm5_core_w=4e-05
.param x_dut_xm5_core_l=2e-06
.param x_dut_xm6_core_w=3.5e-06
.param x_dut_xm6_core_l=2e-06
.param x_dut_xm7_core_w=1.05e-05
.param x_dut_xm8_core_w=3.5e-06
.param x_dut_r1_core_value=8000.0
.param x_dut_c1_core_value=1p
.param i_bias_core=2e-05
.param x_dut_xm1_core_m=1
.param x_dut_xm3_core_m=1
.param x_dut_xm5_core_m=1
.param x_dut_xm6_core_m=1
.param x_dut_xm7_core_m=1
.param x_dut_xm8_core_m=1
.param gm_val_servo=100u
.param rout_val_servo=10k
.param cout_val_servo=100f
.param rin_val_servo=1e12
.param cin_val_servo=10f
.param x_dut_rmp_servo_value=1Meg
.param vcm_ref=0.6
.param vbl0=0.71
* ---- GENERATED parameter ties (abstract/params.yaml groups/ratios) ----
* Each tied symbol is defined exactly once, by its line below; rewrite that
* .param to untie just that symbol (untying = shadowing, plan D-3).
.param x_dut_xm10_core_l = {x_dut_xm6_core_l}
.param x_dut_xm7_core_l = {x_dut_xm6_core_l}
.param x_dut_xm8_core_l = {x_dut_xm6_core_l}
.param x_dut_xm2_core_w = {x_dut_xm1_core_w}
.param x_dut_xm2_core_l = {x_dut_xm1_core_l}
.param x_dut_xm2_core_m = {x_dut_xm1_core_m}
.param x_dut_xm4_core_w = {x_dut_xm3_core_w}
.param x_dut_xm4_core_l = {x_dut_xm3_core_l}
.param x_dut_xm4_core_m = {x_dut_xm3_core_m}
.param x_dut_xm9_core_w = {x_dut_xm5_core_w}
.param x_dut_xm9_core_l = {x_dut_xm5_core_l}
.param x_dut_xm9_core_m = {x_dut_xm5_core_m}
.param x_dut_xm10_core_w = {x_dut_xm7_core_w}
.param x_dut_xm10_core_m = {x_dut_xm7_core_m}
.param x_dut_r2_core_value = {x_dut_r1_core_value}
.param x_dut_c2_core_value = {x_dut_c1_core_value}
.param x_dut_rmn_servo_value = {x_dut_rmp_servo_value}
.subckt amp_030_miller_cmfb_composite vinp vinn voutp voutn vdd vss
C1_CORE core__mill_p voutp 'x_dut_c1_core_value'
C2_CORE core__mill_n voutn 'x_dut_c2_core_value'
CIN_SERVO_SERVO servo__cm_sense vref_cm 'cin_val_servo'
COUT_SERVO_SERVO vss vcmfb_raw 'cout_val_servo'
GM_SERVO_SERVO vss vcmfb_raw vref_cm servo__cm_sense {gm_val_servo}
IBIAS_CORE vdd core__ref dc {i_bias_core}
R1_CORE core__stg1p core__mill_p 'x_dut_r1_core_value'
R2_CORE core__stg1n core__mill_n 'x_dut_r2_core_value'
RIN_SERVO_SERVO servo__cm_sense vref_cm 'rin_val_servo'
RMN_SERVO voutn servo__cm_sense 'x_dut_rmn_servo_value'
RMP_SERVO servo__cm_sense voutp 'x_dut_rmp_servo_value'
ROUT_SERVO_SERVO vss vcmfb_raw 'rout_val_servo'
VBL0 vbl_ctl vcmfb_raw dc {vbl0}
VREFCM vref_cm vss dc {vcm_ref}
XM10_CORE voutn core__ref vss vss nch_lvt l=x_dut_xm10_core_l m=x_dut_xm10_core_m w=x_dut_xm10_core_w
XM1_CORE core__stg1p vinp core__tail vss nch_lvt l=x_dut_xm1_core_l m=x_dut_xm1_core_m w=x_dut_xm1_core_w
XM2_CORE core__stg1n vinn core__tail vss nch_lvt l=x_dut_xm2_core_l m=x_dut_xm2_core_m w=x_dut_xm2_core_w
XM3_CORE core__stg1p vbl_ctl vdd vdd pch_lvt l=x_dut_xm3_core_l m=x_dut_xm3_core_m w=x_dut_xm3_core_w
XM4_CORE core__stg1n vbl_ctl vdd vdd pch_lvt l=x_dut_xm4_core_l m=x_dut_xm4_core_m w=x_dut_xm4_core_w
XM5_CORE voutp core__stg1p vdd vdd pch_lvt l=x_dut_xm5_core_l m=x_dut_xm5_core_m w=x_dut_xm5_core_w
XM6_CORE core__ref core__ref vss vss nch_lvt l=x_dut_xm6_core_l m=x_dut_xm6_core_m w=x_dut_xm6_core_w
XM7_CORE voutp core__ref vss vss nch_lvt l=x_dut_xm7_core_l m=x_dut_xm7_core_m w=x_dut_xm7_core_w
XM8_CORE core__tail core__ref vss vss nch_lvt l=x_dut_xm8_core_l m=x_dut_xm8_core_m w=x_dut_xm8_core_w
XM9_CORE voutn core__stg1n vdd vdd pch_lvt l=x_dut_xm9_core_l m=x_dut_xm9_core_m w=x_dut_xm9_core_w
.ends
.end
