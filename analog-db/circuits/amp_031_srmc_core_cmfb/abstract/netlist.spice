** Abstract complementary-input two-stage fully-differential amplifier with per-stage
** behavioral CMFB servos — the OTA core of the Hsu SRMC duty-cycled filter (bio-afe-01
** family; provenance in circuit.yaml). AUTHORED source of truth (plan D-2). PDK-neutral
** model tokens (nmos/pmos); per-PDK device names + geometry come from circuitgraph
** lowering + pdk/<pdk>/{devices.map,sizing}.yaml.
** Subckt port order (= circuit.yaml ports): vinp vinn voutp voutn vdd vss
**
** Topology (from drawings/bio-afe-01-YuPinHsu-reconfigable-SRMC/simulation/
** SRMC-core-amp-w-cmfb.spice, flattened by hand after xschem netlisting):
**   stage 1 — complementary input pairs, no explicit loads (each pair loads the
**     other): NMOS pair XM3/XM4 (tail XM5, gate on knob-driven vb2) + PMOS pair
**     XM6/XM7 (tail XM8, gate on the loop-1 servo output vcmfb1). Stage-1 outputs
**     vo1p/vo1n.
**   stage 2 — per-side class-A: NMOS drivers XM1/XM9 (gates vo1n/vo1p) against
**     CMFB-controlled PMOS sources XM2/XM10 (gates on the loop-2 servo output
**     vcmfb2). Miller C1+R1 (vo1n->voutp) and C2+R2 (vo1p->voutn) per side.
**   CMFB x2 (one per stage, both CANONICAL polarity — vcmfb = A*(sensed - vref);
**     B5 closure, sim-proven: both plants are INVERTING, drawings/TODO_bio_afe_port.md):
**     loop 1 senses vo1p/vo1n (detector RM1P/RM1N -> cm1_det) into a flattened
**     ideal-amp macromodel (GM1 + ROUT1/COUT1, RIN1/CIN1) driving vcmfb1 (XM8);
**     loop 2 senses voutp/voutn (RM2P/RM2N -> cm2_det) likewise driving vcmfb2
**     (XM2/XM10). Both referenced to knob-driven {vref_cm} (drawn 0.5 V).
**   drawing conformance + entry-level deviations:
**     - the drawn wrapper's VB2/V_REF_CMFB1/V_REF_CMFB2 sources become knob-driven
**       internal dc sources {vb2}/{vref_cm} (instantiator owns bias). The B5 source
**       fixes (XM8 w 0.15u->0.5u seed, VB2 0.5->0.7) are superseded here by the
**       OPTIMIZER-SIZED binding (pdk sizing.yaml, full-precision — see
**       drawings/sizing-and-specs.yaml bio_afe_SRMC_core_amp.ihp_winner).
**     - the drawn shared/ideal CMFB blocks (cmfb-output-ideal-amp, canonical) are
**       flattened per instance like amp_025's servo (VCCS macromodel).
**   input common mode is 0.5 V (the SRMC filter's system CM = the committed refs),
**   NOT the 0.6 convention — 0.6 rails the servos through the filter's DC R path.
C1 vo1n zc_p 'x_dut_c1_value'
C2 vo1p zc_n 'x_dut_c2_value'
CIN1 cm1_det vref_cm1 'cin_val'
CIN2 cm2_det vref_cm2 'cin_val'
COUT1 vss vcmfb1 'cout_val'
COUT2 vss vcmfb2 'cout_val'
GM1 vss vcmfb1 cm1_det vref_cm1 {gm_val}
GM2 vss vcmfb2 cm2_det vref_cm2 {gm_val}
R1 zc_p voutp 'x_dut_r1_value'
R2 zc_n voutn 'x_dut_r2_value'
RIN1 cm1_det vref_cm1 'rin_val'
RIN2 cm2_det vref_cm2 'rin_val'
RM1P cm1_det vo1p 'x_dut_rm1p_value'
RM1N vo1n cm1_det 'x_dut_rm1n_value'
RM2P cm2_det voutp 'x_dut_rm2p_value'
RM2N voutn cm2_det 'x_dut_rm2n_value'
ROUT1 vss vcmfb1 'rout_val'
ROUT2 vss vcmfb2 'rout_val'
VB2 vb2 vss dc {vb2}
VREF1 vref_cm1 vss dc {vref_cm}
VREF2 vref_cm2 vss dc {vref_cm}
XM1 voutp vo1n vss vss nmos l=x_dut_xm1_l m=x_dut_xm1_m w=x_dut_xm1_w
XM2 voutp vcmfb2 vdd vdd pmos l=x_dut_xm2_l m=x_dut_xm2_m w=x_dut_xm2_w
XM3 vo1n vinp ntail vss nmos l=x_dut_xm3_l m=x_dut_xm3_m w=x_dut_xm3_w
XM4 vo1p vinn ntail vss nmos l=x_dut_xm4_l m=x_dut_xm4_m w=x_dut_xm4_w
XM5 ntail vb2 vss vss nmos l=x_dut_xm5_l m=x_dut_xm5_m w=x_dut_xm5_w
XM6 vo1p vinn ptail vdd pmos l=x_dut_xm6_l m=x_dut_xm6_m w=x_dut_xm6_w
XM7 vo1n vinp ptail vdd pmos l=x_dut_xm7_l m=x_dut_xm7_m w=x_dut_xm7_w
XM8 ptail vcmfb1 vdd vdd pmos l=x_dut_xm8_l m=x_dut_xm8_m w=x_dut_xm8_w
XM9 voutn vo1p vss vss nmos l=x_dut_xm9_l m=x_dut_xm9_m w=x_dut_xm9_w
XM10 voutn vcmfb2 vdd vdd pmos l=x_dut_xm10_l m=x_dut_xm10_m w=x_dut_xm10_w
.end
