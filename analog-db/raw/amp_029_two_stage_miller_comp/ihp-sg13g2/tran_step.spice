** GENERATED by `analog-db export-raw` — DO NOT EDIT.
** circuit=amp_029_two_stage_miller_comp  class=amplifier  pdk=ihp-sg13g2  testbench=tran_step  corner=tt
** Self-contained deck: testbench + bound params + lowered DUT (.subckt amp_029_two_stage_miller_comp).
** PDK corner libs resolve by BARE NAME on the image's ngspice sourcepath — run in a
** PDK-enabled env (the base image / api container), NOT a bare host:
**   docker run --rm -i spicexplorer-spice-base:local \
**     bash -lc 'd=$(mktemp -d) && cat > $d/c.spice && cd $d && ngspice -b c.spice' < raw/amp_029_two_stage_miller_comp/ihp-sg13g2/tran_step.spice
*----------------------------------------------------------*
** params: 14 free + 6 frozen knobs (sizing.yaml) · 16 tied · 0 ratio-derived (abstract/params.yaml) · 4 testbench params
** AUTHORED TEMPLATE — amplifier/tran_step_diff (self-biased, differential-output step).
** Unity-gain step -> slew + settling for a DUT with no external ibias port and a true
** differential output. Closes ONE feedback path (vinn <- voutp) and steps vinp; by the
** differential pair's own symmetry (and, for a DUT like amp_020_two_stage_miller_cmfb, its
** internal common-mode servo) voutn tracks the complementary swing, so the DIFFERENTIAL
** output (voutp-voutn) is the correct unity-gain-follower signal to settle on.
**
** Assumes a self-biased, differential-output DUT port order:
**   .subckt <id> vinp vinn voutp voutn vdd vss
** Required bindings: DUT PORT_LINE VDD VCM CL VSTEP TSTART TSTEP TSTOP VTOL PDK_INCLUDE.
.lib cornerMOSlv.lib mos_tt
.lib cornerRES.lib res_typ
.temp 27

.param VDD=1.2
.param VCM=0.6
.param CL=50f
.param VSTEP=50m

Vdd  vdd 0 dc {VDD}
Vss  vss 0 dc 0
CLoadp voutp 0 {CL}
CLoadn voutn 0 {CL}

* unity-gain differential follower: vinn <- voutp (single feedback wire; 0 V source = ideal
* wire). vinp gets the step relative to the input common mode.
Vinp vinp 0 dc {VCM} pulse({VCM} {VCM+VSTEP} 1u 1n 1n 1 1)
Vfb  vinn voutp dc 0

XDUT vinp vinn voutp voutn vdd vss amp_029_two_stage_miller_comp

.control
  set filetype=ascii
  tran 1n 20u
  let vodm = v(voutp) - v(voutn)
  * settle to the FINAL differential value, not the input step size — see tran_step.spice
  * (universal) for why: a systematic offset would otherwise keep the error band open forever.
  meas tran vfinal FIND vodm AT=20u
  let verr = abs(vodm - vfinal)
  meas tran tcross WHEN verr=5m FALL=LAST
  let t_settle = tcross - 1u
  print t_settle
  write
  quit
.endc
.param x_dut_xm1_w=10u
.param x_dut_xm1_l=0.5u
.param x_dut_xm3_w=10u
.param x_dut_xm3_l=1u
.param x_dut_xm5_w=12u
.param x_dut_xm5_l=0.5u
.param x_dut_xm6_w=2u
.param x_dut_xm6_l=1u
.param x_dut_xm7_w=6u
.param x_dut_xm8_w=2u
.param x_dut_r1_value=2k
.param x_dut_c1_value=0.3p
.param i_bias=20u
.param vbl=0.7087
.param x_dut_xm1_m=1
.param x_dut_xm3_m=1
.param x_dut_xm5_m=1
.param x_dut_xm6_m=1
.param x_dut_xm7_m=1
.param x_dut_xm8_m=1
* ---- GENERATED parameter ties (abstract/params.yaml groups/ratios) ----
* Each tied symbol is defined exactly once, by its line below; rewrite that
* .param to untie just that symbol (untying = shadowing, plan D-3).
.param x_dut_xm10_l = {x_dut_xm6_l}
.param x_dut_xm7_l = {x_dut_xm6_l}
.param x_dut_xm8_l = {x_dut_xm6_l}
.param x_dut_xm2_w = {x_dut_xm1_w}
.param x_dut_xm2_l = {x_dut_xm1_l}
.param x_dut_xm2_m = {x_dut_xm1_m}
.param x_dut_xm4_w = {x_dut_xm3_w}
.param x_dut_xm4_l = {x_dut_xm3_l}
.param x_dut_xm4_m = {x_dut_xm3_m}
.param x_dut_xm9_w = {x_dut_xm5_w}
.param x_dut_xm9_l = {x_dut_xm5_l}
.param x_dut_xm9_m = {x_dut_xm5_m}
.param x_dut_xm10_w = {x_dut_xm7_w}
.param x_dut_xm10_m = {x_dut_xm7_m}
.param x_dut_r2_value = {x_dut_r1_value}
.param x_dut_c2_value = {x_dut_c1_value}
.subckt amp_029_two_stage_miller_comp vinp vinn voutp voutn vdd vss
C1 mill_p voutp 'x_dut_c1_value'
C2 mill_n voutn 'x_dut_c2_value'
IBIAS vdd ref dc {i_bias}
R1 stg1p mill_p 'x_dut_r1_value'
R2 stg1n mill_n 'x_dut_r2_value'
VBL vbl vss dc {vbl}
XM1 stg1p vinp tail vss sg13_lv_nmos l=x_dut_xm1_l m=x_dut_xm1_m w=x_dut_xm1_w
XM10 voutn ref vss vss sg13_lv_nmos l=x_dut_xm10_l m=x_dut_xm10_m w=x_dut_xm10_w
XM2 stg1n vinn tail vss sg13_lv_nmos l=x_dut_xm2_l m=x_dut_xm2_m w=x_dut_xm2_w
XM3 stg1p vbl vdd vdd sg13_lv_pmos l=x_dut_xm3_l m=x_dut_xm3_m w=x_dut_xm3_w
XM4 stg1n vbl vdd vdd sg13_lv_pmos l=x_dut_xm4_l m=x_dut_xm4_m w=x_dut_xm4_w
XM5 voutp stg1p vdd vdd sg13_lv_pmos l=x_dut_xm5_l m=x_dut_xm5_m w=x_dut_xm5_w
XM6 ref ref vss vss sg13_lv_nmos l=x_dut_xm6_l m=x_dut_xm6_m w=x_dut_xm6_w
XM7 voutp ref vss vss sg13_lv_nmos l=x_dut_xm7_l m=x_dut_xm7_m w=x_dut_xm7_w
XM8 tail ref vss vss sg13_lv_nmos l=x_dut_xm8_l m=x_dut_xm8_m w=x_dut_xm8_w
XM9 voutn stg1n vdd vdd sg13_lv_pmos l=x_dut_xm9_l m=x_dut_xm9_m w=x_dut_xm9_w
.ends
.end
