** GENERATED by `analog-db export-raw` — DO NOT EDIT.
** circuit=amp_021_yan_az  class=amplifier  pdk=ihp-sg13g2  testbench=tran_step  corner=tt
** Self-contained deck: testbench + bound params + lowered DUT (.subckt amp_021_yan_az).
** PDK corner libs resolve by BARE NAME on the image's ngspice sourcepath — run in a
** PDK-enabled env (the base image / api container), NOT a bare host:
**   docker run --rm -i spicexplorer-spice-base:local \
**     bash -lc 'd=$(mktemp -d) && cat > $d/c.spice && cd $d && ngspice -b c.spice' < raw/amp_021_yan_az/ihp-sg13g2/tran_step.spice
*----------------------------------------------------------*
** params: 36 free + 0 frozen knobs (sizing.yaml) · 27 tied · 6 ratio-derived (abstract/params.yaml) · 4 testbench params
** AUTHORED TEMPLATE — amplifier/tran_step_biaswrap: unity-gain step settling for DUTs on the
** AnalogGym self-bias convention (ports vss vdd vinn vinp vout; NO ibias port). Single-ended
** companion of tran_step_diff (M4 follow-up). Unlike the AC/noise bias-wraps — which AC-open the
** loop with Lfb/Cin — a settling measurement WANTS the real closed loop: wire the inverting input
** directly to the output (unity-gain follower) and step the non-inverting input. Settle to the
** FINAL output value, not the input step, so a systematic offset can't hold a fixed-tolerance band
** open forever (see universal/tran_step for the rationale). These are compensated multistage OTAs,
** designed stable in unity feedback.
**
** Assumes the AnalogGym canonical DUT port order (self-biased; NO ibias port):
**   .subckt <id> vss vdd vinn vinp vout
** Bindings: DUT VDD VCM CL VSTEP TSTART TSTEP TSTOP VTOL PDK_INCLUDE.
** FIXED 2026-07-20: this template used to hardcode `X1 0 vdd opout_dc opin opout amp_021_yan_az`,
** which silently assumed the AnalogGym port order [vss vdd vinn vinp vout] and MIS-WIRED any
** DUT declaring a different order (e.g. the amplifier-class [vdd vout vinp vinn vss] swaps
** vdd<->vss). It now uses XDUT vss vdd vinn vinp vout with canonical node names, exactly like the
** *_biaswrap_ibias sibling. For the AnalogGym DUTs this is a no-op: their vss port binds to
** node `vss`, which `Vss vss 0 dc 0` ties to ground just as the old direct-to-0 wiring did.
.lib cornerMOSlv.lib mos_tt
.temp 27

.param VDD=1.8
.param VCM=300m
.param CL=15n
.param VSTEP=0.2

Vdd  vdd 0 dc {VDD}
Vss  vss 0 dc 0
CLoad vout 0 {CL}
Vinp vinp 0 dc {VCM} pulse({VCM} {VCM+VSTEP} 1u 1n 1n 1 1)
Vfb  vinn vout dc 0          ; unity-gain feedback wire (vinn <- vout; 0 V source = ideal wire)

XDUT vss vdd vinn vinp vout amp_021_yan_az
.control
  set filetype=ascii
  tran 10n 200u
  * settle to the FINAL value, not the input step — a follower's systematic offset would
  * otherwise keep |vout - vfinal| outside a tight tolerance band forever.
  meas tran vfinal FIND v(vout) AT=200u
  let verr = abs(v(vout) - vfinal)
  meas tran tcross WHEN verr=2m FALL=LAST
  let t_settle = tcross - 1u
  print t_settle
  write
  quit
.endc
.param CAPACITOR_0=2.0732096210406212e-12
.param CAPACITOR_1=1.3209260533707503e-12
.param CURRENT_1_BIAS=6.60354669496728e-06
.param x_dut_xm67_l=1.782211188591483e-06
.param x_dut_xm67_m=4
.param x_dut_xm67_w=1.8748136691009925e-06
.param x_dut_xm11_l=6.352699277470426e-07
.param x_dut_xm11_m=4
.param x_dut_xm11_w=2.4431391818709206e-06
.param x_dut_xm13_l=2.373449886230304e-06
.param x_dut_xm13_m=4
.param x_dut_xm13_w=6.058668206892358e-07
.param x_dut_xm14_l=2.227107248789151e-06
.param x_dut_xm14_m=4
.param x_dut_xm14_w=1.7315123012919251e-06
.param x_dut_xm16_l=4.915622161314355e-07
.param x_dut_xm16_m=4
.param x_dut_xm16_w=8.526355584579695e-07
.param x_dut_xm18_l=2.370275853048583e-06
.param x_dut_xm18_m=4
.param x_dut_xm18_w=8.647557110850986e-07
.param x_dut_xm19_l=5.731417654504935e-07
.param x_dut_xm19_m=4
.param x_dut_xm19_w=1.7632804821669286e-06
.param x_dut_xm22_l=2.443659701562954e-06
.param x_dut_xm22_m=4
.param x_dut_xm22_w=7.471045622570156e-07
.param x_dut_xm23_l=1.1682967080953975e-06
.param x_dut_xm23_m=4
.param x_dut_xm23_w=1.991412011402502e-06
.param x_dut_xm10_l=7.673015504227583e-07
.param x_dut_xm10_m=4
.param x_dut_xm10_w=2.078470894994438e-06
.param RESISTOR_0=598629.277243448
.param RESISTOR_1=205758.4303181738
.param RESISTOR_2=77105.04822510517
* ---- GENERATED parameter ties (abstract/params.yaml groups/ratios) ----
* Each tied symbol is defined exactly once, by its line below; rewrite that
* .param to untie just that symbol (untying = shadowing, plan D-3).
.param x_dut_xm3_w = {x_dut_xm67_w}
.param x_dut_xm5_w = {x_dut_xm67_w}
.param x_dut_xm4_w = {x_dut_xm67_w}
.param x_dut_xm2_w = {x_dut_xm67_w}
.param x_dut_xm1_w = {x_dut_xm67_w}
.param x_dut_xm0_w = {x_dut_xm67_w}
.param x_dut_xm3_l = {x_dut_xm67_l}
.param x_dut_xm5_l = {x_dut_xm67_l}
.param x_dut_xm4_l = {x_dut_xm67_l}
.param x_dut_xm2_l = {x_dut_xm67_l}
.param x_dut_xm1_l = {x_dut_xm67_l}
.param x_dut_xm0_l = {x_dut_xm67_l}
.param x_dut_xm9_w = {x_dut_xm10_w}
.param x_dut_xm9_l = {x_dut_xm10_l}
.param x_dut_xm9_m = {x_dut_xm10_m}
.param x_dut_xm17_w = {x_dut_xm16_w}
.param x_dut_xm17_l = {x_dut_xm16_l}
.param x_dut_xm17_m = {x_dut_xm16_m}
.param x_dut_xm20_w = {x_dut_xm19_w}
.param x_dut_xm21_w = {x_dut_xm19_w}
.param x_dut_xm20_l = {x_dut_xm19_l}
.param x_dut_xm21_l = {x_dut_xm19_l}
.param x_dut_xm20_m = {x_dut_xm19_m}
.param x_dut_xm21_m = {x_dut_xm19_m}
.param x_dut_xm15_w = {x_dut_xm14_w}
.param x_dut_xm15_l = {x_dut_xm14_l}
.param x_dut_xm15_m = {x_dut_xm14_m}
.param x_dut_xm3_m = {x_dut_xm67_m*4}
.param x_dut_xm5_m = {x_dut_xm67_m*1}
.param x_dut_xm4_m = {x_dut_xm67_m*1}
.param x_dut_xm2_m = {x_dut_xm67_m*2}
.param x_dut_xm1_m = {x_dut_xm67_m*1}
.param x_dut_xm0_m = {x_dut_xm67_m*1}
.subckt amp_021_yan_az vss vdd vinn vinp vout
C0 net063 VOUT 'CAPACITOR_1'
C1 net051 vss 'CAPACITOR_0'
I0 VB1 vss 'CURRENT_1_BIAS'
R0 net078 net077 'RESISTOR_1'
R1 net078 net082 'RESISTOR_2'
R2 net094 net051 'RESISTOR_0'
XM0 VB1 VB1 vdd vdd sg13_lv_pmos l=x_dut_xm0_l m=x_dut_xm0_m w=x_dut_xm0_w
XM1 VB4 VB1 vdd vdd sg13_lv_pmos l=x_dut_xm1_l m=x_dut_xm1_m w=x_dut_xm1_w
XM10 net063 VINP net019 net019 sg13_lv_pmos l=x_dut_xm10_l m=x_dut_xm10_m w=x_dut_xm10_w
XM11 net094 net050 vdd vdd sg13_lv_pmos l=x_dut_xm11_l m=x_dut_xm11_m w=x_dut_xm11_w
XM13 VOUT net050 vdd vdd sg13_lv_pmos l=x_dut_xm13_l m=x_dut_xm13_m w=x_dut_xm13_w
XM14 VOUTN net077 DM_2 vss sg13_lv_nmos l=x_dut_xm14_l m=x_dut_xm14_m w=x_dut_xm14_w
XM15 net050 net082 net063 vss sg13_lv_nmos l=x_dut_xm15_l m=x_dut_xm15_m w=x_dut_xm15_w
XM16 net077 DM_2 vss vss sg13_lv_nmos l=x_dut_xm16_l m=x_dut_xm16_m w=x_dut_xm16_w
XM17 net082 net063 vss vss sg13_lv_nmos l=x_dut_xm17_l m=x_dut_xm17_m w=x_dut_xm17_w
XM18 VOUT net057 vss vss sg13_lv_nmos l=x_dut_xm18_l m=x_dut_xm18_m w=x_dut_xm18_w
XM19 VB4 VB4 vss vss sg13_lv_nmos l=x_dut_xm19_l m=x_dut_xm19_m w=x_dut_xm19_w
XM2 net019 VB1 vdd vdd sg13_lv_pmos l=x_dut_xm2_l m=x_dut_xm2_m w=x_dut_xm2_w
XM20 DM_2 VB4 vss vss sg13_lv_nmos l=x_dut_xm20_l m=x_dut_xm20_m w=x_dut_xm20_w
XM21 net063 VB4 vss vss sg13_lv_nmos l=x_dut_xm21_l m=x_dut_xm21_m w=x_dut_xm21_w
XM22 net094 net051 vss vss sg13_lv_nmos l=x_dut_xm22_l m=x_dut_xm22_m w=x_dut_xm22_w
XM23 net057 net094 vss vss sg13_lv_nmos l=x_dut_xm23_l m=x_dut_xm23_m w=x_dut_xm23_w
XM3 net078 VB1 vdd vdd sg13_lv_pmos l=x_dut_xm3_l m=x_dut_xm3_m w=x_dut_xm3_w
XM4 VOUTN VOUTN vdd vdd sg13_lv_pmos l=x_dut_xm4_l m=x_dut_xm4_m w=x_dut_xm4_w
XM5 net050 VOUTN vdd vdd sg13_lv_pmos l=x_dut_xm5_l m=x_dut_xm5_m w=x_dut_xm5_w
XM67 net057 VOUTN vdd vdd sg13_lv_pmos l=x_dut_xm67_l m=x_dut_xm67_m w=x_dut_xm67_w
XM9 DM_2 VINN net019 net019 sg13_lv_pmos l=x_dut_xm9_l m=x_dut_xm9_m w=x_dut_xm9_w
.ends
.end
