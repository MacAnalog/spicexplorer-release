** GENERATED by `analog-db export-raw` — DO NOT EDIT.
** circuit=amp_023_fer_fd2s  class=amplifier  pdk=gf180mcu  testbench=iip3  corner=tt
** Self-contained deck: testbench + bound params + lowered DUT (.subckt amp_023_fer_fd2s).
** PDK corner libs resolve by BARE NAME on the image's ngspice sourcepath — run in a
** PDK-enabled env (the base image / api container), NOT a bare host:
**   docker run --rm -i spicexplorer-spice-base:local \
**     bash -lc 'd=$(mktemp -d) && cat > $d/c.spice && cd $d && ngspice -b c.spice' < raw/amp_023_fer_fd2s/gf180mcu/iip3.spice
*----------------------------------------------------------*
** params: 20 free + 30 frozen knobs (sizing.yaml) · 44 tied · 0 ratio-derived (abstract/params.yaml) · 4 testbench params
** AUTHORED TEMPLATE — amplifier/iip3_diff: two-tone third-order intercept of a
** FULLY-DIFFERENTIAL amplifier in the differential unity-feedback (follower) connection.
** Two equal tones (per-tone differential amplitude ASIG at F1 and F2, each split
** +/- ASIG/2 antiphase) intermodulate through the closed loop; the IM3 products at
** 2F1-F2 / 2F2-F1 on the DIFFERENTIAL output v(voutp)-v(voutn) set the intercept. This is
** the FD sibling iip3.spice's dead-output guard points at: an FD member run through the
** single-ended deck leaves node `vout` capacitively fed and the guard populations OVERLAP
** there (amp_031@ihp dead at 0.4136 vs amp_017@gf180 live at 0.4354 — measured, iip3.spice
** header), so no threshold fixes it; this template is the structural fix.
**
** NETWORK: thd_diff.spice's — which is tran_step_diff's follower with the drive split per
** the FD convention. ONE feedback path (vinn <- voutp, 0 V at DC), VCM on the vinp side;
** at DC every sin source below is 0 V, so the operating point is exactly the one
** tran_step_diff certifies. Each tone contributes +ASIG/2 on the vinp side (series-stacked
** about VCM, like iip3.spice's two-source stack) and -ASIG/2 series-stacked in the feedback
** wire, halving the input common-mode wobble the one-wire follower produces. See
** thd_diff.spice's header for the full network story; do not fork either network.
**
** CLOSED-LOOP GAIN IS 2, NOT 1 (only voutp is fed back, so the loop divider is vod/2):
** gain_tone ideally reads 2.0 and the dead-output threshold is 2/3 — the |A| = 1 physical
** line for THIS configuration (gain_tone = 2A/(2+A)), the analogue of iip3.spice's 0.5 =
** A/(1+A) for the unity buffer. Each output NODE swings ASIG per tone, matching the SE
** bench's per-side swing at the same binding. vod also carries the follower's DC term
** 2*(VCM - vocm); the DFT strips DC, but budget the headroom (|vod_op|/2 + 2*ASIG per
** side counting both tones) when binding ASIG.
**
** IIP3 CONVENTION — IDENTICAL TO iip3.spice, INPUT-REFERRED TO THE ASIG BINDING:
** OIP3 = 20log10(a_fund) - im3_dbc/2 and the drive reference is the BINDING's ASIG (the
** per-tone applied differential amplitude), so iip3_dbv = 20log10(ASIG) - im3_dbc/2 — NOT
** referred through the measured gain. That keeps the number comparable with the SE bench
** and with the Spectre lane's calculator (same `AMPL: 0.00625`); a_drv is printed beside it,
** and a_drv disagreeing with ASIG means the stimulus is mis-bound, not the DUT wrong.
** DRIVE LEVEL: bind ASIG = 6.25 mV per tone. The 50 mV the SE bench once shipped was 0.5 -
** 1.4 dB OPTIMISTIC (sign set by the 5th-order coefficient, so not even a consistent bias);
** the ASIG sweep that measured that, and the floor that bounds the window from BELOW, are
** in iip3.spice's header — 6.25 mV is the geometric centre of the valid window there and
** the per-side swing here matches the SE bench at the same binding, so the same centre
** applies. iip3_comp_db (the 5th-order compression estimate, ~21.7*a_im5/a_im3 dB) is
** printed on every run: read it as "at least this much error", one-sided-usable ONLY at
** the shipped drive (measured story in iip3.spice — it UNDERSTATES on slew-limited cells
** at higher drive, up to 2.9x).
**
** BIN PLACEMENT + COHERENCE (iip3.spice's, unchanged): F1/F2 must be integer multiples of
** F0 = gcd(F1,F2) so the tones, both IM3 products (2F1-F2, 2F2-F1) and both IM5 products
** (3F1-2F2, 3F2-2F1) land on exact F0 bins; BOTH TSTART and (TSTOP-TSTART) are integer
** numbers of beat periods 1/F0 and TSTEP <= 1/(200*F2). TSTART must ALSO clear the
** follower's settling — the circuit's tran_step scoreboard t_settle is the floor, and one
** beat period is normally far above it. The DFT carries the endpoint-duplication
** correction ((mean(v*c)*np - v[0]*c[0])/nd); on the SE bench that correction WAS the
** deck's whole noise floor (a_floor fell 2.3e-7 -> 1.6e-11 V, measured — see iip3.spice).
** a_floor (the bin at 5*F0, lowest-order product NINTH) is the same trust check here:
** a_im3 must sit far above it or the window/tones are wrong.
**
** OUTPUT COMMON-MODE DRIFT (cm_drift_v) — the FD trust check, same estimator as
** thd_diff.spice: half-window means of (voutp+voutn)/2 on the linearized record, second
** half minus first. With the shipped 20-beat window the halves are 10 whole beat periods
** each, so every coherent tone cancels exactly and only the walk survives. An intercept
** extrapolated from µV-scale IM3 bins while the CM is still walking is meaningless —
** demand cm_drift_v << ASIG before quoting iip3_dbv; lengthen TSTART if it is not.
**
** `write` runs BEFORE `linearize` (linearize swaps the current plot and would gut the raw
** — measured story in thd.spice). Sentinels: iip3_dbv -> -999 and im3_dbc -> +999 on a
** guard trip — each the BAD direction for its intent (ppa's verdict only fails value<min /
** value>max, so a +999 iip3_dbv would silently PASS a min-bound spec; -999 is the loud
** one), and NOT NaN, which would make the runner discard the whole analysis. iip3_comp_db
** is forced to 0 on a trip — there is no intercept left for it to bound; the verdict is
** the sentinel pair. No `>` inside any `let` (the control preprocessor strips it as an
** output redirection and silently truncates the RHS); masks use `<=` and 1-mask.
**
** Measures: a_f1 a_f2 (differential tone amplitudes), a_drv (measured worst-side per-tone
** differential DRIVE — compare with the ASIG binding), gain_tone / gain_tone_db (~2 / ~6
** dB when live), a_im3l a_im3h, a_im5l a_im5h, a_floor, im3_dbc, iip3_dbv, im5_im3_db,
** iip3_comp_db, vod_op, vocm_op, cm_drift_v. Same names as iip3.spice throughout so the
** datasheet wiring stays uniform; none of the diagnostics is in raw_project._SPEC_REGISTRY
** (`gain_tone`, NOT the registry's `gain_cl`; `vod_op`, not `vout_dc`).
** BINDING FORM: ASIG, F0, F1, F2 reach control-language arithmetic below — plain decimals /
** scientific notation ONLY (0.00625, 0.9e6), never SPICE suffixes. TSTEP/TSTART/TSTOP only
** reach the `tran` card, so suffixes are fine there.
**
** Assumes a self-biased, differential-in/differential-out DUT port order:
**   .subckt <id> vinp vinn voutp voutn vdd vss
** Required bindings: DUT PORT_LINE VDD VCM CL ASIG F0 F1 F2 TSTEP TSTART TSTOP PDK_INCLUDE.
.include design.ngspice
.lib sm141064.ngspice noise_corner
.lib sm141064.ngspice nfet_03v3_t
.lib sm141064.ngspice pfet_03v3_t
.lib sm141064.ngspice fets_mm
.lib sm141064.ngspice res_typical
.lib sm141064.ngspice mimcap_typical
.lib sm141064.ngspice cap_mim
.temp 27

.param VDD=1.5
.param VCM=0.9
.param CL=10p
.param ASIG=0.00625

Vdd  vdd 0 dc {VDD}
Vss  vss 0 dc 0
CLoadp voutp 0 {CL}
CLoadn voutn 0 {CL}
Vcm  vcm 0 dc {VCM}

* thd_diff's follower network, two tones: +ASIG/2 per tone series-stacked about VCM on the
* vinp side; -ASIG/2 per tone series-stacked IN the vinn <- voutp feedback wire (all 0 V at
* DC, so the DC network — and the operating point — is tran_step_diff's exactly).
Vt1p vinp midp  sin(0 {ASIG/2}  0.9e6)
Vt2p midp vcm   sin(0 {ASIG/2}  1.0e6)
Vt1n vinn midn  sin(0 {-ASIG/2} 0.9e6)
Vt2n midn voutp sin(0 {-ASIG/2} 1.0e6)

XDUT vinp vinn voutp voutn vdd vss amp_023_fer_fd2s

.control
  set filetype=ascii
  tran 5n 250u 50u
  * raw first — `linearize` below switches the current plot to its interpolated scratch
  * copy, so a trailing `write` would gut the raw (thd.spice has the measured story)
  write
  let vd = v(voutp) - v(voutn)
  * the applied differential stimulus, reconstructed from its two halves: (vinp - vcm) is
  * the +ASIG/2 stack's EMF, (vinn - voutp) the -ASIG/2 stack's; their difference is the
  * full two-tone differential drive (ASIG peak per tone) — the guard's measured reference
  let vdrv = v(vinp) - v(vcm) - v(vinn) + v(voutp)
  let vcmr = 0.5*(v(voutp) + v(voutn))
  linearize vd vdrv vcmr
  let t = time
  let np = length(vd)
  let nd = np - 1
  let vod_op = (mean(vd)*np - vd[0])/nd
  let vac = vd - vod_op
  let vin_ac = vdrv - mean(vdrv)
* --- coherent single-bin DFT with the endpoint-duplication correction (see the header):
* --- `linearize` returns np = nd+1 points whose last sample REPEATS the first; mean()*np
* --- recovers the sum, the v[0]*c[0] term drops the duplicate, /nd normalises over the nd
* --- non-redundant samples -> an exactly rectangular window.
  let c_f1 = cos(2*pi*0.9e6*t)
  let s_f1 = sin(2*pi*0.9e6*t)
  let re_f1 = (mean(vac*c_f1)*np - vac[0]*c_f1[0])/nd
  let im_f1 = (mean(vac*s_f1)*np - vac[0]*s_f1[0])/nd
  let a_f1  = 2*sqrt(re_f1^2+im_f1^2)
* --- the SAME bin taken on the measured DRIVE — the dead-output guard's reference ---
  let rd_f1 = (mean(vin_ac*c_f1)*np - vin_ac[0]*c_f1[0])/nd
  let id_f1 = (mean(vin_ac*s_f1)*np - vin_ac[0]*s_f1[0])/nd
  let a_dr1 = 2*sqrt(rd_f1^2+id_f1^2)
  let c_f2 = cos(2*pi*1.0e6*t)
  let s_f2 = sin(2*pi*1.0e6*t)
  let re_f2 = (mean(vac*c_f2)*np - vac[0]*c_f2[0])/nd
  let im_f2 = (mean(vac*s_f2)*np - vac[0]*s_f2[0])/nd
  let a_f2  = 2*sqrt(re_f2^2+im_f2^2)
  let rd_f2 = (mean(vin_ac*c_f2)*np - vin_ac[0]*c_f2[0])/nd
  let id_f2 = (mean(vin_ac*s_f2)*np - vin_ac[0]*s_f2[0])/nd
  let a_dr2 = 2*sqrt(rd_f2^2+id_f2^2)
  let c_3l = cos(2*pi*(2*0.9e6-1.0e6)*t)
  let s_3l = sin(2*pi*(2*0.9e6-1.0e6)*t)
  let re_3l = (mean(vac*c_3l)*np - vac[0]*c_3l[0])/nd
  let im_3l = (mean(vac*s_3l)*np - vac[0]*s_3l[0])/nd
  let a_im3l = 2*sqrt(re_3l^2+im_3l^2)
  let c_3h = cos(2*pi*(2*1.0e6-0.9e6)*t)
  let s_3h = sin(2*pi*(2*1.0e6-0.9e6)*t)
  let re_3h = (mean(vac*c_3h)*np - vac[0]*c_3h[0])/nd
  let im_3h = (mean(vac*s_3h)*np - vac[0]*s_3h[0])/nd
  let a_im3h = 2*sqrt(re_3h^2+im_3h^2)
* --- 5th-order products at 3F1-2F2 / 3F2-2F1 — the COMPRESSION INDICATOR's inputs (see
* --- the header). Same coherent grid, so they cost two bin pairs and no extra simulation.
  let c_5l = cos(2*pi*(3*0.9e6-2*1.0e6)*t)
  let s_5l = sin(2*pi*(3*0.9e6-2*1.0e6)*t)
  let re_5l = (mean(vac*c_5l)*np - vac[0]*c_5l[0])/nd
  let im_5l = (mean(vac*s_5l)*np - vac[0]*s_5l[0])/nd
  let a_im5l = 2*sqrt(re_5l^2+im_5l^2)
  let c_5h = cos(2*pi*(3*1.0e6-2*0.9e6)*t)
  let s_5h = sin(2*pi*(3*1.0e6-2*0.9e6)*t)
  let re_5h = (mean(vac*c_5h)*np - vac[0]*c_5h[0])/nd
  let im_5h = (mean(vac*s_5h)*np - vac[0]*s_5h[0])/nd
  let a_im5h = 2*sqrt(re_5h^2+im_5h^2)
  let c_fl = cos(2*pi*5*0.1e6*t)
  let s_fl = sin(2*pi*5*0.1e6*t)
  let re_fl = (mean(vac*c_fl)*np - vac[0]*c_fl[0])/nd
  let im_fl = (mean(vac*s_fl)*np - vac[0]*s_fl[0])/nd
  let a_floor = 2*sqrt(re_fl^2+im_fl^2)
* --- output common-mode drift (see the header): half-window means, tone-blind when the
* --- window is a whole number of beat periods (halves then hold whole beats too at the
* --- shipped even beat count). Full-record mean = vocm_op.
  let vocm_op = (mean(vcmr)*np - vcmr[0])/nd
  let nh = floor(nd/2)
  let cm_first = mean(vcmr[0, nh-1])
  let cm_last  = mean(vcmr[nd-nh, nd-1])
  let cm_drift_v = cm_last - cm_first
* --- worst-side IM3/IM5 over the weaker tone; min/max of two scalars without branching ---
  let a_fund = 0.5*(a_f1+a_f2 - abs(a_f1-a_f2))
  let a_im3  = 0.5*(a_im3l+a_im3h + abs(a_im3l-a_im3h))
  let a_im5  = 0.5*(a_im5l+a_im5h + abs(a_im5l-a_im5h))
  let a_drv  = 0.5*(a_dr1+a_dr2 - abs(a_dr1-a_dr2))
* --- floors keep log10() finite when a bin lands on zero (a NaN aborts the run) ---
  let a_fund_g = a_fund + 1e-15
  let a_im3_g  = a_im3 + 1e-15
* --- DEAD-OUTPUT GUARD (see the header): a MEASURED gain, not a NaN check. Threshold 2/3 =
* --- the |A| = 1 line for this gain-2 configuration (gain_tone = 2A/(2+A)). Do NOT write
* --- `>` inside a `let` — the control preprocessor strips it as an output redirection and
* --- silently truncates the RHS. Masks use `<=`, inverted with 1 - mask.
  let gain_tone = a_fund/(a_drv + 1e-18)
  let gain_tone_db = 20*log10(gain_tone + 1e-18)
  let dead = (gain_tone <= 0.6667)
  let live = 1 - dead
* input-referred to the BINDING's ASIG on purpose (see the header): iip3_dbv =
* 20log10(ASIG) - im3_dbc/2, identical to iip3.spice and the Spectre-lane calculator's
* `AMPL: 0.00625`. a_drv is printed beside it — a disagreement means a mis-bound stimulus.
  let im3_raw  = 20*log10(a_im3_g/a_fund_g)
  let iip3_raw = 20*log10(0.00625) - im3_raw/2
  let im3_dbc  = live*im3_raw  + dead*999
  let iip3_dbv = live*iip3_raw - dead*999
* --- COMPRESSION INDICATOR (see the header): |IIP3 error| ~ 21.7 * a_im5/a_im3 dB.
  let im5_im3_db  = 20*log10((a_im5 + 1e-18)/a_im3_g)
  let iip3_comp_db = live*21.71*a_im5/a_im3_g
  print a_f1 a_f2 a_drv gain_tone gain_tone_db a_im3l a_im3h a_im5l a_im5h a_floor
  print im3_dbc iip3_dbv im5_im3_db iip3_comp_db vod_op vocm_op cm_drift_v
  quit
.endc
.param x_dut_xmbd_w=4u
.param x_dut_xmpd1_w=6u
.param x_dut_xmpd2_w=1.5u
.param x_dut_xmnd1_w=0.75u
.param x_dut_xmi1_w=6u
.param x_dut_xmsa_w=6u
.param x_dut_xmca_w=6u
.param x_dut_xmna_w=4u
.param x_dut_xmka_w=3u
.param x_dut_xm2a_w=8u
.param x_dut_xmla_w=6u
.param x_dut_xmepd_w=3u
.param x_dut_xmncd_w=1.5u
.param x_dut_xmbd_l=0.4u
.param x_dut_xmi1_l=0.3u
.param x_dut_xmca_l=0.28u
.param x_dut_rza_value=1500
.param x_dut_cca_value=2e-12
.param x_dut_rca_value=2e5
.param x_dut_cma_value=150e-15
.param x_ibias_val=20e-6
.param x_vcmr_val=0.75
.param x_dut_xmbd_m=1
.param x_dut_xmb1_m=1
.param x_dut_xmpd1_m=1
.param x_dut_xmb2_m=1
.param x_dut_xmpd2_m=1
.param x_dut_xmpm1_m=1
.param x_dut_xmnd1_m=1
.param x_dut_xmt_m=2
.param x_dut_xmi1_m=2
.param x_dut_xmi2_m=2
.param x_dut_xmsa_m=2
.param x_dut_xmsb_m=2
.param x_dut_xmca_m=1
.param x_dut_xmcb_m=1
.param x_dut_xmna_m=1
.param x_dut_xmnb_m=1
.param x_dut_xmka_m=1
.param x_dut_xmkb_m=1
.param x_dut_xm2a_m=4
.param x_dut_xm2b_m=4
.param x_dut_xmla_m=6
.param x_dut_xmlb_m=6
.param x_dut_xmea1_m=1
.param x_dut_xmea2_m=1
.param x_dut_xmepd_m=1
.param x_dut_xmepm_m=2
.param x_dut_xmncd_m=1
.param x_dut_xmeat_m=1
* ---- GENERATED parameter ties (abstract/params.yaml groups/ratios) ----
* Each tied symbol is defined exactly once, by its line below; rewrite that
* .param to untie just that symbol (untying = shadowing, plan D-3).
.param x_dut_xmb1_l = {x_dut_xmbd_l}
.param x_dut_xmpd1_l = {x_dut_xmbd_l}
.param x_dut_xmb2_l = {x_dut_xmbd_l}
.param x_dut_xmpd2_l = {x_dut_xmbd_l}
.param x_dut_xmpm1_l = {x_dut_xmbd_l}
.param x_dut_xmnd1_l = {x_dut_xmbd_l}
.param x_dut_xmt_l = {x_dut_xmbd_l}
.param x_dut_xmsa_l = {x_dut_xmbd_l}
.param x_dut_xmsb_l = {x_dut_xmbd_l}
.param x_dut_xmka_l = {x_dut_xmbd_l}
.param x_dut_xmkb_l = {x_dut_xmbd_l}
.param x_dut_xmla_l = {x_dut_xmbd_l}
.param x_dut_xmlb_l = {x_dut_xmbd_l}
.param x_dut_xmepd_l = {x_dut_xmbd_l}
.param x_dut_xmepm_l = {x_dut_xmbd_l}
.param x_dut_xmncd_l = {x_dut_xmbd_l}
.param x_dut_xmeat_l = {x_dut_xmbd_l}
.param x_dut_xmb1_w = {x_dut_xmbd_w}
.param x_dut_xmb2_w = {x_dut_xmbd_w}
.param x_dut_xmt_w = {x_dut_xmbd_w}
.param x_dut_xmea1_w = {x_dut_xmbd_w}
.param x_dut_xmea2_w = {x_dut_xmbd_w}
.param x_dut_xmeat_w = {x_dut_xmbd_w}
.param x_dut_xmpm1_w = {x_dut_xmpd1_w}
.param x_dut_xmi2_l = {x_dut_xmi1_l}
.param x_dut_xm2a_l = {x_dut_xmi1_l}
.param x_dut_xm2b_l = {x_dut_xmi1_l}
.param x_dut_xmi2_w = {x_dut_xmi1_w}
.param x_dut_xmsb_w = {x_dut_xmsa_w}
.param x_dut_xmcb_l = {x_dut_xmca_l}
.param x_dut_xmna_l = {x_dut_xmca_l}
.param x_dut_xmnb_l = {x_dut_xmca_l}
.param x_dut_xmea1_l = {x_dut_xmca_l}
.param x_dut_xmea2_l = {x_dut_xmca_l}
.param x_dut_xmcb_w = {x_dut_xmca_w}
.param x_dut_xmnb_w = {x_dut_xmna_w}
.param x_dut_xmkb_w = {x_dut_xmka_w}
.param x_dut_xm2b_w = {x_dut_xm2a_w}
.param x_dut_xmlb_w = {x_dut_xmla_w}
.param x_dut_xmepm_w = {x_dut_xmepd_w}
.param x_dut_rzb_value = {x_dut_rza_value}
.param x_dut_ccb_value = {x_dut_cca_value}
.param x_dut_rcb_value = {x_dut_rca_value}
.param x_dut_cmb_value = {x_dut_cma_value}
.subckt amp_023_fer_fd2s vinp vinn voutp voutn vdd vss
CCA za voutp x_dut_cca_value
CCB zb voutn x_dut_ccb_value
CMA voutp vsen x_dut_cma_value
CMB voutn vsen x_dut_cmb_value
IB vdd ibias dc {x_ibias_val}
RCA voutp vsen x_dut_rca_value
RCB voutn vsen x_dut_rcb_value
RZA o1a za x_dut_rza_value
RZB o1b zb x_dut_rzb_value
VCR vcmr vss dc {x_vcmr_val}
XM2A voutp o1a vss vss nfet_03v3 l=x_dut_xm2a_l m=x_dut_xm2a_m w=x_dut_xm2a_w
XM2B voutn o1b vss vss nfet_03v3 l=x_dut_xm2b_l m=x_dut_xm2b_m w=x_dut_xm2b_w
XMB1 vbp ibias vss vss nfet_03v3 l=x_dut_xmb1_l m=x_dut_xmb1_m w=x_dut_xmb1_w
XMB2 vcp ibias vss vss nfet_03v3 l=x_dut_xmb2_l m=x_dut_xmb2_m w=x_dut_xmb2_w
XMBD ibias ibias vss vss nfet_03v3 l=x_dut_xmbd_l m=x_dut_xmbd_m w=x_dut_xmbd_w
XMCA o1a vcp fp vdd pfet_03v3 l=x_dut_xmca_l m=x_dut_xmca_m w=x_dut_xmca_w
XMCB o1b vcp fn vdd pfet_03v3 l=x_dut_xmcb_l m=x_dut_xmcb_m w=x_dut_xmcb_w
XMEA1 ead vcmr eatail vss nfet_03v3 l=x_dut_xmea1_l m=x_dut_xmea1_m w=x_dut_xmea1_w
XMEA2 vcmfb vsen eatail vss nfet_03v3 l=x_dut_xmea2_l m=x_dut_xmea2_m w=x_dut_xmea2_w
XMEAT eatail ibias vss vss nfet_03v3 l=x_dut_xmeat_l m=x_dut_xmeat_m w=x_dut_xmeat_w
XMEPD ead ead vdd vdd pfet_03v3 l=x_dut_xmepd_l m=x_dut_xmepd_m w=x_dut_xmepd_w
XMEPM vcmfb ead vdd vdd pfet_03v3 l=x_dut_xmepm_l m=x_dut_xmepm_m w=x_dut_xmepm_w
XMI1 fp vinp tail vss nfet_03v3 l=x_dut_xmi1_l m=x_dut_xmi1_m w=x_dut_xmi1_w
XMI2 fn vinn tail vss nfet_03v3 l=x_dut_xmi2_l m=x_dut_xmi2_m w=x_dut_xmi2_w
XMKA x1a vcmfb vss vss nfet_03v3 l=x_dut_xmka_l m=x_dut_xmka_m w=x_dut_xmka_w
XMKB x1b vcmfb vss vss nfet_03v3 l=x_dut_xmkb_l m=x_dut_xmkb_m w=x_dut_xmkb_w
XMLA voutp vbp vdd vdd pfet_03v3 l=x_dut_xmla_l m=x_dut_xmla_m w=x_dut_xmla_w
XMLB voutn vbp vdd vdd pfet_03v3 l=x_dut_xmlb_l m=x_dut_xmlb_m w=x_dut_xmlb_w
XMNA o1a vcn x1a vss nfet_03v3 l=x_dut_xmna_l m=x_dut_xmna_m w=x_dut_xmna_w
XMNB o1b vcn x1b vss nfet_03v3 l=x_dut_xmnb_l m=x_dut_xmnb_m w=x_dut_xmnb_w
XMNCD vcmfb vcmfb vss vss nfet_03v3 l=x_dut_xmncd_l m=x_dut_xmncd_m w=x_dut_xmncd_w
XMND1 vcn vcn vss vss nfet_03v3 l=x_dut_xmnd1_l m=x_dut_xmnd1_m w=x_dut_xmnd1_w
XMPD1 vbp vbp vdd vdd pfet_03v3 l=x_dut_xmpd1_l m=x_dut_xmpd1_m w=x_dut_xmpd1_w
XMPD2 vcp vcp vdd vdd pfet_03v3 l=x_dut_xmpd2_l m=x_dut_xmpd2_m w=x_dut_xmpd2_w
XMPM1 vcn vbp vdd vdd pfet_03v3 l=x_dut_xmpm1_l m=x_dut_xmpm1_m w=x_dut_xmpm1_w
XMSA fp vbp vdd vdd pfet_03v3 l=x_dut_xmsa_l m=x_dut_xmsa_m w=x_dut_xmsa_w
XMSB fn vbp vdd vdd pfet_03v3 l=x_dut_xmsb_l m=x_dut_xmsb_m w=x_dut_xmsb_w
XMT tail ibias vss vss nfet_03v3 l=x_dut_xmt_l m=x_dut_xmt_m w=x_dut_xmt_w
.ends
.end
