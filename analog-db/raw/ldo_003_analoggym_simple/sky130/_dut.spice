** GENERATED by `analog-db export-raw` — DO NOT EDIT.
** Standalone lowered DUT subckt for ldo_003_analoggym_simple on sky130 (sizing .param defaults + .subckt).
** Not a runnable deck on its own — include it under your own testbench:
**   .include _dut.spice
**   XDUT vdd vout vss ldo_003_analoggym_simple
** Source: pdk/sky130/netlist.spice (run `analog-db generate` to refresh).
*----------------------------------------------------------*
** params: 14 free + 0 frozen knobs (sizing.yaml) · 4 tied · 0 ratio-derived (abstract/params.yaml)
.param x_dut_xm1_w=2
.param x_dut_xm1_l=2
.param x_dut_xm4_w=80
.param x_dut_xm4_l=0.5
.param x_dut_xm5_w=100
.param x_dut_xm5_l=0.5
.param x_dut_xmp_w=20
.param x_dut_xmp_l=0.5
.param x_dut_xmp_m=360
.param r_z=3k
.param c_comp=1p
.param vref_val=1.8
.param vb_val=1.2
.param r_bleed=100k
* ---- GENERATED parameter ties (abstract/params.yaml groups/ratios) ----
* Each tied symbol is defined exactly once, by its line below; rewrite that
* .param to untie just that symbol (untying = shadowing, plan D-3).
.param x_dut_xm2_w = {x_dut_xm1_w}
.param x_dut_xm2_l = {x_dut_xm1_l}
.param x_dut_xm3_w = {x_dut_xm4_w}
.param x_dut_xm3_l = {x_dut_xm4_l}
.subckt ldo_003_analoggym_simple vdd vout vss
CC ncz vout 'c_comp'
RZ ncz ngate 'r_z'
R_BLEED vout vss 'r_bleed'
VB vb vss dc {vb_val}
VLP lp_brk vout dc 0
VREF vref vss dc {vref_val}
XM1 ndiode lp_brk ntail vss sky130_fd_pr__nfet_g5v0d10v5 l=x_dut_xm1_l w=x_dut_xm1_w
XM2 ngate vref ntail vss sky130_fd_pr__nfet_g5v0d10v5 l=x_dut_xm2_l w=x_dut_xm2_w
XM3 ngate ndiode vdd vdd sky130_fd_pr__pfet_g5v0d10v5 l=x_dut_xm3_l w=x_dut_xm3_w
XM4 ndiode ndiode vdd vdd sky130_fd_pr__pfet_g5v0d10v5 l=x_dut_xm4_l w=x_dut_xm4_w
XM5 ntail vb vss vss sky130_fd_pr__nfet_g5v0d10v5 l=x_dut_xm5_l w=x_dut_xm5_w
XMP vout ngate vdd vdd sky130_fd_pr__pfet_g5v0d10v5 l=x_dut_xmp_l m=x_dut_xmp_m w=x_dut_xmp_w
.ends
