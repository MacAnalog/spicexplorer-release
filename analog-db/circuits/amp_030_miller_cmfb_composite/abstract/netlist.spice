** GENERATED by `analog-db generate` — DO NOT EDIT. Source: composition.yaml (composer, plan P4)
** Composite: amp_030_miller_cmfb_composite = core(amp_029_two_stage_miller_comp @ 67c6e24e4137) + servo(cmfb_001_ideal_rsense_servo @ 9c8861186398)
** CMFB closure of amp_029 (which has NO interior DC operating point on its own — its committed dc_cm_bias_sweep measures cm_interior_pts = 0): the cmfb_001_ideal_rsense_servo behavioral servo senses the output common mode resistively and corrects the stage-1 PMOS load-gate node in place of amp_029's knife-edge {vbl} knob source (tap vbl -> vbl_ctl; omit Vbl — the composite, as instantiator, owns that bias, plan D3). Loop sign: vocm UP -> cm_sense UP -> correction = gm*rout*(vref - cm_sense) DOWN -> vbl DOWN -> stage-1 load current UP -> stg1 CM UP -> stage-2 PMOS vsg DOWN -> vocm DOWN: NEGATIVE feedback. RANGE-REFERENCING (found live, first compose attempt): an UNCLAMPED behavioral servo at gain 1000 saturates to gm*rout*vref = +600 V on the load gates, which drives the PSP models into a nonphysical leakage regime where the railed-low output is a STABLE spurious equilibrium (4/5 op solves latched there). The fix is structural, not a tune: the series {vbl0} source carries the DC bias point and the servo contributes only the CORRECTION at gain ~1 (rout_val override 10k, so gm*rout = 1) — the saturated drive stays inside [vbl0-0.6, vbl0+0.6], physical gate range, and NEITHER rail state survives as a DC equilibrium (each contradicts its own load state). The servo reference is the composite-owned {vcm_ref} knob; acceptance = dc_cm_bias_sweep over vcm_ref flips 0 -> 5.
**.subckt amp_030_miller_cmfb_composite vinp vinn voutp voutn vdd vss
* --- instance core: amp_029_two_stage_miller_comp @ 67c6e24e4137 (omit: Vbl) ---
XM1_CORE core__stg1p vinp core__tail vss nmos w=x_dut_xm1_core_w l=x_dut_xm1_core_l m=x_dut_xm1_core_m
XM2_CORE core__stg1n vinn core__tail vss nmos w=x_dut_xm2_core_w l=x_dut_xm2_core_l m=x_dut_xm2_core_m
XM3_CORE core__stg1p vbl_ctl vdd vdd pmos w=x_dut_xm3_core_w l=x_dut_xm3_core_l m=x_dut_xm3_core_m
XM4_CORE core__stg1n vbl_ctl vdd vdd pmos w=x_dut_xm4_core_w l=x_dut_xm4_core_l m=x_dut_xm4_core_m
XM5_CORE voutp core__stg1p vdd vdd pmos w=x_dut_xm5_core_w l=x_dut_xm5_core_l m=x_dut_xm5_core_m
XM9_CORE voutn core__stg1n vdd vdd pmos w=x_dut_xm9_core_w l=x_dut_xm9_core_l m=x_dut_xm9_core_m
XM7_CORE voutp core__ref vss vss nmos w=x_dut_xm7_core_w l=x_dut_xm7_core_l m=x_dut_xm7_core_m
XM10_CORE voutn core__ref vss vss nmos w=x_dut_xm10_core_w l=x_dut_xm10_core_l m=x_dut_xm10_core_m
XM6_CORE core__ref core__ref vss vss nmos w=x_dut_xm6_core_w l=x_dut_xm6_core_l m=x_dut_xm6_core_m
XM8_CORE core__tail core__ref vss vss nmos w=x_dut_xm8_core_w l=x_dut_xm8_core_l m=x_dut_xm8_core_m
Ibias_CORE vdd core__ref dc {i_bias_core}
R1_CORE core__stg1p core__mill_p 'x_dut_r1_core_value'
C1_CORE core__mill_p voutp 'x_dut_c1_core_value'
R2_CORE core__stg1n core__mill_n 'x_dut_r2_core_value'
C2_CORE core__mill_n voutn 'x_dut_c2_core_value'
* --- instance servo: cmfb_001_ideal_rsense_servo @ 9c8861186398 ---
Gm_servo_SERVO vss vcmfb_raw vref_cm servo__cm_sense {gm_val_servo}
Rout_servo_SERVO vss vcmfb_raw 'rout_val_servo'
Cout_servo_SERVO vss vcmfb_raw 'cout_val_servo'
Rin_servo_SERVO servo__cm_sense vref_cm 'rin_val_servo'
Cin_servo_SERVO servo__cm_sense vref_cm 'cin_val_servo'
Rmp_SERVO servo__cm_sense voutp 'x_dut_rmp_servo_value'
Rmn_SERVO voutn servo__cm_sense 'x_dut_rmn_servo_value'
* --- composite-owned nets ---
Vrefcm vref_cm vss dc {vcm_ref}
Vbl0 vbl_ctl vcmfb_raw dc {vbl0}
**.ends
.end
