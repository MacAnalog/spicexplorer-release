** GENERATED by `analog-db generate` — DO NOT EDIT. Source: abstract/netlist.spice → gf180mcu
* tsn_002_ptat_classic (emitted by spicexplorer-circuitgraph)
R0 vout vss x_r0
XM0 vmir net1 vout vout nfet_03v3 l=x_dut_xm0_l m=x_dut_xm0_m w=x_dut_xm0_w
XM1 net1 net1 vss vss nfet_03v3 l=x_dut_xm1_l m=x_dut_xm1_m w=x_dut_xm1_w
XM3 vmir vmir vdd vdd pfet_03v3 l=x_dut_xm3_l m=x_dut_xm3_m w=x_dut_xm3_w
XM4 net1 vmir vdd vdd pfet_03v3 l=x_dut_xm4_l m=x_dut_xm4_m w=x_dut_xm4_w
.end
