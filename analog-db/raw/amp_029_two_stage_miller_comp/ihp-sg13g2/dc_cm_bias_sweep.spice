** GENERATED by `analog-db export-raw` — DO NOT EDIT.
** circuit=amp_029_two_stage_miller_comp  class=amplifier  pdk=ihp-sg13g2  testbench=dc_cm_bias_sweep  corner=tt
** Self-contained deck: testbench + bound params + lowered DUT (.subckt amp_029_two_stage_miller_comp).
** PDK corner libs resolve by BARE NAME on the image's ngspice sourcepath — run in a
** PDK-enabled env (the base image / api container), NOT a bare host:
**   docker run --rm -i spicexplorer-spice-base:local \
**     bash -lc 'd=$(mktemp -d) && cat > $d/c.spice && cd $d && ngspice -b c.spice' < raw/amp_029_two_stage_miller_comp/ihp-sg13g2/dc_cm_bias_sweep.spice
*----------------------------------------------------------*
** params: 14 free + 6 frozen knobs (sizing.yaml) · 16 tied · 0 ratio-derived (abstract/params.yaml) · 2 testbench params
** AUTHORED TEMPLATE — amplifier/dc_cm_bias_sweep (committed from the amp_029 review
** finding: "no stable interior DC point" deserved a reproducible gate, not scratchpad
** prose). Characterizes the OUTPUT-COMMON-MODE sensitivity of an FD amplifier to one
** internal bias knob: the knob (name bound as CMKNOB, e.g. the stage-1 load-gate bias)
** is stepped across 5 points VB1..VB5 via alterparam+reset; at each point the op's
** output CM vocm_i = (voutp+voutn)/2 is recorded. cm_interior_pts counts how many of
** the 5 land inside VCM +/- VBAND:
**   5..1  = the knob has a usable interior window (its width ~ the passing points'
**           span — pick VB points around the expected balance);
**   0     = the output rails at every sampled bias: no interior operating point at
**           this sizing (e.g. a no-CMFB topology's cascaded gds knife edges).
** Matched DC inputs at VCM; self-biased diff port order:
**   .subckt <id> vinp vinn voutp voutn vdd vss
** Required bindings: DUT PORT_LINE VDD VCM VBAND CMKNOB VB1 VB2 VB3 VB4 VB5
**                    PDK_INCLUDE.
.lib cornerMOSlv.lib mos_tt
.lib cornerRES.lib res_typ
.temp 27

.param VDD=1.2
.param VCM=0.6

Vdd  vdd 0 dc {VDD}
Vss  vss 0 dc 0
Vcm  vcm 0 dc {VCM}
Vinp vinp vcm dc 0
Vinn vinn vcm dc 0

XDUT vinp vinn voutp voutn vdd vss amp_029_two_stage_miller_comp

.control
  set filetype=ascii
  * each op opens a NEW plot: print every vocm_i immediately (the measure parser reads
  * these lines), and the final count reaches back via plot-qualified names (opN.vocm_N).
  alterparam vbl=0.66
  reset
  op
  let vocm_1 = (v(voutp)+v(voutn))/2
  print vocm_1
  alterparam vbl=0.69
  reset
  op
  let vocm_2 = (v(voutp)+v(voutn))/2
  print vocm_2
  alterparam vbl=0.71
  reset
  op
  let vocm_3 = (v(voutp)+v(voutn))/2
  print vocm_3
  alterparam vbl=0.73
  reset
  op
  let vocm_4 = (v(voutp)+v(voutn))/2
  print vocm_4
  alterparam vbl=0.76
  reset
  op
  let vocm_5 = (v(voutp)+v(voutn))/2
  print vocm_5
  let lo = 0.6 - 0.25
  let hi = 0.6 + 0.25
  let cm_interior_pts = ((op1.vocm_1 gt lo) & (op1.vocm_1 lt hi)) + ((op2.vocm_2 gt lo) & (op2.vocm_2 lt hi)) + ((op3.vocm_3 gt lo) & (op3.vocm_3 lt hi)) + ((op4.vocm_4 gt lo) & (op4.vocm_4 lt hi)) + ((vocm_5 gt lo) & (vocm_5 lt hi))
  print cm_interior_pts
  write
  quit
.endc
.param x_dut_xm1_w=10u
.param x_dut_xm1_l=0.5u
.param x_dut_xm3_w=10u
.param x_dut_xm3_l=1u
.param x_dut_xm5_w=12u
.param x_dut_xm5_l=0.5u
.param x_dut_xm6_w=2u
.param x_dut_xm6_l=1u
.param x_dut_xm7_w=6u
.param x_dut_xm8_w=2u
.param x_dut_r1_value=30k
.param x_dut_c1_value=0.4p
.param i_bias=20u
.param vbl=0.7087
.param x_dut_xm1_m=1
.param x_dut_xm3_m=1
.param x_dut_xm5_m=1
.param x_dut_xm6_m=1
.param x_dut_xm7_m=1
.param x_dut_xm8_m=1
* ---- GENERATED parameter ties (abstract/params.yaml groups/ratios) ----
* Each tied symbol is defined exactly once, by its line below; rewrite that
* .param to untie just that symbol (untying = shadowing, plan D-3).
.param x_dut_xm10_l = {x_dut_xm6_l}
.param x_dut_xm7_l = {x_dut_xm6_l}
.param x_dut_xm8_l = {x_dut_xm6_l}
.param x_dut_xm2_w = {x_dut_xm1_w}
.param x_dut_xm2_l = {x_dut_xm1_l}
.param x_dut_xm2_m = {x_dut_xm1_m}
.param x_dut_xm4_w = {x_dut_xm3_w}
.param x_dut_xm4_l = {x_dut_xm3_l}
.param x_dut_xm4_m = {x_dut_xm3_m}
.param x_dut_xm9_w = {x_dut_xm5_w}
.param x_dut_xm9_l = {x_dut_xm5_l}
.param x_dut_xm9_m = {x_dut_xm5_m}
.param x_dut_xm10_w = {x_dut_xm7_w}
.param x_dut_xm10_m = {x_dut_xm7_m}
.param x_dut_r2_value = {x_dut_r1_value}
.param x_dut_c2_value = {x_dut_c1_value}
.subckt amp_029_two_stage_miller_comp vinp vinn voutp voutn vdd vss
C1 mill_p voutp 'x_dut_c1_value'
C2 mill_n voutn 'x_dut_c2_value'
IBIAS vdd ref dc {i_bias}
R1 stg1p mill_p 'x_dut_r1_value'
R2 stg1n mill_n 'x_dut_r2_value'
VBL vbl vss dc {vbl}
XM1 stg1p vinp tail vss sg13_lv_nmos l=x_dut_xm1_l m=x_dut_xm1_m w=x_dut_xm1_w
XM10 voutn ref vss vss sg13_lv_nmos l=x_dut_xm10_l m=x_dut_xm10_m w=x_dut_xm10_w
XM2 stg1n vinn tail vss sg13_lv_nmos l=x_dut_xm2_l m=x_dut_xm2_m w=x_dut_xm2_w
XM3 stg1p vbl vdd vdd sg13_lv_pmos l=x_dut_xm3_l m=x_dut_xm3_m w=x_dut_xm3_w
XM4 stg1n vbl vdd vdd sg13_lv_pmos l=x_dut_xm4_l m=x_dut_xm4_m w=x_dut_xm4_w
XM5 voutp stg1p vdd vdd sg13_lv_pmos l=x_dut_xm5_l m=x_dut_xm5_m w=x_dut_xm5_w
XM6 ref ref vss vss sg13_lv_nmos l=x_dut_xm6_l m=x_dut_xm6_m w=x_dut_xm6_w
XM7 voutp ref vss vss sg13_lv_nmos l=x_dut_xm7_l m=x_dut_xm7_m w=x_dut_xm7_w
XM8 tail ref vss vss sg13_lv_nmos l=x_dut_xm8_l m=x_dut_xm8_m w=x_dut_xm8_w
XM9 voutn stg1n vdd vdd sg13_lv_pmos l=x_dut_xm9_l m=x_dut_xm9_m w=x_dut_xm9_w
.ends
.end
