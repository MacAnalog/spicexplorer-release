** GENERATED by `analog-db export-raw` — DO NOT EDIT.
** Standalone lowered DUT subckt for dp_001_resistive_load on gf180mcu (sizing .param defaults + .subckt).
** Not a runnable deck on its own — include it under your own testbench:
**   .include _dut.spice
**   XDUT vdd voutp voutn vinp vinn ibias vss dp_001_resistive_load
** Source: pdk/gf180mcu/netlist.spice (run `analog-db generate` to refresh).
*----------------------------------------------------------*
** params: 7 free + 3 frozen knobs (sizing.yaml) · 4 tied · 0 ratio-derived (abstract/params.yaml)
.param x_dut_xmp_w=12u
.param x_dut_xmp_l=0.3u
.param x_dut_rp_value=22000
.param x_dut_xmt_w=24u
.param x_dut_xmr_l=0.3u
.param x_dut_xmt_m=1
.param x_dut_xmr_w=24u
.param x_dut_xmp_m=1
.param x_dut_xmn_m=1
.param x_dut_xmr_m=1
* ---- GENERATED parameter ties (abstract/params.yaml groups/ratios) ----
* Each tied symbol is defined exactly once, by its line below; rewrite that
* .param to untie just that symbol (untying = shadowing, plan D-3).
.param x_dut_xmn_w = {x_dut_xmp_w}
.param x_dut_xmn_l = {x_dut_xmp_l}
.param x_dut_xmt_l = {x_dut_xmr_l}
.param x_dut_rn_value = {x_dut_rp_value}
.subckt dp_001_resistive_load vdd voutp voutn vinp vinn ibias vss
RN vdd voutn x_dut_rn_value
RP vdd voutp x_dut_rp_value
XMN voutn vinn tail vss nfet_03v3 l=x_dut_xmn_l m=x_dut_xmn_m w=x_dut_xmn_w
XMP voutp vinp tail vss nfet_03v3 l=x_dut_xmp_l m=x_dut_xmp_m w=x_dut_xmp_w
XMR ibias ibias vss vss nfet_03v3 l=x_dut_xmr_l m=x_dut_xmr_m w=x_dut_xmr_w
XMT tail ibias vss vss nfet_03v3 l=x_dut_xmt_l m=x_dut_xmt_m w=x_dut_xmt_w
.ends
