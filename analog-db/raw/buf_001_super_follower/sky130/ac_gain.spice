** GENERATED by `analog-db export-raw` — DO NOT EDIT.
** circuit=buf_001_super_follower  class=buffer  pdk=sky130  testbench=ac_gain  corner=tt
** Self-contained deck: testbench + bound params + lowered DUT (.subckt buf_001_super_follower).
** PDK corner libs resolve by BARE NAME on the image's ngspice sourcepath — run in a
** PDK-enabled env (the base image / api container), NOT a bare host:
**   docker run --rm -i spicexplorer-spice-base:local \
**     bash -lc 'd=$(mktemp -d) && cat > $d/c.spice && cd $d && ngspice -b c.spice' < raw/buf_001_super_follower/sky130/ac_gain.spice
*----------------------------------------------------------*
** params: 8 free + 6 frozen knobs (sizing.yaml) · 5 tied · 0 ratio-derived (abstract/params.yaml) · 4 testbench params
** AUTHORED TEMPLATE — buffer/ac_gain: small-signal AC response at the VCM bias point.
** The input is DC-biased at VCM with a unit AC stimulus; CL loads the output. Reports the
** low-frequency gain (dB, ~0 for a follower) and the -3 dB bandwidth.
** Class port convention: vdd vout vin ibias vss (ibias source-referenced, see metrics.yaml).
** Bindings: DUT PORT_LINE VDD VCM IBIAS CL FSTART FSTOP PPD PDK_INCLUDE.
.lib sky130.lib.spice tt
.temp 27

.param VDD=1.5
.param VCM=1.05
.param IBIAS=10u
.param CL=500f

Vdd  vdd 0 dc {VDD}
Vss  vss 0 dc 0
Ibias vdd ibias dc {IBIAS}
Vin  vin 0 dc {VCM} ac 1
CLoad vout 0 {CL}

XDUT vdd vout vin ibias vss buf_001_super_follower

.control
  set filetype=ascii
  ac dec 20 100 10G
  meas ac gain_ac_db FIND vdb(vout) AT=100
  let gtarget = gain_ac_db - 3
  meas ac f3db_hz WHEN vdb(vout)=gtarget FALL=1
  write
  quit
.endc
.param x_dut_xm1_w=8
.param x_dut_xm2_w=8
.param x_dut_xmrn_w=4
.param x_dut_xmpd_w=8
.param x_dut_xmpb_w=8
.param x_dut_xm1_l=0.3
.param x_dut_xmpd_l=0.3
.param x_cc=250e-15
.param x_dut_xm1_m=4
.param x_dut_xm2_m=4
.param x_dut_xmrn_m=1
.param x_dut_xmns_m=1
.param x_dut_xmpd_m=1
.param x_dut_xmpb_m=6
* ---- GENERATED parameter ties (abstract/params.yaml groups/ratios) ----
* Each tied symbol is defined exactly once, by its line below; rewrite that
* .param to untie just that symbol (untying = shadowing, plan D-3).
.param x_dut_xm2_l = {x_dut_xm1_l}
.param x_dut_xmrn_l = {x_dut_xm1_l}
.param x_dut_xmns_l = {x_dut_xm1_l}
.param x_dut_xmns_w = {x_dut_xmrn_w}
.param x_dut_xmpb_l = {x_dut_xmpd_l}
.subckt buf_001_super_follower vdd vout vin ibias vss
CC na vss x_cc
XM1 na vin vout vss sky130_fd_pr__nfet_01v8 l=x_dut_xm1_l m=x_dut_xm1_m w=x_dut_xm1_w
XM2 vout na vss vss sky130_fd_pr__nfet_01v8 l=x_dut_xm2_l m=x_dut_xm2_m w=x_dut_xm2_w
XMNS pd ibias vss vss sky130_fd_pr__nfet_01v8 l=x_dut_xmns_l m=x_dut_xmns_m w=x_dut_xmns_w
XMPB na pd vdd vdd sky130_fd_pr__pfet_01v8 l=x_dut_xmpb_l m=x_dut_xmpb_m w=x_dut_xmpb_w
XMPD pd pd vdd vdd sky130_fd_pr__pfet_01v8 l=x_dut_xmpd_l m=x_dut_xmpd_m w=x_dut_xmpd_w
XMRN ibias ibias vss vss sky130_fd_pr__nfet_01v8 l=x_dut_xmrn_l m=x_dut_xmrn_m w=x_dut_xmrn_w
.ends
.end
