** GENERATED by `analog-db export-raw` — DO NOT EDIT.
** Standalone lowered DUT subckt for amp_031_srmc_core_cmfb on sky130 (sizing .param defaults + .subckt).
** Not a runnable deck on its own — include it under your own testbench:
**   .include _dut.spice
**   XDUT vinp vinn voutp voutn vdd vss amp_031_srmc_core_cmfb
** Source: pdk/sky130/netlist.spice (run `analog-db generate` to refresh).
*----------------------------------------------------------*
** params: 22 free + 6 frozen knobs (sizing.yaml) · 17 tied · 0 ratio-derived (abstract/params.yaml)
.param x_dut_xm3_w=6.294672891308078
.param x_dut_xm3_l=0.6753594045045483
.param x_dut_xm6_w=24.30804173824302
.param x_dut_xm6_l=0.6177436544112089
.param x_dut_xm5_w=28.711996565281737
.param x_dut_xm5_l=0.8800799502364873
.param x_dut_xm8_w=7.657238260880444
.param x_dut_xm8_l=0.7487316292807233
.param x_dut_xm1_w=18.631503913485417
.param x_dut_xm1_l=1.1458849126018995
.param x_dut_xm2_w=12.047485238576684
.param x_dut_xm2_l=1.1947908531195768
.param x_dut_c1_value=6.087573358364232e-12
.param x_dut_r1_value=11732.586882619622
.param x_dut_rm1p_value=13630139.383233285
.param gm_val=100u
.param rout_val=722149788.3259561
.param rin_val=82883762370133.39
.param cout_val=1.098648189774105e-12
.param cin_val=8.234272443600992e-13
.param vb2=0.9
.param vref_cm=0.7
.param x_dut_xm1_m=1
.param x_dut_xm2_m=1
.param x_dut_xm3_m=1
.param x_dut_xm5_m=1
.param x_dut_xm6_m=1
.param x_dut_xm8_m=1
* ---- GENERATED parameter ties (abstract/params.yaml groups/ratios) ----
* Each tied symbol is defined exactly once, by its line below; rewrite that
* .param to untie just that symbol (untying = shadowing, plan D-3).
.param x_dut_xm4_w = {x_dut_xm3_w}
.param x_dut_xm4_l = {x_dut_xm3_l}
.param x_dut_xm4_m = {x_dut_xm3_m}
.param x_dut_xm7_w = {x_dut_xm6_w}
.param x_dut_xm7_l = {x_dut_xm6_l}
.param x_dut_xm7_m = {x_dut_xm6_m}
.param x_dut_xm9_w = {x_dut_xm1_w}
.param x_dut_xm9_l = {x_dut_xm1_l}
.param x_dut_xm9_m = {x_dut_xm1_m}
.param x_dut_xm10_w = {x_dut_xm2_w}
.param x_dut_xm10_l = {x_dut_xm2_l}
.param x_dut_xm10_m = {x_dut_xm2_m}
.param x_dut_c2_value = {x_dut_c1_value}
.param x_dut_r2_value = {x_dut_r1_value}
.param x_dut_rm1n_value = {x_dut_rm1p_value}
.param x_dut_rm2p_value = {x_dut_rm1p_value}
.param x_dut_rm2n_value = {x_dut_rm1p_value}
.subckt amp_031_srmc_core_cmfb vinp vinn voutp voutn vdd vss
C1 vo1n zc_p 'x_dut_c1_value'
C2 vo1p zc_n 'x_dut_c2_value'
CIN1 cm1_det vref_cm1 'cin_val'
CIN2 cm2_det vref_cm2 'cin_val'
COUT1 vss vcmfb1 'cout_val'
COUT2 vss vcmfb2 'cout_val'
GM1 vss vcmfb1 cm1_det vref_cm1 {gm_val}
GM2 vss vcmfb2 cm2_det vref_cm2 {gm_val}
R1 zc_p voutp 'x_dut_r1_value'
R2 zc_n voutn 'x_dut_r2_value'
RIN1 cm1_det vref_cm1 'rin_val'
RIN2 cm2_det vref_cm2 'rin_val'
RM1N vo1n cm1_det 'x_dut_rm1n_value'
RM1P cm1_det vo1p 'x_dut_rm1p_value'
RM2N voutn cm2_det 'x_dut_rm2n_value'
RM2P cm2_det voutp 'x_dut_rm2p_value'
ROUT1 vss vcmfb1 'rout_val'
ROUT2 vss vcmfb2 'rout_val'
VB2 vb2 vss dc {vb2}
VREF1 vref_cm1 vss dc {vref_cm}
VREF2 vref_cm2 vss dc {vref_cm}
XM1 voutp vo1n vss vss sky130_fd_pr__nfet_01v8 l=x_dut_xm1_l m=x_dut_xm1_m w=x_dut_xm1_w
XM10 voutn vcmfb2 vdd vdd sky130_fd_pr__pfet_01v8 l=x_dut_xm10_l m=x_dut_xm10_m w=x_dut_xm10_w
XM2 voutp vcmfb2 vdd vdd sky130_fd_pr__pfet_01v8 l=x_dut_xm2_l m=x_dut_xm2_m w=x_dut_xm2_w
XM3 vo1n vinp ntail vss sky130_fd_pr__nfet_01v8 l=x_dut_xm3_l m=x_dut_xm3_m w=x_dut_xm3_w
XM4 vo1p vinn ntail vss sky130_fd_pr__nfet_01v8 l=x_dut_xm4_l m=x_dut_xm4_m w=x_dut_xm4_w
XM5 ntail vb2 vss vss sky130_fd_pr__nfet_01v8 l=x_dut_xm5_l m=x_dut_xm5_m w=x_dut_xm5_w
XM6 vo1p vinn ptail vdd sky130_fd_pr__pfet_01v8 l=x_dut_xm6_l m=x_dut_xm6_m w=x_dut_xm6_w
XM7 vo1n vinp ptail vdd sky130_fd_pr__pfet_01v8 l=x_dut_xm7_l m=x_dut_xm7_m w=x_dut_xm7_w
XM8 ptail vcmfb1 vdd vdd sky130_fd_pr__pfet_01v8 l=x_dut_xm8_l m=x_dut_xm8_m w=x_dut_xm8_w
XM9 voutn vo1p vss vss sky130_fd_pr__nfet_01v8 l=x_dut_xm9_l m=x_dut_xm9_m w=x_dut_xm9_w
.ends
