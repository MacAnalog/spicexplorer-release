** GENERATED by `analog-db export-raw` — DO NOT EDIT.
** circuit=amp_027_fan_rrl_ota  class=amplifier  pdk=gf180mcu  testbench=ac_open_loop  corner=tt
** Self-contained deck: testbench + bound params + lowered DUT (.subckt amp_027_fan_rrl_ota).
** PDK corner libs resolve by BARE NAME on the image's ngspice sourcepath — run in a
** PDK-enabled env (the base image / api container), NOT a bare host:
**   docker run --rm -i spicexplorer-spice-base:local \
**     bash -lc 'd=$(mktemp -d) && cat > $d/c.spice && cd $d && ngspice -b c.spice' < raw/amp_027_fan_rrl_ota/gf180mcu/ac_open_loop.spice
*----------------------------------------------------------*
** params: 20 free + 9 frozen knobs (sizing.yaml) · 23 tied · 0 ratio-derived (abstract/params.yaml) · 3 testbench params
** AUTHORED TEMPLATE — amplifier/ac_open_loop_diff (fully-differential open-loop AC).
** Open-loop DIFFERENTIAL gain/phase of a self-biased FD OTA (internal current reference,
** no external ibias port; e.g. amp_020_two_stage_miller_cmfb). Differential input driven directly
** — no AnalogGym-style bias-wrap needed: unlike a single-ended amp with no output
** feedback of any kind, a genuinely SYMMETRIC differential topology driven by MATCHED
** (vinp=vinn=VCM) inputs gives a well-defined output OFFSET regardless of open-loop gain
** — both branches move together, not apart, so there is nothing for the gain to amplify
** into a rail. (The output COMMON MODE still has to be centered by sizing — see
** pdk/<pdk>/sizing.yaml — but that's a device-sizing concern, not a testbench one.)
**
** Required bindings: DUT (subckt name), PORT_LINE (instance port order = circuit.yaml
**   ports: vinp vinn voutp voutn vdd vss), VDD VCM CL, FSTART FSTOP PPD,
**   PDK_INCLUDE (.lib/.include lines for the bound PDK+corner).
*----------------------------------------------------------*
.include design.ngspice
.lib sm141064.ngspice noise_corner
.lib sm141064.ngspice nfet_03v3_t
.lib sm141064.ngspice pfet_03v3_t
.lib sm141064.ngspice fets_mm
.lib sm141064.ngspice res_typical
.lib sm141064.ngspice mimcap_typical
.lib sm141064.ngspice cap_mim
.temp 27

.param VDD=3.3
.param VCM=1.2
.param CL=10p

Vdd  vdd 0 dc {VDD}
Vss  vss 0 dc 0
CLoadp voutp 0 {CL}
CLoadn voutn 0 {CL}

* DUT instance (port order = circuit.yaml ports)
XDUT vinp vinn voutp voutn vdd vss amp_027_fan_rrl_ota

* --- input drive (AC open loop, differential) ---
Vcm  vcm 0 dc {VCM}
Vinp vinp vcm dc 0 ac 0.5
Vinn vinn vcm dc 0 ac -0.5

.control
  set filetype=ascii
  ac dec 101 10 1G
  let vodm = v(voutp) - v(voutn)
  * db()/cph() must be precomputed as their own vectors before use in .meas FIND/WHEN —
  * ngspice's vdb()/cph() shorthand only resolves against real circuit nodes, not a
  * `let`-derived vector like vodm, so a bare `FIND db(vodm)` fails to resolve.
  let dbvodm = db(vodm)
  meas ac dcgain  FIND dbvodm  AT=10
  meas ac ugf     WHEN dbvodm=0 FALL=1
  * cph() = continuous (unwrapped) phase — vp() wraps at +/-180 and corrupts PM for
  * multi-pole phase trajectories; normalize to the DC phase so PM = 180 - total phase lag.
  let phc = cph(vodm)*180/3.14159265
  let ph = 180 + phc - phc[0]
  meas ac pm      FIND ph WHEN dbvodm=0 FALL=1
  write
  quit
.endc
.param x_dut_xm1_w=1.7623089602048373e-05
.param x_dut_xm1_l=1.369127501694859e-06
.param x_dut_xm2_w=5.889049437027081e-05
.param x_dut_xm2_l=1.6033732040870076e-06
.param x_dut_xm4_w=9.94615820750218e-05
.param x_dut_xm5_w=1.0451333631298199e-05
.param x_dut_xm5_l=1.3544484994578545e-06
.param x_dut_xm6_w=1.5274424179235197e-05
.param x_dut_xm6_l=1.6098583754463795e-06
.param x_dut_xm9_w=9.187857450587903e-05
.param x_dut_xm9_l=1.6789147317226054e-06
.param x_dut_xm11_w=9.296521288010723e-05
.param x_dut_xm11_l=2.3257966982671126e-06
.param x_dut_xm13_w=5.8433283014360016e-05
.param x_dut_xm15_w=2.016318826733622e-05
.param x_dut_xm15_l=9.487648744819404e-07
.param vb1=1.1
.param vb2=1.2
.param vb3=2.2
.param vb4=1.65
.param x_dut_xm1_m=1
.param x_dut_xm2_m=1
.param x_dut_xm4_m=1
.param x_dut_xm5_m=1
.param x_dut_xm6_m=1
.param x_dut_xm9_m=1
.param x_dut_xm11_m=1
.param x_dut_xm13_m=1
.param x_dut_xm15_m=1
* ---- GENERATED parameter ties (abstract/params.yaml groups/ratios) ----
* Each tied symbol is defined exactly once, by its line below; rewrite that
* .param to untie just that symbol (untying = shadowing, plan D-3).
.param x_dut_xm13_l = {x_dut_xm15_l}
.param x_dut_xm14_l = {x_dut_xm15_l}
.param x_dut_xm3_w = {x_dut_xm2_w}
.param x_dut_xm3_l = {x_dut_xm2_l}
.param x_dut_xm3_m = {x_dut_xm2_m}
.param x_dut_xm10_w = {x_dut_xm9_w}
.param x_dut_xm10_l = {x_dut_xm9_l}
.param x_dut_xm10_m = {x_dut_xm9_m}
.param x_dut_xm12_w = {x_dut_xm11_w}
.param x_dut_xm12_l = {x_dut_xm11_l}
.param x_dut_xm12_m = {x_dut_xm11_m}
.param x_dut_xm14_w = {x_dut_xm13_w}
.param x_dut_xm14_m = {x_dut_xm13_m}
.param x_dut_xm7_w = {x_dut_xm5_w}
.param x_dut_xm7_l = {x_dut_xm5_l}
.param x_dut_xm7_m = {x_dut_xm5_m}
.param x_dut_xm8_w = {x_dut_xm6_w}
.param x_dut_xm8_l = {x_dut_xm6_l}
.param x_dut_xm8_m = {x_dut_xm6_m}
.param x_dut_xm16_w = {x_dut_xm15_w}
.param x_dut_xm16_l = {x_dut_xm15_l}
.param x_dut_xm16_m = {x_dut_xm15_m}
.param x_dut_xm4_l = {x_dut_xm1_l}
.subckt amp_027_fan_rrl_ota vinp vinn voutp voutn vdd vss
VB1 vb1 vss dc {vb1}
VB2 vb2 vss dc {vb2}
VB3 vb3 vss dc {vb3}
VB4 vb4 vss dc {vb4}
XM1 tail vb3 vdd vdd pfet_03v3 l=x_dut_xm1_l m=x_dut_xm1_m w=x_dut_xm1_w
XM10 voutp vb1 d1p vdd pfet_03v3 l=x_dut_xm10_l m=x_dut_xm10_m w=x_dut_xm10_w
XM11 voutn vb2 csrc_n vss nfet_03v3 l=x_dut_xm11_l m=x_dut_xm11_m w=x_dut_xm11_w
XM12 voutp vb2 csrc_p vss nfet_03v3 l=x_dut_xm12_l m=x_dut_xm12_m w=x_dut_xm12_w
XM13 csrc_n cm_bias vss vss nfet_03v3 l=x_dut_xm13_l m=x_dut_xm13_m w=x_dut_xm13_w
XM14 csrc_p cm_bias vss vss nfet_03v3 l=x_dut_xm14_l m=x_dut_xm14_m w=x_dut_xm14_w
XM15 cm_bias cm_bias vss vss nfet_03v3 l=x_dut_xm15_l m=x_dut_xm15_m w=x_dut_xm15_w
XM16 cm_sense cm_sense vss vss nfet_03v3 l=x_dut_xm16_l m=x_dut_xm16_m w=x_dut_xm16_w
XM2 d1n vinp tail vdd pfet_03v3 l=x_dut_xm2_l m=x_dut_xm2_m w=x_dut_xm2_w
XM3 d1p vinn tail vdd pfet_03v3 l=x_dut_xm3_l m=x_dut_xm3_m w=x_dut_xm3_w
XM4 cm_tail vb3 vdd vdd pfet_03v3 l=x_dut_xm4_l m=x_dut_xm4_m w=x_dut_xm4_w
XM5 cm_sense voutn cm_tail vdd pfet_03v3 l=x_dut_xm5_l m=x_dut_xm5_m w=x_dut_xm5_w
XM6 cm_bias vb4 cm_tail vdd pfet_03v3 l=x_dut_xm6_l m=x_dut_xm6_m w=x_dut_xm6_w
XM7 cm_sense voutp cm_tail vdd pfet_03v3 l=x_dut_xm7_l m=x_dut_xm7_m w=x_dut_xm7_w
XM8 cm_bias vb4 cm_tail vdd pfet_03v3 l=x_dut_xm8_l m=x_dut_xm8_m w=x_dut_xm8_w
XM9 voutn vb1 d1n vdd pfet_03v3 l=x_dut_xm9_l m=x_dut_xm9_m w=x_dut_xm9_w
.ends
.end
