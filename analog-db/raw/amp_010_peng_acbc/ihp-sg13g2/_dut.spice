** GENERATED by `analog-db export-raw` — DO NOT EDIT.
** Standalone lowered DUT subckt for amp_010_peng_acbc on ihp-sg13g2 (sizing .param defaults + .subckt).
** Not a runnable deck on its own — include it under your own testbench:
**   .include _dut.spice
**   XDUT vss vdd vinn vinp vout amp_010_peng_acbc
** Source: pdk/ihp-sg13g2/netlist.spice (run `analog-db generate` to refresh).
*----------------------------------------------------------*
** params: 33 free + 0 frozen knobs (sizing.yaml) · 36 tied · 15 ratio-derived (abstract/params.yaml)
.param CAPACITOR_0=1.52436e-11
.param CAPACITOR_1=4.40251e-12
.param CURRENT_0_BIAS=1.80825e-05
.param x_dut_xm7_l=1.29023e-06
.param x_dut_xm7_m=4
.param x_dut_xm7_w=2.68552e-06
.param x_dut_xm11_l=1.24398e-06
.param x_dut_xm11_m=1
.param x_dut_xm11_w=6.39689e-06
.param x_dut_xm12_l=1.18843e-06
.param x_dut_xm12_m=4
.param x_dut_xm12_w=9.15993e-06
.param x_dut_xm16_l=5.01072e-07
.param x_dut_xm16_m=16
.param x_dut_xm16_w=3.54528e-06
.param x_dut_xm20_l=6.16839e-07
.param x_dut_xm15_m=4
.param x_dut_xm20_w=5.53172e-06
.param x_dut_xm23_l=9.69768e-06
.param x_dut_xm23_m=4
.param x_dut_xm23_w=4.02344e-06
.param x_dut_xm24_l=8.02382e-06
.param x_dut_xm24_m=4
.param x_dut_xm24_w=9.96754e-06
.param x_dut_xm25_l=1.90775e-06
.param x_dut_xm25_m=4
.param x_dut_xm25_w=3.52209e-06
.param x_dut_xm59_l=7.87825e-06
.param x_dut_xm59_m=4
.param x_dut_xm59_w=4.97775e-06
.param x_dut_xm10_l=1.06667e-06
.param x_dut_xm10_m=4
.param x_dut_xm10_w=4.25034e-06
* ---- GENERATED parameter ties (abstract/params.yaml groups/ratios) ----
* Each tied symbol is defined exactly once, by its line below; rewrite that
* .param to untie just that symbol (untying = shadowing, plan D-3).
.param x_dut_xm6_w = {x_dut_xm7_w}
.param x_dut_xm5_w = {x_dut_xm7_w}
.param x_dut_xm4_w = {x_dut_xm7_w}
.param x_dut_xm3_w = {x_dut_xm7_w}
.param x_dut_xm2_w = {x_dut_xm7_w}
.param x_dut_xm8_w = {x_dut_xm7_w}
.param x_dut_xm1_w = {x_dut_xm7_w}
.param x_dut_xm0_w = {x_dut_xm7_w}
.param x_dut_xm6_l = {x_dut_xm7_l}
.param x_dut_xm5_l = {x_dut_xm7_l}
.param x_dut_xm4_l = {x_dut_xm7_l}
.param x_dut_xm3_l = {x_dut_xm7_l}
.param x_dut_xm2_l = {x_dut_xm7_l}
.param x_dut_xm8_l = {x_dut_xm7_l}
.param x_dut_xm1_l = {x_dut_xm7_l}
.param x_dut_xm0_l = {x_dut_xm7_l}
.param x_dut_xm9_w = {x_dut_xm10_w}
.param x_dut_xm9_l = {x_dut_xm10_l}
.param x_dut_xm9_m = {x_dut_xm10_m}
.param x_dut_xm22_w = {x_dut_xm23_w}
.param x_dut_xm22_l = {x_dut_xm23_l}
.param x_dut_xm22_m = {x_dut_xm23_m}
.param x_dut_xm21_w = {x_dut_xm20_w}
.param x_dut_xm18_w = {x_dut_xm20_w}
.param x_dut_xm15_w = {x_dut_xm20_w}
.param x_dut_xm13_w = {x_dut_xm20_w}
.param x_dut_xm19_w = {x_dut_xm20_w}
.param x_dut_xm14_w = {x_dut_xm20_w}
.param x_dut_xm21_l = {x_dut_xm20_l}
.param x_dut_xm18_l = {x_dut_xm20_l}
.param x_dut_xm15_l = {x_dut_xm20_l}
.param x_dut_xm13_l = {x_dut_xm20_l}
.param x_dut_xm19_l = {x_dut_xm20_l}
.param x_dut_xm14_l = {x_dut_xm20_l}
.param x_dut_xm17_w = {x_dut_xm16_w}
.param x_dut_xm17_l = {x_dut_xm16_l}
.param x_dut_xm6_m = {x_dut_xm7_m*1}
.param x_dut_xm5_m = {x_dut_xm7_m*1}
.param x_dut_xm4_m = {x_dut_xm7_m*2}
.param x_dut_xm3_m = {x_dut_xm7_m*1}
.param x_dut_xm2_m = {x_dut_xm7_m*1}
.param x_dut_xm8_m = {x_dut_xm7_m*1}
.param x_dut_xm1_m = {x_dut_xm7_m*1}
.param x_dut_xm0_m = {x_dut_xm7_m*1}
.param x_dut_xm17_m = {x_dut_xm16_m*1}
.param x_dut_xm20_m = {x_dut_xm15_m*8}
.param x_dut_xm21_m = {x_dut_xm15_m*8}
.param x_dut_xm18_m = {x_dut_xm15_m*4}
.param x_dut_xm13_m = {x_dut_xm15_m*4}
.param x_dut_xm19_m = {x_dut_xm15_m*4}
.param x_dut_xm14_m = {x_dut_xm15_m*4}
.subckt amp_010_peng_acbc vss vdd vinn vinp vout
C0 net050 VOUT 'CAPACITOR_0'
C1 net049 net1 'CAPACITOR_1'
I0 net013 vss 'CURRENT_0_BIAS'
XM0 net013 net013 vdd vdd sg13_lv_pmos l=x_dut_xm0_l m=x_dut_xm0_m w=x_dut_xm0_w
XM1 VB4 net013 vdd vdd sg13_lv_pmos l=x_dut_xm1_l m=x_dut_xm1_m w=x_dut_xm1_w
XM10 net063 VINP net31 net31 sg13_lv_pmos l=x_dut_xm10_l m=x_dut_xm10_m w=x_dut_xm10_w
XM11 net043 net050 vdd vdd sg13_lv_pmos l=x_dut_xm11_l m=x_dut_xm11_m w=x_dut_xm11_w
XM12 VOUT net050 vdd vdd sg13_lv_pmos l=x_dut_xm12_l m=x_dut_xm12_m w=x_dut_xm12_w
XM13 VB4 VB3 net54 vss sg13_lv_nmos l=x_dut_xm13_l m=x_dut_xm13_m w=x_dut_xm13_w
XM14 DM_1 VB3 net56 vss sg13_lv_nmos l=x_dut_xm14_l m=x_dut_xm14_m w=x_dut_xm14_w
XM15 VB3 VB3 vss vss sg13_lv_nmos l=x_dut_xm15_l m=x_dut_xm15_m w=x_dut_xm15_w
XM16 VOUTN VB3 DM_2 vss sg13_lv_nmos l=x_dut_xm16_l m=x_dut_xm16_m w=x_dut_xm16_w
XM17 net050 VB3 net063 vss sg13_lv_nmos l=x_dut_xm17_l m=x_dut_xm17_m w=x_dut_xm17_w
XM18 net54 VB4 vss vss sg13_lv_nmos l=x_dut_xm18_l m=x_dut_xm18_m w=x_dut_xm18_w
XM19 net56 VB4 vss vss sg13_lv_nmos l=x_dut_xm19_l m=x_dut_xm19_m w=x_dut_xm19_w
XM2 DM_1 net013 vdd vdd sg13_lv_pmos l=x_dut_xm2_l m=x_dut_xm2_m w=x_dut_xm2_w
XM20 DM_2 VB4 vss vss sg13_lv_nmos l=x_dut_xm20_l m=x_dut_xm20_m w=x_dut_xm20_w
XM21 net063 VB4 vss vss sg13_lv_nmos l=x_dut_xm21_l m=x_dut_xm21_m w=x_dut_xm21_w
XM22 net043 net043 vss vss sg13_lv_nmos l=x_dut_xm22_l m=x_dut_xm22_m w=x_dut_xm22_w
XM23 net049 net043 vss vss sg13_lv_nmos l=x_dut_xm23_l m=x_dut_xm23_m w=x_dut_xm23_w
XM24 net1 net043 vss vss sg13_lv_nmos l=x_dut_xm24_l m=x_dut_xm24_m w=x_dut_xm24_w
XM25 VOUT net049 vss vss sg13_lv_nmos l=x_dut_xm25_l m=x_dut_xm25_m w=x_dut_xm25_w
XM3 VB3 net013 vdd vdd sg13_lv_pmos l=x_dut_xm3_l m=x_dut_xm3_m w=x_dut_xm3_w
XM4 net31 net013 vdd vdd sg13_lv_pmos l=x_dut_xm4_l m=x_dut_xm4_m w=x_dut_xm4_w
XM5 VOUTN VOUTN vdd vdd sg13_lv_pmos l=x_dut_xm5_l m=x_dut_xm5_m w=x_dut_xm5_w
XM59 net1 net1 vdd vdd sg13_lv_pmos l=x_dut_xm59_l m=x_dut_xm59_m w=x_dut_xm59_w
XM6 net050 VOUTN vdd vdd sg13_lv_pmos l=x_dut_xm6_l m=x_dut_xm6_m w=x_dut_xm6_w
XM7 net049 net013 vdd vdd sg13_lv_pmos l=x_dut_xm7_l m=x_dut_xm7_m w=x_dut_xm7_w
XM8 net1 net013 vdd vdd sg13_lv_pmos l=x_dut_xm8_l m=x_dut_xm8_m w=x_dut_xm8_w
XM9 DM_2 VINN net31 net31 sg13_lv_pmos l=x_dut_xm9_l m=x_dut_xm9_m w=x_dut_xm9_w
.ends
