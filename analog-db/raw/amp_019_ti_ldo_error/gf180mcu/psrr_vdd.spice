** GENERATED by `analog-db export-raw` — DO NOT EDIT.
** circuit=amp_019_ti_ldo_error  class=amplifier  pdk=gf180mcu  testbench=psrr_vdd  corner=tt
** Self-contained deck: testbench + bound params + lowered DUT (.subckt amp_019_ti_ldo_error).
** PDK corner libs resolve by BARE NAME on the image's ngspice sourcepath — run in a
** PDK-enabled env (the base image / api container), NOT a bare host:
**   docker run --rm -i spicexplorer-spice-base:local \
**     bash -lc 'd=$(mktemp -d) && cat > $d/c.spice && cd $d && ngspice -b c.spice' < raw/amp_019_ti_ldo_error/gf180mcu/psrr_vdd.spice
*----------------------------------------------------------*
** params: 19 free + 0 frozen knobs (sizing.yaml) · 10 tied · 0 ratio-derived (abstract/params.yaml) · 4 testbench params
** AUTHORED TEMPLATE — amplifier/psrr_vdd (plan D-4/D-5): positive-supply rejection.
** The DUT is closed in a unity-gain buffer (vinn shorted to vout, vinp held at VCM with NO ac), and
** the supply Vdd carries a 1 V AC ripple. With the signal input quiet, every AC volt at vout is
** supply feed-through, so PSRR+ = -20·log10|vout/vdd| = -vdb(vout) (vdd ac = 1). Reported at FSTART
** (the DC-band floor). This is the buffer-application PSRR — the meaningful number for the
** voltage-buffer OTAs whose datasheet is closed-loop (gain_cl/bw_cl); sim-validated on the 5T
** (ihp≈29.7, sky130≈26.8, gf180≈53.5 dB — tracks the loop gain, as expected).
** Bindings: DUT PORT_LINE VDD VCM IBIAS CL FSTART FSTOP PPD PDK_INCLUDE.
.include design.ngspice
.lib sm141064.ngspice typical
.temp 27

.param VDD=3.3
.param VCM=1.2
.param IBIAS=1m
.param CL=10p

Vdd  vdd 0 dc {VDD} ac 1     ; 1 V supply-ripple stimulus
Vss  vss 0 dc 0
Ibias vdd ibias dc {IBIAS}
CLoad vout 0 {CL}

Vinp vinp 0 dc {VCM}         ; signal input held quiet (no ac) — isolate the supply path
Vfb  vinn vout dc 0          ; unity-gain buffer: vinn shorted to vout

XDUT vdd vout vinp vinn ibias vss amp_019_ti_ldo_error

.control
  set filetype=ascii
  ac dec 101 1k 1G
  let psrr = -vdb(vout)
  meas ac psrr_vdd_db FIND psrr AT=1k
  write
  quit
.endc
.param x_dut_xmb0_w=1e-05
.param x_dut_xmb0_l=2e-06
.param x_dut_xmbc_m=1
.param x_dut_xmbo_m=1
.param x_dut_xm1_w=4e-05
.param x_dut_xm1_l=7e-07
.param x_dut_xm3_w=0.0001
.param x_dut_xm3_l=5e-07
.param x_dut_xm4_w=1e-05
.param x_dut_xm4_l=5e-07
.param x_dut_xm7_w=4e-05
.param x_dut_xm7_l=5e-07
.param x_dut_xm6_w=0.0001
.param x_dut_xm6_l=5e-07
.param r_z=470
.param c_comp=2.5e-11
.param x_dut_xmbe_w=4e-07
.param x_dut_xmbf_w=5e-06
.param r_nd=500000
* ---- GENERATED parameter ties (abstract/params.yaml groups/ratios) ----
* Each tied symbol is defined exactly once, by its line below; rewrite that
* .param to untie just that symbol (untying = shadowing, plan D-3).
.param x_dut_xmbc_l = {x_dut_xmb0_l}
.param x_dut_xmbf_l = {x_dut_xmb0_l}
.param x_dut_xmbe_l = {x_dut_xmb0_l}
.param x_dut_xmbo_l = {x_dut_xmb0_l}
.param x_dut_xmbc_w = {x_dut_xmb0_w}
.param x_dut_xmbo_w = {x_dut_xmb0_w}
.param x_dut_xm2_w = {x_dut_xm1_w}
.param x_dut_xm2_l = {x_dut_xm1_l}
.param x_dut_xm5_w = {x_dut_xm3_w}
.param x_dut_xm5_l = {x_dut_xm3_l}
.subckt amp_019_ti_ldo_error vdd vout vinp vinn ibias vss
CC ncz vout 'c_comp'
RND na nd 'r_nd'
RZ nb ncz 'r_z'
XM1 na vinn tail vss nfet_06v0 l=x_dut_xm1_l w=x_dut_xm1_w
XM2 nb vinp tail vss nfet_06v0 l=x_dut_xm2_l w=x_dut_xm2_w
XM3 na nd vdd vdd pfet_06v0 l=x_dut_xm3_l w=x_dut_xm3_w
XM4 nlev na nd vdd pfet_06v0 l=x_dut_xm4_l w=x_dut_xm4_w
XM5 nb nd vdd vdd pfet_06v0 l=x_dut_xm5_l w=x_dut_xm5_w
XM6 vout ne vdd vdd pfet_06v0 l=x_dut_xm6_l w=x_dut_xm6_w
XM7 ne ne nb vdd pfet_06v0 l=x_dut_xm7_l w=x_dut_xm7_w
XMB0 ibias ibias vss vss nfet_06v0 l=x_dut_xmb0_l w=x_dut_xmb0_w
XMBC tail ibias vss vss nfet_06v0 l=x_dut_xmbc_l m=x_dut_xmbc_m w=x_dut_xmbc_w
XMBE ne ibias vss vss nfet_06v0 l=x_dut_xmbe_l w=x_dut_xmbe_w
XMBF nlev ibias vss vss nfet_06v0 l=x_dut_xmbf_l w=x_dut_xmbf_w
XMBO vout ibias vss vss nfet_06v0 l=x_dut_xmbo_l m=x_dut_xmbo_m w=x_dut_xmbo_w
.ends
.end
