** AUTHORED TEMPLATE — voltage_reference/line_sweep: line regulation over the supply.
** [VALIDATED 2026-07-16 on ihp-sg13g2 against vref_001_vgs — live ngspice, 4/4 benches pass].
** Sweeps Vdd and reports the reference %-change over the swept range referred to the nominal-supply
** value. Port convention: vdd vref vss. Bindings: DUT PORT_LINE VDD VDD_LO VDD_HI VDD_STEP PDK_INCLUDE.
${PDK_INCLUDE}

.param VDD=${VDD}

Vdd vdd 0 dc {VDD}
Vss vss 0 dc 0

${PORT_LINE} ${DUT}

.control
  set filetype=ascii
  dc Vdd ${VDD_LO} ${VDD_HI} ${VDD_STEP}
  meas dc v_at_lo  FIND v(vref) AT=${VDD_LO}
  meas dc v_at_hi  FIND v(vref) AT=${VDD_HI}
  meas dc v_at_nom FIND v(vref) AT=${VDD}
  let line_reg_pct = abs((v_at_hi - v_at_lo) / v_at_nom) * 100
  print line_reg_pct
  write
  quit
.endc
.end
