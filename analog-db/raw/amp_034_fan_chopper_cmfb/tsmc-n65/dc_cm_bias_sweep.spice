** GENERATED by `analog-db export-raw` — DO NOT EDIT.
** circuit=amp_034_fan_chopper_cmfb  class=amplifier  pdk=tsmc-n65  testbench=dc_cm_bias_sweep  corner=tt
** Self-contained deck: testbench + bound params + lowered DUT (.subckt amp_034_fan_chopper_cmfb).
** PDK corner libs resolve by BARE NAME on the image's ngspice sourcepath — run in a
** PDK-enabled env (the base image / api container), NOT a bare host:
**   docker run --rm -i spicexplorer-spice-base:local \
**     bash -lc 'd=$(mktemp -d) && cat > $d/c.spice && cd $d && ngspice -b c.spice' < raw/amp_034_fan_chopper_cmfb/tsmc-n65/dc_cm_bias_sweep.spice
*----------------------------------------------------------*
** params: 36 free + 15 frozen knobs (sizing.yaml) · 49 tied · 0 ratio-derived (abstract/params.yaml) · 2 testbench params
** AUTHORED TEMPLATE — amplifier/dc_cm_bias_sweep (committed from the amp_029 review
** finding: "no stable interior DC point" deserved a reproducible gate, not scratchpad
** prose). Characterizes the OUTPUT-COMMON-MODE sensitivity of an FD amplifier to one
** internal bias knob: the knob (name bound as CMKNOB, e.g. the stage-1 load-gate bias)
** is stepped across 5 points VB1..VB5 via alterparam+reset; at each point the op's
** output CM vocm_i = (voutp+voutn)/2 is recorded. cm_interior_pts counts how many of
** the 5 land inside VCM +/- VBAND:
**   5..1  = the knob has a usable interior window (its width ~ the passing points'
**           span — pick VB points around the expected balance);
**   0     = the output rails at every sampled bias: no interior operating point at
**           this sizing (e.g. a no-CMFB topology's cascaded gds knife edges).
** Matched DC inputs at VCM; self-biased diff port order:
**   .subckt <id> vinp vinn voutp voutn vdd vss
** Required bindings: DUT PORT_LINE VDD VCM VBAND CMKNOB VB1 VB2 VB3 VB4 VB5
**                    PDK_INCLUDE.
.lib tsmc_n65_models.scs tt
.temp 27

.param VDD=1.2
.param VCM=0.6

Vdd  vdd 0 dc {VDD}
Vss  vss 0 dc 0
Vcm  vcm 0 dc {VCM}
Vinp vinp vcm dc 0
Vinn vinn vcm dc 0

XDUT vinp vinn voutp voutn vdd vss amp_034_fan_chopper_cmfb

.control
  set filetype=ascii
  * each op opens a NEW plot: print every vocm_i immediately (the measure parser reads
  * these lines), and the final count reaches back via plot-qualified names (opN.vocm_N).
  alterparam vcm_ref=0.46
  reset
  op
  let vocm_1 = (v(voutp)+v(voutn))/2
  print vocm_1
  alterparam vcm_ref=0.48
  reset
  op
  let vocm_2 = (v(voutp)+v(voutn))/2
  print vocm_2
  alterparam vcm_ref=0.5
  reset
  op
  let vocm_3 = (v(voutp)+v(voutn))/2
  print vocm_3
  alterparam vcm_ref=0.52
  reset
  op
  let vocm_4 = (v(voutp)+v(voutn))/2
  print vocm_4
  alterparam vcm_ref=0.54
  reset
  op
  let vocm_5 = (v(voutp)+v(voutn))/2
  print vocm_5
  let lo = 0.6 - 0.15
  let hi = 0.6 + 0.15
  let cm_interior_pts = ((op1.vocm_1 gt lo) & (op1.vocm_1 lt hi)) + ((op2.vocm_2 gt lo) & (op2.vocm_2 lt hi)) + ((op3.vocm_3 gt lo) & (op3.vocm_3 lt hi)) + ((op4.vocm_4 gt lo) & (op4.vocm_4 lt hi)) + ((vocm_5 gt lo) & (vocm_5 lt hi))
  print cm_interior_pts
  write
  quit
.endc
.param x_dut_xm4_cmfb_w=6.65u
.param x_dut_xm4_cmfb_l=1u
.param x_dut_xm2_cmfb_w=0.168u
.param x_dut_xm2_cmfb_l=6u
.param x_dut_xm1_cmfb_w=3.82u
.param x_dut_xm7_cmfb_w=0.180u
.param x_dut_xm7_cmfb_l=10u
.param x_dut_xm3_cmfb_w=1.91u
.param x_dut_xm3_cmfb_l=1u
.param x_dut_rmp_cmfb_value=1Meg
.param x_dut_xm1_cmfb_m=1
.param x_dut_xm2_cmfb_m=1
.param x_dut_xm3_cmfb_m=1
.param x_dut_xm4_cmfb_m=1
.param x_dut_xm7_cmfb_m=1
.param x_dut_xm1_core_w=5.629u
.param x_dut_xm1_core_l=1u
.param x_dut_xm2_core_w=4.933u
.param x_dut_xm2_core_l=0.5u
.param x_dut_xm4_core_w=2.51u
.param x_dut_xm4_core_l=1u
.param x_dut_xm6_core_w=2.814u
.param x_dut_xm10_core_w=2.398u
.param x_dut_xm10_core_l=0.3u
.param x_dut_xm12_core_w=0.792u
.param x_dut_xm12_core_l=0.3u
.param x_dut_xm14_core_w=1.043u
.param x_dut_xm14_core_l=0.25u
.param x_dut_xm16_core_w=2u
.param x_dut_xm16_core_l=0.13u
.param x_dut_xm17_core_w=2u
.param x_dut_xm17_core_l=0.13u
.param x_dut_cm1_core_value=2p
.param vb1_core=0.324117
.param vb2_core=0.472198
.param vb3_core=0.438401
.param vb4_core=0.785955
.param x_dut_xm1_core_m=1
.param x_dut_xm2_core_m=1
.param x_dut_xm4_core_m=1
.param x_dut_xm6_core_m=1
.param x_dut_xm10_core_m=1
.param x_dut_xm12_core_m=1
.param x_dut_xm14_core_m=1
.param x_dut_xm16_core_m=1
.param x_dut_xm17_core_m=1
.param vcm_ref=0.6
.param x_dut_xm8o_w=11.257u
.param x_dut_xm8o_l=1u
.param x_dut_xm8o_m=1
.param c_cm=5p
* ---- GENERATED parameter ties (abstract/params.yaml groups/ratios) ----
* Each tied symbol is defined exactly once, by its line below; rewrite that
* .param to untie just that symbol (untying = shadowing, plan D-3).
.param x_dut_xm9o_w = {x_dut_xm8o_w}
.param x_dut_xm9o_l = {x_dut_xm8o_l}
.param x_dut_xm9o_m = {x_dut_xm8o_m}
.param x_dut_xm5_cmfb_w = {x_dut_xm4_cmfb_w}
.param x_dut_xm5_cmfb_l = {x_dut_xm4_cmfb_l}
.param x_dut_xm5_cmfb_m = {x_dut_xm4_cmfb_m}
.param x_dut_xm6_cmfb_w = {x_dut_xm2_cmfb_w}
.param x_dut_xm6_cmfb_l = {x_dut_xm2_cmfb_l}
.param x_dut_xm6_cmfb_m = {x_dut_xm2_cmfb_m}
.param x_dut_rmn_cmfb_value = {x_dut_rmp_cmfb_value}
.param x_dut_xm3_core_w = {x_dut_xm2_core_w}
.param x_dut_xm3_core_l = {x_dut_xm2_core_l}
.param x_dut_xm3_core_m = {x_dut_xm2_core_m}
.param x_dut_xm5_core_w = {x_dut_xm4_core_w}
.param x_dut_xm5_core_l = {x_dut_xm4_core_l}
.param x_dut_xm5_core_m = {x_dut_xm4_core_m}
.param x_dut_xm13_core_w = {x_dut_xm12_core_w}
.param x_dut_xm13_core_l = {x_dut_xm12_core_l}
.param x_dut_xm13_core_m = {x_dut_xm12_core_m}
.param x_dut_xm11_core_w = {x_dut_xm10_core_w}
.param x_dut_xm11_core_l = {x_dut_xm10_core_l}
.param x_dut_xm11_core_m = {x_dut_xm10_core_m}
.param x_dut_xm7_core_w = {x_dut_xm6_core_w}
.param x_dut_xm7_core_m = {x_dut_xm6_core_m}
.param x_dut_xm6_core_l = {x_dut_xm1_core_l}
.param x_dut_xm7_core_l = {x_dut_xm1_core_l}
.param x_dut_xm15_core_w = {x_dut_xm14_core_w}
.param x_dut_xm15_core_l = {x_dut_xm14_core_l}
.param x_dut_xm15_core_m = {x_dut_xm14_core_m}
.param x_dut_xm18_core_w = {x_dut_xm16_core_w}
.param x_dut_xm20_core_w = {x_dut_xm16_core_w}
.param x_dut_xm22_core_w = {x_dut_xm16_core_w}
.param x_dut_xm18_core_l = {x_dut_xm16_core_l}
.param x_dut_xm20_core_l = {x_dut_xm16_core_l}
.param x_dut_xm22_core_l = {x_dut_xm16_core_l}
.param x_dut_xm18_core_m = {x_dut_xm16_core_m}
.param x_dut_xm20_core_m = {x_dut_xm16_core_m}
.param x_dut_xm22_core_m = {x_dut_xm16_core_m}
.param x_dut_xm19_core_w = {x_dut_xm17_core_w}
.param x_dut_xm21_core_w = {x_dut_xm17_core_w}
.param x_dut_xm23_core_w = {x_dut_xm17_core_w}
.param x_dut_xm19_core_l = {x_dut_xm17_core_l}
.param x_dut_xm21_core_l = {x_dut_xm17_core_l}
.param x_dut_xm23_core_l = {x_dut_xm17_core_l}
.param x_dut_xm19_core_m = {x_dut_xm17_core_m}
.param x_dut_xm21_core_m = {x_dut_xm17_core_m}
.param x_dut_xm23_core_m = {x_dut_xm17_core_m}
.param x_dut_cm2_core_value = {x_dut_cm1_core_value}
.param x_dut_xm1_cmfb_l = {x_dut_xm3_cmfb_l}
.param x_dut_xm20_core_w = {x_dut_xm16_core_w}
.param x_dut_xm20_core_l = {x_dut_xm16_core_l}
.param x_dut_xm20_core_m = {x_dut_xm16_core_m}
.param x_dut_xm23_core_w = {x_dut_xm17_core_w}
.param x_dut_xm23_core_l = {x_dut_xm17_core_l}
.param x_dut_xm23_core_m = {x_dut_xm17_core_m}
.param x_dut_xm22_core_w = {x_dut_xm18_core_w}
.param x_dut_xm22_core_l = {x_dut_xm18_core_l}
.param x_dut_xm22_core_m = {x_dut_xm18_core_m}
.param x_dut_xm21_core_w = {x_dut_xm19_core_w}
.param x_dut_xm21_core_l = {x_dut_xm19_core_l}
.param x_dut_xm21_core_m = {x_dut_xm19_core_m}
.subckt amp_034_fan_chopper_cmfb vinp vinn voutp voutn vdd vss
CCM vb4o vss 'c_cm'
CM1_CORE core__g2_p voutp 'x_dut_cm1_core_value'
CM2_CORE core__g2_n voutn 'x_dut_cm2_core_value'
RMN_CMFB voutn cmfb__cm_sense 'x_dut_rmn_cmfb_value'
RMP_CMFB cmfb__cm_sense voutp 'x_dut_rmp_cmfb_value'
VB1_CORE core__vb1 vss dc {vb1_core}
VB2_CORE core__vb2 vss dc {vb2_core}
VB3_CORE core__vb3 vss dc {vb3_core}
VB4_CORE core__vb4 vss dc {vb4_core}
VREFCM vref_cm vss dc {vcm_ref}
XM10_CORE core__out1_n core__vb3 core__casc_src_n vdd pch_lvt l=x_dut_xm10_core_l m=x_dut_xm10_core_m w=x_dut_xm10_core_w
XM11_CORE core__out1_p core__vb3 core__casc_src_p vdd pch_lvt l=x_dut_xm11_core_l m=x_dut_xm11_core_m w=x_dut_xm11_core_w
XM12_CORE core__out1_p core__vb2 core__fold_p vss nch_lvt l=x_dut_xm12_core_l m=x_dut_xm12_core_m w=x_dut_xm12_core_w
XM13_CORE core__out1_n core__vb2 core__fold_n vss nch_lvt l=x_dut_xm13_core_l m=x_dut_xm13_core_m w=x_dut_xm13_core_w
XM14_CORE voutp core__g2_p vss vss nch_lvt l=x_dut_xm14_core_l m=x_dut_xm14_core_m w=x_dut_xm14_core_w
XM15_CORE voutn core__g2_n vss vss nch_lvt l=x_dut_xm15_core_l m=x_dut_xm15_core_m w=x_dut_xm15_core_w
XM16_CORE core__out1_n vdd core__g2_n vss nch_lvt l=x_dut_xm16_core_l m=x_dut_xm16_core_m w=x_dut_xm16_core_w
XM17_CORE core__g2_n vss core__out1_n vdd pch_lvt l=x_dut_xm17_core_l m=x_dut_xm17_core_m w=x_dut_xm17_core_w
XM18_CORE core__out1_p vdd core__g2_p vss nch_lvt l=x_dut_xm18_core_l m=x_dut_xm18_core_m w=x_dut_xm18_core_w
XM19_CORE core__g2_p vss core__out1_p vdd pch_lvt l=x_dut_xm19_core_l m=x_dut_xm19_core_m w=x_dut_xm19_core_w
XM1_CMFB cmfb__ptail cmfb__bias vdd vdd pch_lvt l=x_dut_xm1_cmfb_l m=x_dut_xm1_cmfb_m w=x_dut_xm1_cmfb_w
XM1_CORE core__tail core__vb4 vdd vdd pch_lvt l=x_dut_xm1_core_l m=x_dut_xm1_core_m w=x_dut_xm1_core_w
XM20_CORE core__out1_p vss core__g2_n vss nch_lvt l=x_dut_xm20_core_l m=x_dut_xm20_core_m w=x_dut_xm20_core_w
XM21_CORE core__g2_n vdd core__out1_p vdd pch_lvt l=x_dut_xm21_core_l m=x_dut_xm21_core_m w=x_dut_xm21_core_w
XM22_CORE core__out1_n vss core__g2_p vss nch_lvt l=x_dut_xm22_core_l m=x_dut_xm22_core_m w=x_dut_xm22_core_w
XM23_CORE core__g2_p vdd core__out1_n vdd pch_lvt l=x_dut_xm23_core_l m=x_dut_xm23_core_m w=x_dut_xm23_core_w
XM2_CMFB vb4o cmfb__mirr vss vss nch_lvt l=x_dut_xm2_cmfb_l m=x_dut_xm2_cmfb_m w=x_dut_xm2_cmfb_w
XM2_CORE core__fold_p vinp core__tail vdd pch_lvt l=x_dut_xm2_core_l m=x_dut_xm2_core_m w=x_dut_xm2_core_w
XM3_CMFB cmfb__bias cmfb__bias vdd vdd pch_lvt l=x_dut_xm3_cmfb_l m=x_dut_xm3_cmfb_m w=x_dut_xm3_cmfb_w
XM3_CORE core__fold_n vinn core__tail vdd pch_lvt l=x_dut_xm3_core_l m=x_dut_xm3_core_m w=x_dut_xm3_core_w
XM4_CMFB cmfb__mirr cmfb__cm_sense cmfb__ptail vdd pch_lvt l=x_dut_xm4_cmfb_l m=x_dut_xm4_cmfb_m w=x_dut_xm4_cmfb_w
XM4_CORE core__fold_p core__vb1 vss vss nch_lvt l=x_dut_xm4_core_l m=x_dut_xm4_core_m w=x_dut_xm4_core_w
XM5_CMFB vb4o vref_cm cmfb__ptail vdd pch_lvt l=x_dut_xm5_cmfb_l m=x_dut_xm5_cmfb_m w=x_dut_xm5_cmfb_w
XM5_CORE core__fold_n core__vb1 vss vss nch_lvt l=x_dut_xm5_core_l m=x_dut_xm5_core_m w=x_dut_xm5_core_w
XM6_CMFB cmfb__mirr cmfb__mirr vss vss nch_lvt l=x_dut_xm6_cmfb_l m=x_dut_xm6_cmfb_m w=x_dut_xm6_cmfb_w
XM6_CORE core__casc_src_n core__vb4 vdd vdd pch_lvt l=x_dut_xm6_core_l m=x_dut_xm6_core_m w=x_dut_xm6_core_w
XM7_CMFB cmfb__bias cmfb__bias vss vss nch_lvt l=x_dut_xm7_cmfb_l m=x_dut_xm7_cmfb_m w=x_dut_xm7_cmfb_w
XM7_CORE core__casc_src_p core__vb4 vdd vdd pch_lvt l=x_dut_xm7_core_l m=x_dut_xm7_core_m w=x_dut_xm7_core_w
XM8O voutp vb4o vdd vdd pch_lvt l=x_dut_xm8o_l m=x_dut_xm8o_m w=x_dut_xm8o_w
XM9O voutn vb4o vdd vdd pch_lvt l=x_dut_xm9o_l m=x_dut_xm9o_m w=x_dut_xm9o_w
.ends
.end
