** GENERATED by `analog-db export-raw` — DO NOT EDIT.
** Standalone lowered DUT subckt for buf_001_super_follower on sky130 (sizing .param defaults + .subckt).
** Not a runnable deck on its own — include it under your own testbench:
**   .include _dut.spice
**   XDUT vdd vout vin ibias vss buf_001_super_follower
** Source: pdk/sky130/netlist.spice (run `analog-db generate` to refresh).
*----------------------------------------------------------*
** params: 8 free + 6 frozen knobs (sizing.yaml) · 5 tied · 0 ratio-derived (abstract/params.yaml)
.param x_dut_xm1_w=8
.param x_dut_xm2_w=8
.param x_dut_xmrn_w=4
.param x_dut_xmpd_w=8
.param x_dut_xmpb_w=8
.param x_dut_xm1_l=0.3
.param x_dut_xmpd_l=0.3
.param x_cc=250e-15
.param x_dut_xm1_m=4
.param x_dut_xm2_m=4
.param x_dut_xmrn_m=1
.param x_dut_xmns_m=1
.param x_dut_xmpd_m=1
.param x_dut_xmpb_m=6
* ---- GENERATED parameter ties (abstract/params.yaml groups/ratios) ----
* Each tied symbol is defined exactly once, by its line below; rewrite that
* .param to untie just that symbol (untying = shadowing, plan D-3).
.param x_dut_xm2_l = {x_dut_xm1_l}
.param x_dut_xmrn_l = {x_dut_xm1_l}
.param x_dut_xmns_l = {x_dut_xm1_l}
.param x_dut_xmns_w = {x_dut_xmrn_w}
.param x_dut_xmpb_l = {x_dut_xmpd_l}
.subckt buf_001_super_follower vdd vout vin ibias vss
CC na vss x_cc
XM1 na vin vout vss sky130_fd_pr__nfet_01v8 l=x_dut_xm1_l m=x_dut_xm1_m w=x_dut_xm1_w
XM2 vout na vss vss sky130_fd_pr__nfet_01v8 l=x_dut_xm2_l m=x_dut_xm2_m w=x_dut_xm2_w
XMNS pd ibias vss vss sky130_fd_pr__nfet_01v8 l=x_dut_xmns_l m=x_dut_xmns_m w=x_dut_xmns_w
XMPB na pd vdd vdd sky130_fd_pr__pfet_01v8 l=x_dut_xmpb_l m=x_dut_xmpb_m w=x_dut_xmpb_w
XMPD pd pd vdd vdd sky130_fd_pr__pfet_01v8 l=x_dut_xmpd_l m=x_dut_xmpd_m w=x_dut_xmpd_w
XMRN ibias ibias vss vss sky130_fd_pr__nfet_01v8 l=x_dut_xmrn_l m=x_dut_xmrn_m w=x_dut_xmrn_w
.ends
