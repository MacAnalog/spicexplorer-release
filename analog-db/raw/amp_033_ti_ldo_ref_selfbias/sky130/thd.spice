** GENERATED by `analog-db export-raw` — DO NOT EDIT.
** circuit=amp_033_ti_ldo_ref_selfbias  class=amplifier  pdk=sky130  testbench=thd  corner=tt
** Self-contained deck: testbench + bound params + lowered DUT (.subckt amp_033_ti_ldo_ref_selfbias).
** PDK corner libs resolve by BARE NAME on the image's ngspice sourcepath — run in a
** PDK-enabled env (the base image / api container), NOT a bare host:
**   docker run --rm -i spicexplorer-spice-base:local \
**     bash -lc 'd=$(mktemp -d) && cat > $d/c.spice && cd $d && ngspice -b c.spice' < raw/amp_033_ti_ldo_ref_selfbias/sky130/thd.spice
*----------------------------------------------------------*
** params: 16 free + 0 frozen knobs (sizing.yaml) · 6 tied · 0 ratio-derived (abstract/params.yaml) · 4 testbench params
** AUTHORED TEMPLATE — amplifier/thd_selfbias (2026-08-01): large-signal harmonic distortion in
** the unity buffer for SELF-BIASED DUTs (no ibias port — the TI-LDO error amps amp_032/033).
** Identical to `thd` except there is no external bias source — derived exactly as
** psrr_vdd_selfbias derives from psrr_vdd (drop `.param IBIAS` and the `Ibias` line), so a
** 5-port [vdd vout vinp vinn vss] DUT does not leave a current source driving a dangling
** `ibias` node (which makes the DC solve singular). The unity-buffer DC op point is the same
** one ac_closed_loop_selfbias / linearity_selfbias already prove out for these DUTs, so
** biasing is safe. EVERYTHING measurement-side is grafted from thd.spice UNCHANGED — that
** header carries the full audited story and is the reference for any future edit here; the
** load-bearing invariants it establishes (do not relax ANY of them):
**   * COHERENT WINDOW: (TSTOP-TSTART) MUST be an integer number of F0 periods — a half-period
**     mismatch inflates thd_pct up to 63x (measured). TSTART discards the startup transient
**     and need not land on a period boundary. >= 8 measured periods, TSTEP <= 1/(200*F0).
**   * ENDPOINT-DUPLICATION CORRECTION: `linearize` returns np = nd+1 points whose last sample
**     repeats the first; every bin is therefore taken as
**         re_k = (mean(vac*c_k)*np - vac[0]*c_k[0])/nd
**     Without it the window phase alone swings thd 2.95x and a3 41x (measured on amp_022@ihp).
**     a4/a5 are the tell-tale: if either creeps up to 2*|vac[0]|/np the correction is broken.
**   * `write` BEFORE `linearize`: linearize swaps the current plot for its interpolated
**     scratch copy, so a trailing write guts the raw from every circuit node to the DFT
**     leftovers and breaks the platform {meas: thd_pct} cross-check on the raw.
**   * DEAD-OUTPUT GUARD: a MEASURED tone gain (a1 over the same bin taken on the drive
**     v(vinp)), threshold 0.5 = the |A| = 1 line of gain_tone = A/(1+A). On a fail thd_pct
**     becomes the loud 999 sentinel — bad-direction for a minimize metric, and NOT NaN (a NaN
**     makes the runner discard the whole analysis). It is a SCREEN, not a proof.
**   * No `>` inside a `let` — the .control preprocessor strips it as an output redirection
**     and silently truncates the RHS; masks use `<=` and 1 - mask.
**   * Measure names match the ibias sibling EXACTLY (thd_pct, thd_db, a1..a5, a1_in,
**     gain_tone, vout_op) so datasheet wiring stays uniform across template variants; none is
**     in raw_project._SPEC_REGISTRY (deliberately: `vout_op` not `vout_dc`, `gain_tone` not
**     `gain_cl` — the alternatives ARE registry names and would silently add objectives).
** Bindings: DUT PORT_LINE VDD VCM CL ASIG F0 TSTEP TSTART TSTOP PDK_INCLUDE.
.lib sky130.lib.spice tt
.temp 27

.param VDD=1.8
.param VCM=0.9
.param CL=10p
.param ASIG=0.1

Vdd  vdd 0 dc {VDD}
Vss  vss 0 dc 0
CLoad vout 0 {CL}

* unity buffer; the sine offset VCM doubles as the DC operating point
Vinp vinp 0 sin({VCM} {ASIG} 0.1e6)
Vfb  vinn vout dc 0

XDUT vdd vout vinp vinn vss amp_033_ti_ldo_ref_selfbias

.control
  set filetype=ascii
  tran 20n 200u 40u
  * raw first — see the header; linearize below switches the current plot
  write
  let vo = v(vout)
  let vi = v(vinp)
  linearize vo vi
  let t = time
* --- endpoint-duplication correction (see the header): `linearize` hands back np = nd+1
* --- points whose last sample repeats the first, so mean() averages one sample too many.
* --- mean()*np recovers the sum, subtracting vac[0]*c_k[0] drops the duplicate, /nd gives
* --- the true rectangular-window average over one whole number of periods.
  let np = length(vo)
  let nd = np - 1
  let vout_op = (mean(vo)*np - vo[0])/nd
  * the pedestal subtraction is exactly cancelled by the correction above (measured
  * bit-identical); kept because vout_op is reported anyway and `vac` reads clearer
  let vac = vo - vout_op
  let vin_ac = vi - mean(vi)
  let w = 2*pi*0.1e6
  let c1 = cos(w*t)
  let s1 = sin(w*t)
  let re1 = (mean(vac*c1)*np - vac[0]*c1[0])/nd
  let im1 = (mean(vac*s1)*np - vac[0]*s1[0])/nd
  let a1 = 2*sqrt(re1^2+im1^2)
* --- the SAME bin taken on the DRIVE v(vinp) — the reference for the dead-output guard ---
  let rei = (mean(vin_ac*c1)*np - vin_ac[0]*c1[0])/nd
  let imi = (mean(vin_ac*s1)*np - vin_ac[0]*s1[0])/nd
  let a1_in = 2*sqrt(rei^2+imi^2)
  let c2 = cos(2*w*t)
  let s2 = sin(2*w*t)
  let re2 = (mean(vac*c2)*np - vac[0]*c2[0])/nd
  let im2 = (mean(vac*s2)*np - vac[0]*s2[0])/nd
  let a2 = 2*sqrt(re2^2+im2^2)
  let c3 = cos(3*w*t)
  let s3 = sin(3*w*t)
  let re3 = (mean(vac*c3)*np - vac[0]*c3[0])/nd
  let im3 = (mean(vac*s3)*np - vac[0]*s3[0])/nd
  let a3 = 2*sqrt(re3^2+im3^2)
  let c4 = cos(4*w*t)
  let s4 = sin(4*w*t)
  let re4 = (mean(vac*c4)*np - vac[0]*c4[0])/nd
  let im4 = (mean(vac*s4)*np - vac[0]*s4[0])/nd
  let a4 = 2*sqrt(re4^2+im4^2)
  let c5 = cos(5*w*t)
  let s5 = sin(5*w*t)
  let re5 = (mean(vac*c5)*np - vac[0]*c5[0])/nd
  let im5 = (mean(vac*s5)*np - vac[0]*s5[0])/nd
  let a5 = 2*sqrt(re5^2+im5^2)
* --- DEAD-OUTPUT GUARD (see the header): a MEASURED gain, not a NaN check. Do NOT write
* --- `>` inside a `let` — the control preprocessor strips it as an output redirection and
* --- silently truncates the RHS. Masks use `<=`, inverted with 1 - mask.
  let gain_tone = a1/(a1_in + 1e-18)
  let dead = (gain_tone <= 0.5)
  let live = 1 - dead
  * the 1e-18 floors keep a dead output (a1 == 0) from emitting inf/NaN, which makes the runner
  * throw away the WHOLE analysis; they sit 12+ decades below any real amplitude
  let thd_raw = 100*sqrt(a2^2+a3^2+a4^2+a5^2)/(a1+1e-18)
  let thd_pct = live*thd_raw + dead*999
  let thd_db = 20*log10(thd_pct/100 + 1e-18)
  print a1 a2 a3 a4 a5 a1_in gain_tone thd_pct thd_db vout_op
  quit
.endc
.param x_dut_xmbp_w=23.71339160604486
.param x_dut_xmbp_l=1.1974442129526897
.param x_dut_xmb0_w=14.316321410441935
.param x_dut_xmb0_l=4.017319560601552
.param x_dut_xmbc_w=26.895472565757352
.param x_dut_xmbc_m=1
.param x_dut_xmbo_w=17.003801287035284
.param x_dut_xmbo_m=1
.param x_dut_xm1_w=13.80211797930676
.param x_dut_xm1_l=0.8298635361175917
.param x_dut_xm3_w=12.154294570182673
.param x_dut_xm3_l=1.159444890985505
.param x_dut_xm5_w=9.903158187330707
.param x_dut_xm5_l=2.949529504310346
.param r_z=49350.31244197376
.param c_comp=5.9836450528951e-12
* ---- GENERATED parameter ties (abstract/params.yaml groups/ratios) ----
* Each tied symbol is defined exactly once, by its line below; rewrite that
* .param to untie just that symbol (untying = shadowing, plan D-3).
.param x_dut_xm4_w = {x_dut_xm3_w}
.param x_dut_xm4_l = {x_dut_xm3_l}
.param x_dut_xm2_w = {x_dut_xm1_w}
.param x_dut_xm2_l = {x_dut_xm1_l}
.param x_dut_xmbc_l = {x_dut_xmb0_l}
.param x_dut_xmbo_l = {x_dut_xmb0_l}
.subckt amp_033_ti_ldo_ref_selfbias vdd vout vinp vinn vss
CC ncz vout 'c_comp'
RZ nb ncz 'r_z'
XM1 na vinn tail vss sky130_fd_pr__nfet_01v8 l=x_dut_xm1_l w=x_dut_xm1_w
XM2 nb vinp tail vss sky130_fd_pr__nfet_01v8 l=x_dut_xm2_l w=x_dut_xm2_w
XM3 na na vdd vdd sky130_fd_pr__pfet_01v8 l=x_dut_xm3_l w=x_dut_xm3_w
XM4 nb na vdd vdd sky130_fd_pr__pfet_01v8 l=x_dut_xm4_l w=x_dut_xm4_w
XM5 vout nb vdd vdd sky130_fd_pr__pfet_01v8 l=x_dut_xm5_l w=x_dut_xm5_w
XMB0 ibias ibias vss vss sky130_fd_pr__nfet_01v8 l=x_dut_xmb0_l w=x_dut_xmb0_w
XMBC tail ibias vss vss sky130_fd_pr__nfet_01v8 l=x_dut_xmbc_l m=x_dut_xmbc_m w=x_dut_xmbc_w
XMBO vout ibias vss vss sky130_fd_pr__nfet_01v8 l=x_dut_xmbo_l m=x_dut_xmbo_m w=x_dut_xmbo_w
XMBP ibias ibias vdd vdd sky130_fd_pr__pfet_01v8 l=x_dut_xmbp_l w=x_dut_xmbp_w
.ends
.end
