** GENERATED by `analog-db export-raw` — DO NOT EDIT.
** circuit=amp_029_two_stage_miller_comp  class=amplifier  pdk=sky130  testbench=psrr_vdd  corner=tt
** Self-contained deck: testbench + bound params + lowered DUT (.subckt amp_029_two_stage_miller_comp).
** PDK corner libs resolve by BARE NAME on the image's ngspice sourcepath — run in a
** PDK-enabled env (the base image / api container), NOT a bare host:
**   docker run --rm -i spicexplorer-spice-base:local \
**     bash -lc 'd=$(mktemp -d) && cat > $d/c.spice && cd $d && ngspice -b c.spice' < raw/amp_029_two_stage_miller_comp/sky130/psrr_vdd.spice
*----------------------------------------------------------*
** params: 14 free + 6 frozen knobs (sizing.yaml) · 16 tied · 0 ratio-derived (abstract/params.yaml) · 3 testbench params
** AUTHORED TEMPLATE — amplifier/psrr_vdd_diff: positive-supply rejection of a fully-
** differential (self-biased, voutp/voutn) DUT, in the same CM-pinned differential
** unity-feedback network stb_diff uses.
**
** CONFIGURATION (see stb_diff.spice for the full why). The differential loop is closed by two
** ideal VCVSs, fbn/fbp = VCM +/- (voutp-voutn)/2, feeding the inputs through quiet 0 V sources;
** the input CM is pinned at VCM and the DC operating point is the matched-inputs-at-VCM point
** of dc_op_diff/ac_open_loop_diff. No CM loop is closed by the bench — the output CM is left to
** the DUT's own CMFB; small-signal, so it works regardless of CMFB quality.
**
** STIMULUS + MATH (the exact FD analog of psrr_vdd.spice). The supply Vdd carries a 1 V AC
** ripple and every input is AC-quiet, so all AC at the output is supply feed-through. With
** A_vd = the supply -> differential-output gain and the loop holding vin_d = -vout_d:
**     vout_d = A_vd*vac + Add*vin_d  =>  vout_d = A_vd/(1+Add) * vac,
** the closed-loop (buffer-application) differential supply feed-through, so
** psrr_vdd_db = -20*log10|vout_d| (vac = 1), read at FSTART (the DC-band floor) — the same
** loop-suppressed figure the SE bench reports for the unity buffer.
**
** SOLVER-RESOLUTION CEILING (why the 1e-15 floor exists — same argument as cmrr_vcm_diff, in
** full there). On a perfectly symmetric netlist the supply disturbs both half-circuits
** identically, the TRUE A_vd of the deck is zero, and the solved vout_d is matrix round-off
** (~1e-16 of the ~1 V node signals). The `+ 1e-15` magnitude floor caps the reportable figure
** at 300 dB and keeps -db() finite; a psrr_vdd_db at or near 300 means "beyond what the solver
** can resolve on a symmetric netlist", NOT a physical rejection (real PSRR- and PSRR+ of FD
** silicon are mismatch-set). Treat anything above ~200 dB as unresolved-by-construction.
**
** psrr_cm_db — the SECONDARY, always-physical figure. The OUTPUT-CM response to the same
** ripple, vocm = (voutp+voutn)/2, psrr_cm_db = -db|vocm|: the supply rejection of the cell's
** CM path (CMFB loop included). It is finite even on a perfect netlist — supply ripple feeds
** the CM of both branches with the same sign, nothing cancels — so it is the number that
** actually discriminates between FD cells whose differential figure saturates the solver.
** (Not a canonical datasheet metric; it rides the scoreboard entry's analyses block.)
**
** DIFFERENTIAL-GAIN CORRECTION (downstream, scoreboard.record). psrr_cm_db here is the RAW CM
** supply residual -db|vocm|, NOT yet a rejection FIGURE. PSRR is (differential gain)/(supply
** gain), so the physical FD PSRR+ adds the differential open-loop gain back:
** psrr_cm_corr_db = dc_gain_db + psrr_cm_db (the SE unity-buffer psrr_vdd_db folds this in via
** its closed loop; the FD CM path does not, so the term is added when the scoreboard entry is
** assembled). psrr_cm_corr_db is the figure the paper prints.
**
** Bindings: DUT PORT_LINE VDD VCM CL FSTART FSTOP PPD PDK_INCLUDE.
.lib sky130.lib.spice tt
.temp 27

.param VDD=1.8
.param VCM=0.9
.param CL=10p

Vdd  vdd 0 dc {VDD} ac 1     ; 1 V supply-ripple stimulus
Vss  vss 0 dc 0
CLoadp voutp 0 {CL}
CLoadn voutn 0 {CL}

* differential unity feedback, CM pinned at VCM (see stb_diff.spice); inputs AC-quiet —
* isolate the supply path
Vcm  vcm 0 dc {VCM}
Efbn fbn vcm voutp voutn 0.5
Efbp fbp vcm voutp voutn -0.5
Vfbn vinn fbn dc 0
Vfbp vinp fbp dc 0

XDUT vinp vinn voutp voutn vdd vss amp_029_two_stage_miller_comp

.control
  set filetype=ascii
  ac dec 101 1k 1G
  let vodm = v(voutp) - v(voutn)
  let vocm = (v(voutp) + v(voutn))/2
  * 1e-15 magnitude floor: caps the figure at 300 dB = "beyond solver resolution" (see header);
  * also keeps -db() finite on a bit-symmetric netlist whose true response is exactly 0.
  let psrr   = -db(mag(vodm) + 1e-15)
  let psrrcm = -db(mag(vocm) + 1e-15)
  meas ac psrr_vdd_db FIND psrr   AT=1k
  meas ac psrr_cm_db  FIND psrrcm AT=1k
  write
  quit
.endc
.param x_dut_xm1_w=10
.param x_dut_xm1_l=0.5
.param x_dut_xm3_w=10
.param x_dut_xm3_l=1
.param x_dut_xm5_w=12
.param x_dut_xm5_l=0.5
.param x_dut_xm6_w=2
.param x_dut_xm6_l=1
.param x_dut_xm7_w=6
.param x_dut_xm8_w=2
.param x_dut_r1_value=30k
.param x_dut_c1_value=0.6p
.param i_bias=20u
.param vbl=0.64753
.param x_dut_xm1_m=1
.param x_dut_xm3_m=1
.param x_dut_xm5_m=1
.param x_dut_xm6_m=1
.param x_dut_xm7_m=1
.param x_dut_xm8_m=1
* ---- GENERATED parameter ties (abstract/params.yaml groups/ratios) ----
* Each tied symbol is defined exactly once, by its line below; rewrite that
* .param to untie just that symbol (untying = shadowing, plan D-3).
.param x_dut_xm10_l = {x_dut_xm6_l}
.param x_dut_xm7_l = {x_dut_xm6_l}
.param x_dut_xm8_l = {x_dut_xm6_l}
.param x_dut_xm2_w = {x_dut_xm1_w}
.param x_dut_xm2_l = {x_dut_xm1_l}
.param x_dut_xm2_m = {x_dut_xm1_m}
.param x_dut_xm4_w = {x_dut_xm3_w}
.param x_dut_xm4_l = {x_dut_xm3_l}
.param x_dut_xm4_m = {x_dut_xm3_m}
.param x_dut_xm9_w = {x_dut_xm5_w}
.param x_dut_xm9_l = {x_dut_xm5_l}
.param x_dut_xm9_m = {x_dut_xm5_m}
.param x_dut_xm10_w = {x_dut_xm7_w}
.param x_dut_xm10_m = {x_dut_xm7_m}
.param x_dut_r2_value = {x_dut_r1_value}
.param x_dut_c2_value = {x_dut_c1_value}
.subckt amp_029_two_stage_miller_comp vinp vinn voutp voutn vdd vss
C1 mill_p voutp 'x_dut_c1_value'
C2 mill_n voutn 'x_dut_c2_value'
IBIAS vdd ref dc {i_bias}
R1 stg1p mill_p 'x_dut_r1_value'
R2 stg1n mill_n 'x_dut_r2_value'
VBL vbl vss dc {vbl}
XM1 stg1p vinp tail vss sky130_fd_pr__nfet_01v8 l=x_dut_xm1_l m=x_dut_xm1_m w=x_dut_xm1_w
XM10 voutn ref vss vss sky130_fd_pr__nfet_01v8 l=x_dut_xm10_l m=x_dut_xm10_m w=x_dut_xm10_w
XM2 stg1n vinn tail vss sky130_fd_pr__nfet_01v8 l=x_dut_xm2_l m=x_dut_xm2_m w=x_dut_xm2_w
XM3 stg1p vbl vdd vdd sky130_fd_pr__pfet_01v8 l=x_dut_xm3_l m=x_dut_xm3_m w=x_dut_xm3_w
XM4 stg1n vbl vdd vdd sky130_fd_pr__pfet_01v8 l=x_dut_xm4_l m=x_dut_xm4_m w=x_dut_xm4_w
XM5 voutp stg1p vdd vdd sky130_fd_pr__pfet_01v8 l=x_dut_xm5_l m=x_dut_xm5_m w=x_dut_xm5_w
XM6 ref ref vss vss sky130_fd_pr__nfet_01v8 l=x_dut_xm6_l m=x_dut_xm6_m w=x_dut_xm6_w
XM7 voutp ref vss vss sky130_fd_pr__nfet_01v8 l=x_dut_xm7_l m=x_dut_xm7_m w=x_dut_xm7_w
XM8 tail ref vss vss sky130_fd_pr__nfet_01v8 l=x_dut_xm8_l m=x_dut_xm8_m w=x_dut_xm8_w
XM9 voutn stg1n vdd vdd sky130_fd_pr__pfet_01v8 l=x_dut_xm9_l m=x_dut_xm9_m w=x_dut_xm9_w
.ends
.end
