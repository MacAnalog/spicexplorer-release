** GENERATED by `analog-db export-raw` — DO NOT EDIT.
** Standalone lowered DUT subckt for cmp_002_strongarm on gf180mcu (sizing .param defaults + .subckt).
** Not a runnable deck on its own — include it under your own testbench:
**   .include _dut.spice
**   XDUT vdd voutp voutn vinp vinn clk vss cmp_002_strongarm
** Source: pdk/gf180mcu/netlist.spice (run `analog-db generate` to refresh).
*----------------------------------------------------------*
** params: 7 free + 15 frozen knobs (sizing.yaml) · 23 tied · 0 ratio-derived (abstract/params.yaml)
.param x_dut_xmtail_w=4u
.param x_dut_xminn_w=8u
.param x_dut_xmlem_w=4u
.param x_dut_xmpc1_w=2u
.param x_dut_xmobn1_w=1.5u
.param x_dut_xmobp1_w=3u
.param x_dut_xmtail_l=0.28u
.param x_dut_xmtail_m=1
.param x_dut_xminn_m=2
.param x_dut_xminp_m=2
.param x_dut_xmlem_m=1
.param x_dut_xmlep_m=1
.param x_dut_xmlum_m=1
.param x_dut_xmlup_m=1
.param x_dut_xmpc1_m=1
.param x_dut_xmpc2_m=1
.param x_dut_xmpc3_m=1
.param x_dut_xmpc4_m=1
.param x_dut_xmobn1_m=1
.param x_dut_xmobp1_m=1
.param x_dut_xmobn2_m=1
.param x_dut_xmobp2_m=1
* ---- GENERATED parameter ties (abstract/params.yaml groups/ratios) ----
* Each tied symbol is defined exactly once, by its line below; rewrite that
* .param to untie just that symbol (untying = shadowing, plan D-3).
.param x_dut_xminn_l = {x_dut_xmtail_l}
.param x_dut_xminp_l = {x_dut_xmtail_l}
.param x_dut_xmlem_l = {x_dut_xmtail_l}
.param x_dut_xmlep_l = {x_dut_xmtail_l}
.param x_dut_xmlum_l = {x_dut_xmtail_l}
.param x_dut_xmlup_l = {x_dut_xmtail_l}
.param x_dut_xmpc1_l = {x_dut_xmtail_l}
.param x_dut_xmpc2_l = {x_dut_xmtail_l}
.param x_dut_xmpc3_l = {x_dut_xmtail_l}
.param x_dut_xmpc4_l = {x_dut_xmtail_l}
.param x_dut_xmobn1_l = {x_dut_xmtail_l}
.param x_dut_xmobp1_l = {x_dut_xmtail_l}
.param x_dut_xmobn2_l = {x_dut_xmtail_l}
.param x_dut_xmobp2_l = {x_dut_xmtail_l}
.param x_dut_xminp_w = {x_dut_xminn_w}
.param x_dut_xmlep_w = {x_dut_xmlem_w}
.param x_dut_xmlum_w = {x_dut_xmlem_w}
.param x_dut_xmlup_w = {x_dut_xmlem_w}
.param x_dut_xmpc2_w = {x_dut_xmpc1_w}
.param x_dut_xmpc3_w = {x_dut_xmpc1_w}
.param x_dut_xmpc4_w = {x_dut_xmpc1_w}
.param x_dut_xmobn2_w = {x_dut_xmobn1_w}
.param x_dut_xmobp2_w = {x_dut_xmobp1_w}
.subckt cmp_002_strongarm vdd voutp voutn vinp vinn clk vss
XMINN sp vinn tail vss nfet_03v3 l=x_dut_xminn_l m=x_dut_xminn_m w=x_dut_xminn_w
XMINP sn vinp tail vss nfet_03v3 l=x_dut_xminp_l m=x_dut_xminp_m w=x_dut_xminp_w
XMLEM lm lp sn vss nfet_03v3 l=x_dut_xmlem_l m=x_dut_xmlem_m w=x_dut_xmlem_w
XMLEP lp lm sp vss nfet_03v3 l=x_dut_xmlep_l m=x_dut_xmlep_m w=x_dut_xmlep_w
XMLUM lm lp vdd vdd pfet_03v3 l=x_dut_xmlum_l m=x_dut_xmlum_m w=x_dut_xmlum_w
XMLUP lp lm vdd vdd pfet_03v3 l=x_dut_xmlup_l m=x_dut_xmlup_m w=x_dut_xmlup_w
XMOBN1 voutp lm vss vss nfet_03v3 l=x_dut_xmobn1_l m=x_dut_xmobn1_m w=x_dut_xmobn1_w
XMOBN2 voutn lp vss vss nfet_03v3 l=x_dut_xmobn2_l m=x_dut_xmobn2_m w=x_dut_xmobn2_w
XMOBP1 voutp lm vdd vdd pfet_03v3 l=x_dut_xmobp1_l m=x_dut_xmobp1_m w=x_dut_xmobp1_w
XMOBP2 voutn lp vdd vdd pfet_03v3 l=x_dut_xmobp2_l m=x_dut_xmobp2_m w=x_dut_xmobp2_w
XMPC1 sp clk vdd vdd pfet_03v3 l=x_dut_xmpc1_l m=x_dut_xmpc1_m w=x_dut_xmpc1_w
XMPC2 sn clk vdd vdd pfet_03v3 l=x_dut_xmpc2_l m=x_dut_xmpc2_m w=x_dut_xmpc2_w
XMPC3 lp clk vdd vdd pfet_03v3 l=x_dut_xmpc3_l m=x_dut_xmpc3_m w=x_dut_xmpc3_w
XMPC4 lm clk vdd vdd pfet_03v3 l=x_dut_xmpc4_l m=x_dut_xmpc4_m w=x_dut_xmpc4_w
XMTAIL tail clk vss vss nfet_03v3 l=x_dut_xmtail_l m=x_dut_xmtail_m w=x_dut_xmtail_w
.ends
