** GENERATED by `analog-db export-raw` — DO NOT EDIT.
** circuit=amp_004_folded_cascode  class=amplifier  pdk=gf180mcu  testbench=ac_open_loop  corner=tt
** Self-contained deck: testbench + bound params + lowered DUT (.subckt amp_004_folded_cascode).
** PDK corner libs resolve by BARE NAME on the image's ngspice sourcepath — run in a
** PDK-enabled env (the base image / api container), NOT a bare host:
**   docker run --rm -i spicexplorer-spice-base:local \
**     bash -lc 'd=$(mktemp -d) && cat > $d/c.spice && cd $d && ngspice -b c.spice' < raw/amp_004_folded_cascode/gf180mcu/ac_open_loop.spice
*----------------------------------------------------------*
** params: 16 free + 21 frozen knobs (sizing.yaml) · 21 tied · 0 ratio-derived (abstract/params.yaml) · 4 testbench params
** AUTHORED TEMPLATE — amplifier/ac_open_loop (plan D-4).
** Open-loop AC gain/phase of an OTA. Placeholders are bound by the analysis resolver
** (assemble.py) from analyses/<id>.yaml params + datasheet default_conditions.
** Flag `bias_wrap` (AnalogGym trick): close the DC loop with a huge Lfb/Cin so the DUT
** self-biases, while the AC path stays open. Without the flag the inputs are driven directly.
**
** Required bindings: DUT (subckt name), PORT_LINE (instance port order),
**   VDD VCM IBIAS CL, FSTART FSTOP PPD (points/decade),
**   PDK_INCLUDE (.lib/.include lines for the bound PDK+corner).
*----------------------------------------------------------*
.include design.ngspice
.lib sm141064.ngspice noise_corner
.lib sm141064.ngspice nfet_03v3_t
.lib sm141064.ngspice pfet_03v3_t
.lib sm141064.ngspice fets_mm
.temp 27

.param VDD=1.8
.param VCM=0.9
.param IBIAS=-34u
.param CL=5p

Vdd  vdd 0 dc {VDD}
Vss  vss 0 dc 0
Ibias vdd ibias dc {IBIAS}
CLoad vout 0 {CL}

* DUT instance (port order = circuit.yaml ports)
XDUT vinn vinp vout vdd ibias vss amp_004_folded_cascode

* --- input drive (AC open loop) ---
Vcm  vcm 0 dc {VCM}
Vinp vinp vcm dc 0 ac 0.5
Vinn vinn vcm dc 0 ac -0.5

.control
  set filetype=ascii
  ac dec 101 1 10G
  meas ac dcgain  FIND vdb(vout) AT=1
  meas ac ugf     WHEN vdb(vout)=0 FALL=1
  * cph() = continuous (unwrapped) phase — vp() wraps at +/-180 and corrupts PM for
  * multi-pole phase trajectories; normalize to the DC phase so PM = 180 - total phase lag.
  * NOTE: this DIRECT open-loop PM is reliable for dominant-pole single-stage OTAs (5t,
  * folded-cascode). For a telescopic cascode the differential→single-ended mirror path adds
  * excess phase that makes direct-drive PM ill-defined — accurate PM/stability there needs a
  * dedicated loop-gain probe (the legacy tb-loopgain testbench / a future ac_loopgain template).
  let phc = cph(vout)*180/3.14159265
  let ph = 180 + phc - phc[0]
  meas ac pm      FIND ph WHEN vdb(vout)=0 FALL=1
  write
  quit
.endc
.param x_dut_xm1_w=72u
.param x_dut_xm1_l=2u
.param x_dut_xm13_w=106.5u
.param x_dut_xm13_l=2u
.param x_dut_xm6_w=44u
.param x_dut_xm6_l=2.5u
.param x_dut_xm7_w=78u
.param x_dut_xm7_l=2u
.param x_dut_xm9_w=183u
.param x_dut_xm9_l=4.5u
.param x_dut_xm11_w=50u
.param x_dut_xm11_l=3u
.param x_dut_xm12_w=50u
.param x_dut_xm12_l=3u
.param x_dut_vb1=1.225
.param x_dut_vb2=1.275
.param x_dut_xm1_ng=8
.param x_dut_xm13_ng=11
.param x_dut_xm6_ng=5
.param x_dut_xm7_ng=8
.param x_dut_xm9_ng=19
.param x_dut_xm11_ng=5
.param x_dut_xm12_ng=5
.param x_dut_xm4_m=1
.param x_dut_xm1_m=1
.param x_dut_xm2_m=1
.param x_dut_xm3_m=1
.param x_dut_xm11_m=1
.param x_dut_xm0_m=1
.param x_dut_xm6_m=1
.param x_dut_xm5_m=1
.param x_dut_xm7_m=1
.param x_dut_xm8_m=1
.param x_dut_xm9_m=1
.param x_dut_xm10_m=1
.param x_dut_xm12_m=1
.param x_dut_xm13_m=1
* ---- GENERATED parameter ties (abstract/params.yaml groups/ratios) ----
* Each tied symbol is defined exactly once, by its line below; rewrite that
* .param to untie just that symbol (untying = shadowing, plan D-3).
.param x_dut_xm4_w = {x_dut_xm13_w}
.param x_dut_xm3_w = {x_dut_xm13_w}
.param x_dut_xm4_l = {x_dut_xm13_l}
.param x_dut_xm3_l = {x_dut_xm13_l}
.param x_dut_xm4_ng = {x_dut_xm13_ng}
.param x_dut_xm3_ng = {x_dut_xm13_ng}
.param x_dut_xm2_w = {x_dut_xm1_w}
.param x_dut_xm2_l = {x_dut_xm1_l}
.param x_dut_xm2_ng = {x_dut_xm1_ng}
.param x_dut_xm0_w = {x_dut_xm11_w}
.param x_dut_xm0_l = {x_dut_xm11_l}
.param x_dut_xm0_ng = {x_dut_xm11_ng}
.param x_dut_xm5_w = {x_dut_xm6_w}
.param x_dut_xm5_l = {x_dut_xm6_l}
.param x_dut_xm5_ng = {x_dut_xm6_ng}
.param x_dut_xm8_w = {x_dut_xm7_w}
.param x_dut_xm8_l = {x_dut_xm7_l}
.param x_dut_xm8_ng = {x_dut_xm7_ng}
.param x_dut_xm10_w = {x_dut_xm9_w}
.param x_dut_xm10_l = {x_dut_xm9_l}
.param x_dut_xm10_ng = {x_dut_xm9_ng}
.subckt amp_004_folded_cascode vinn vinp vout vdd ibias vss
V1 vb1 vss x_dut_vb1
V2 vb2 vss x_dut_vb2
XM0 tail ibias vdd vdd pfet_03v3 l=x_dut_xm0_l m=x_dut_xm0_m nf=x_dut_xm0_ng w=x_dut_xm0_w
XM1 foldp vinp tail vdd pfet_03v3 l=x_dut_xm1_l m=x_dut_xm1_m nf=x_dut_xm1_ng w=x_dut_xm1_w
XM10 s10 cascp vdd vdd pfet_03v3 l=x_dut_xm10_l m=x_dut_xm10_m nf=x_dut_xm10_ng w=x_dut_xm10_w
XM11 ibias ibias vdd vdd pfet_03v3 l=x_dut_xm11_l m=x_dut_xm11_m nf=x_dut_xm11_ng w=x_dut_xm11_w
XM12 nbias ibias vdd vdd pfet_03v3 l=x_dut_xm12_l m=x_dut_xm12_m nf=x_dut_xm12_ng w=x_dut_xm12_w
XM13 nbias nbias vss vss nfet_03v3 l=x_dut_xm13_l m=x_dut_xm13_m nf=x_dut_xm13_ng w=x_dut_xm13_w
XM2 foldn vinn tail vdd pfet_03v3 l=x_dut_xm2_l m=x_dut_xm2_m nf=x_dut_xm2_ng w=x_dut_xm2_w
XM3 foldp nbias vss vss nfet_03v3 l=x_dut_xm3_l m=x_dut_xm3_m nf=x_dut_xm3_ng w=x_dut_xm3_w
XM4 foldn nbias vss vss nfet_03v3 l=x_dut_xm4_l m=x_dut_xm4_m nf=x_dut_xm4_ng w=x_dut_xm4_w
XM5 cascp vb1 foldp vss nfet_03v3 l=x_dut_xm5_l m=x_dut_xm5_m nf=x_dut_xm5_ng w=x_dut_xm5_w
XM6 vout vb1 foldn vss nfet_03v3 l=x_dut_xm6_l m=x_dut_xm6_m nf=x_dut_xm6_ng w=x_dut_xm6_w
XM7 cascp vb2 s9 vdd pfet_03v3 l=x_dut_xm7_l m=x_dut_xm7_m nf=x_dut_xm7_ng w=x_dut_xm7_w
XM8 vout vb2 s10 vdd pfet_03v3 l=x_dut_xm8_l m=x_dut_xm8_m nf=x_dut_xm8_ng w=x_dut_xm8_w
XM9 s9 cascp vdd vdd pfet_03v3 l=x_dut_xm9_l m=x_dut_xm9_m nf=x_dut_xm9_ng w=x_dut_xm9_w
.ends
.end
