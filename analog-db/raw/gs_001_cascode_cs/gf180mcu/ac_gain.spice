** GENERATED by `analog-db export-raw` — DO NOT EDIT.
** circuit=gs_001_cascode_cs  class=gain_stage  pdk=gf180mcu  testbench=ac_gain  corner=tt
** Self-contained deck: testbench + bound params + lowered DUT (.subckt gs_001_cascode_cs).
** PDK corner libs resolve by BARE NAME on the image's ngspice sourcepath — run in a
** PDK-enabled env (the base image / api container), NOT a bare host:
**   docker run --rm -i spicexplorer-spice-base:local \
**     bash -lc 'd=$(mktemp -d) && cat > $d/c.spice && cd $d && ngspice -b c.spice' < raw/gs_001_cascode_cs/gf180mcu/ac_gain.spice
*----------------------------------------------------------*
** params: 10 free + 9 frozen knobs (sizing.yaml) · 8 tied · 0 ratio-derived (abstract/params.yaml) · 3 testbench params
** AUTHORED TEMPLATE — gain_stage/ac_gain: bias-wrapped small-signal AC response.
** The 1 TH inductor DC-shorts vout back to vin — self-biasing the inverting stage at its trip
** point (= the high-gain region, wherever the PDK/corner puts it) — while the 1 TF cap AC-opens
** that loop and injects the stimulus. CL loads the output. Reports the low-frequency gain (dB)
** and the -3 dB bandwidth.
** Class port convention: vdd vout vin ibias vss (ibias sink-referenced, see metrics.yaml).
** Bindings: DUT PORT_LINE VDD IBIAS CL FSTART FSTOP PPD PDK_INCLUDE.
.include design.ngspice
.lib sm141064.ngspice noise_corner
.lib sm141064.ngspice nfet_03v3_t
.lib sm141064.ngspice pfet_03v3_t
.lib sm141064.ngspice fets_mm
.lib sm141064.ngspice res_typical
.lib sm141064.ngspice mimcap_typical
.lib sm141064.ngspice cap_mim
.temp 27

.param VDD=1.5
.param IBIAS=20u
.param CL=200f

Vdd  vdd 0 dc {VDD}
Vss  vss 0 dc 0
Ibias ibias vss dc {IBIAS}
Vac  sigin 0 dc 0 ac 1        ; AC stimulus
Lfb  vout vin 1T              ; 1 TH: DC short (bias), AC open
Cin  vin sigin 1T             ; 1 TF: DC open, AC inject into the input node
CLoad vout 0 {CL}

XDUT vdd vout vin ibias vss gs_001_cascode_cs

.control
  set filetype=ascii
  ac dec 20 100 1G
  meas ac gain_ac_db FIND vdb(vout) AT=100
  let gtarget = gain_ac_db - 3
  meas ac f3db_hz WHEN vdb(vout)=gtarget FALL=1
  write
  quit
.endc
.param x_dut_xmpb1_w=16u
.param x_dut_xmpb1_l=0.5u
.param x_dut_xmpnr_w=0.5u
.param x_dut_xmnb2_w=6u
.param x_dut_xmnb2_l=0.3u
.param x_dut_xmpld_w=10u
.param x_dut_xmpld_l=0.5u
.param x_dut_xmnca_w=4u
.param x_dut_xmnin_w=4u
.param x_dut_xmnca_l=0.3u
.param x_dut_xmpb1_m=1
.param x_dut_xmpb2_m=1
.param x_dut_xmpnr_m=1
.param x_dut_xmnb2_m=1
.param x_dut_xmnb1_m=1
.param x_dut_xmpld_m=1
.param x_dut_xmpca_m=1
.param x_dut_xmnca_m=1
.param x_dut_xmnin_m=1
* ---- GENERATED parameter ties (abstract/params.yaml groups/ratios) ----
* Each tied symbol is defined exactly once, by its line below; rewrite that
* .param to untie just that symbol (untying = shadowing, plan D-3).
.param x_dut_xmpb2_l = {x_dut_xmpb1_l}
.param x_dut_xmpnr_l = {x_dut_xmpb1_l}
.param x_dut_xmpb2_w = {x_dut_xmpb1_w}
.param x_dut_xmnb1_w = {x_dut_xmnb2_w}
.param x_dut_xmnb1_l = {x_dut_xmnb2_l}
.param x_dut_xmpca_w = {x_dut_xmpld_w}
.param x_dut_xmpca_l = {x_dut_xmpld_l}
.param x_dut_xmnin_l = {x_dut_xmnca_l}
.subckt gs_001_cascode_cs vdd vout vin ibias vss
XMNB1 nbias1 nbias1 vss vss nfet_03v3 l=x_dut_xmnb1_l m=x_dut_xmnb1_m w=x_dut_xmnb1_w
XMNB2 nbias2 nbias2 nbias1 vss nfet_03v3 l=x_dut_xmnb2_l m=x_dut_xmnb2_m w=x_dut_xmnb2_w
XMNCA vout nbias2 nint vss nfet_03v3 l=x_dut_xmnca_l m=x_dut_xmnca_m w=x_dut_xmnca_w
XMNIN nint vin vss vss nfet_03v3 l=x_dut_xmnin_l m=x_dut_xmnin_m w=x_dut_xmnin_w
XMPB1 pbias1 pbias1 vdd vdd pfet_03v3 l=x_dut_xmpb1_l m=x_dut_xmpb1_m w=x_dut_xmpb1_w
XMPB2 ibias ibias pbias1 vdd pfet_03v3 l=x_dut_xmpb2_l m=x_dut_xmpb2_m w=x_dut_xmpb2_w
XMPCA vout ibias pint vdd pfet_03v3 l=x_dut_xmpca_l m=x_dut_xmpca_m w=x_dut_xmpca_w
XMPLD pint pbias1 vdd vdd pfet_03v3 l=x_dut_xmpld_l m=x_dut_xmpld_m w=x_dut_xmpld_w
XMPNR nbias2 ibias vdd vdd pfet_03v3 l=x_dut_xmpnr_l m=x_dut_xmpnr_m w=x_dut_xmpnr_w
.ends
.end
