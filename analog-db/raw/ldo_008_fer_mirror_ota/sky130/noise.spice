** GENERATED by `analog-db export-raw` — DO NOT EDIT.
** circuit=ldo_008_fer_mirror_ota  class=ldo  pdk=sky130  testbench=noise  corner=tt
** Self-contained deck: testbench + bound params + lowered DUT (.subckt ldo_008_fer_mirror_ota).
** PDK corner libs resolve by BARE NAME on the image's ngspice sourcepath — run in a
** PDK-enabled env (the base image / api container), NOT a bare host:
**   docker run --rm -i spicexplorer-spice-base:local \
**     bash -lc 'd=$(mktemp -d) && cat > $d/c.spice && cd $d && ngspice -b c.spice' < raw/ldo_008_fer_mirror_ota/sky130/noise.spice
*----------------------------------------------------------*
** params: 11 free + 9 frozen knobs (sizing.yaml) · 7 tied · 0 ratio-derived (abstract/params.yaml) · 1 testbench params
** AUTHORED TEMPLATE — ldo/noise: closed-loop output noise, integrated over a band.
** Methodology from the LDO literature benches vendored at circuits/ldo_004_basic_pmos/reference/
** ltspice/Noise_6p38..42.asc (`.noise v(vout)` + integrated output noise). ngspice's `.noise`
** needs an independent source as its "input"; the supply Vdd serves (the DUT's reference is
** internal to the 3-port subckt), so only the OUTPUT-referred noise is meaningful here:
** vn_out_rms = sqrt(onoise_total) over FSTART..FSTOP.
** Bindings: DUT PORT_LINE VDD ILOAD COUT FSTART FSTOP PPD PDK_INCLUDE.
.lib sky130.lib.spice tt
.temp 27

.param VDD=1.8

Vdd  vdd 0 dc {VDD} ac 1
Vss  vss 0 dc 0
Iload vout 0 dc 1m
CLoad vout 0 1u

XDUT vdd vout vss ldo_008_fer_mirror_ota

.control
  set filetype=ascii
  noise v(vout) Vdd dec 10 10 10meg
  let vn_out_rms = sqrt(onoise_total)
  print onoise_total vn_out_rms
  write
  quit
.endc
.param x_dut_xmnb_w=8
.param x_dut_xmnb_l=0.5
.param x_dut_xmdr_w=6
.param x_dut_xmdr_l=0.3
.param x_dut_xmld_w=8
.param x_dut_xmld_l=0.5
.param x_dut_xmp_w=8
.param x_dut_xmp_l=0.2
.param x_rcomp=2000
.param x_ccomp=160e-12
.param x_dut_rt_value=9000
.param x_vref_val=0.6
.param x_ibias_val=20e-6
.param x_dut_xmnb_m=1
.param x_dut_xmnt_m=4
.param x_dut_xmdr_m=4
.param x_dut_xmdf_m=4
.param x_dut_xmld_m=4
.param x_dut_xmlm_m=4
.param x_dut_xmp_m=60
* ---- GENERATED parameter ties (abstract/params.yaml groups/ratios) ----
* Each tied symbol is defined exactly once, by its line below; rewrite that
* .param to untie just that symbol (untying = shadowing, plan D-3).
.param x_dut_xmnt_w = {x_dut_xmnb_w}
.param x_dut_xmnt_l = {x_dut_xmnb_l}
.param x_dut_xmdf_w = {x_dut_xmdr_w}
.param x_dut_xmdf_l = {x_dut_xmdr_l}
.param x_dut_xmlm_w = {x_dut_xmld_w}
.param x_dut_xmlm_l = {x_dut_xmld_l}
.param x_dut_rb_value = {x_dut_rt_value}
.subckt ldo_008_fer_mirror_ota vdd vout vss
CC czero vout x_ccomp
IBI vdd nbias dc {x_ibias_val}
RB fb vss x_dut_rb_value
RC egate czero x_rcomp
RT vout fb x_dut_rt_value
VREF vref vss dc {x_vref_val}
XMDF ldiode fb tail vss sky130_fd_pr__nfet_01v8 l=x_dut_xmdf_l m=x_dut_xmdf_m w=x_dut_xmdf_w
XMDR egate vref tail vss sky130_fd_pr__nfet_01v8 l=x_dut_xmdr_l m=x_dut_xmdr_m w=x_dut_xmdr_w
XMLD ldiode ldiode vdd vdd sky130_fd_pr__pfet_01v8 l=x_dut_xmld_l m=x_dut_xmld_m w=x_dut_xmld_w
XMLM egate ldiode vdd vdd sky130_fd_pr__pfet_01v8 l=x_dut_xmlm_l m=x_dut_xmlm_m w=x_dut_xmlm_w
XMNB nbias nbias vss vss sky130_fd_pr__nfet_01v8 l=x_dut_xmnb_l m=x_dut_xmnb_m w=x_dut_xmnb_w
XMNT tail nbias vss vss sky130_fd_pr__nfet_01v8 l=x_dut_xmnt_l m=x_dut_xmnt_m w=x_dut_xmnt_w
XMP vout egate vdd vdd sky130_fd_pr__pfet_01v8 l=x_dut_xmp_l m=x_dut_xmp_m w=x_dut_xmp_w
.ends
.end
