* amp_001_5t — the schematic DUT for SIMULATION (the pre-layout reference the post-layout
* testbenches `.include`). Same circuit/sizing/pins as ../ota_5t_gf_lvs.spice (the KLayout
* LVS reference), with the primitive `M` cards written as `XM` calls: ngspice's IHP sg13g2
* devices are subcircuits. The layout flow swaps this include for the kpex-extracted
* `dut_postlayout.spice` (same `.subckt ota_5t_gf` header/pin order) per trial.
.subckt ota_5t_gf vdd vout vinp vinn ibias vss
XM1 outm vinp tail vss sg13_lv_nmos w=0.5u l=5u
XM2 vout vinn tail vss sg13_lv_nmos w=0.5u l=5u
XM3 outm outm vdd  vdd sg13_lv_pmos w=1.5u l=5u
XM4 vout outm vdd  vdd sg13_lv_pmos w=1.5u l=5u
XM5 tail ibias vss vss sg13_lv_nmos w=2u l=5u
XM6 ibias ibias vss vss sg13_lv_nmos w=2u l=5u
.ends
