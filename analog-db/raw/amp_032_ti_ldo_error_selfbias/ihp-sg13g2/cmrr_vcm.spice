** GENERATED by `analog-db export-raw` — DO NOT EDIT.
** circuit=amp_032_ti_ldo_error_selfbias  class=amplifier  pdk=ihp-sg13g2  testbench=cmrr_vcm  corner=tt
** Self-contained deck: testbench + bound params + lowered DUT (.subckt amp_032_ti_ldo_error_selfbias).
** PDK corner libs resolve by BARE NAME on the image's ngspice sourcepath — run in a
** PDK-enabled env (the base image / api container), NOT a bare host:
**   docker run --rm -i spicexplorer-spice-base:local \
**     bash -lc 'd=$(mktemp -d) && cat > $d/c.spice && cd $d && ngspice -b c.spice' < raw/amp_032_ti_ldo_error_selfbias/ihp-sg13g2/cmrr_vcm.spice
*----------------------------------------------------------*
** params: 18 free + 0 frozen knobs (sizing.yaml) · 9 tied · 0 ratio-derived (abstract/params.yaml) · 3 testbench params
** AUTHORED TEMPLATE — amplifier/cmrr_vcm_selfbias (plan D-4/D-5): common-mode rejection
** for self-biased DUTs (no ibias port — the AnalogGym amplifiers). Identical to cmrr_vcm
** except there is no external bias source. The DUT is closed in a unity-gain buffer and the
** SAME 1 V AC rides on both inputs (Vinp ac 1, and the vinn–vout short also ac 1, so
** vinn = vout + vac); the differential input is −vout while the common mode moves by a full
** volt, giving vout ≈ (Acm/Ad)·vac = vac/CMRR and CMRR = −vdb(vout). Reported at FSTART.
** The unity-buffer DC op point is the same one the ac_open_loop_biaswrap bench already
** proves out for these DUTs, so biasing is safe.
** Bindings: DUT PORT_LINE VDD VCM CL FSTART FSTOP PPD PDK_INCLUDE.
.lib cornerMOSlv.lib mos_tt
.lib cornerRES.lib res_typ
.lib cornerCAP.lib cap_typ
.temp 27

.param VDD=1.5
.param VCM=0.75
.param CL=10p

Vdd  vdd 0 dc {VDD}          ; supply quiet — isolate the common-mode path
Vss  vss 0 dc 0
CLoad vout 0 {CL}

Vinp vinp 0 dc {VCM} ac 1    ; +1 V AC on the + input ...
Vfb  vinn vout dc 0 ac 1     ; ... and the same +1 V AC lifted onto vinn (unity buffer at DC)

XDUT vdd vout vinp vinn vss amp_032_ti_ldo_error_selfbias

.control
  set filetype=ascii
  ac dec 101 1k 1G
  let cmrr = -vdb(vout)
  meas ac cmrr_db FIND cmrr AT=1k
  write
  quit
.endc
.param x_dut_xmbp_w=5.578670789917222e-06
.param x_dut_xmbp_l=4.652399317553778e-06
.param x_dut_xmb0_w=8.276833786204537e-05
.param x_dut_xmb0_l=3.15070605280647e-06
.param x_dut_xmbc_m=1
.param x_dut_xmbo_m=1
.param x_dut_xm1_w=6.400316047920548e-05
.param x_dut_xm1_l=5.758061070605141e-07
.param x_dut_xm3_w=2.269768753572863e-05
.param x_dut_xm3_l=4.103599384216178e-06
.param x_dut_xm4_w=4.622984258189675e-05
.param x_dut_xm4_l=7.560584329408141e-06
.param x_dut_xm6_w=1.0646593948046076e-05
.param x_dut_xm6_l=1.3958157250351549e-06
.param r_z=35759.18207181488
.param c_comp=5.3161930814325235e-12
.param x_dut_xmbf_w=3.1866222602286976e-06
.param r_nd=9882082.54892156
* ---- GENERATED parameter ties (abstract/params.yaml groups/ratios) ----
* Each tied symbol is defined exactly once, by its line below; rewrite that
* .param to untie just that symbol (untying = shadowing, plan D-3).
.param x_dut_xmbc_l = {x_dut_xmb0_l}
.param x_dut_xmbf_l = {x_dut_xmb0_l}
.param x_dut_xmbo_l = {x_dut_xmb0_l}
.param x_dut_xmbc_w = {x_dut_xmb0_w}
.param x_dut_xmbo_w = {x_dut_xmb0_w}
.param x_dut_xm2_w = {x_dut_xm1_w}
.param x_dut_xm2_l = {x_dut_xm1_l}
.param x_dut_xm5_w = {x_dut_xm3_w}
.param x_dut_xm5_l = {x_dut_xm3_l}
.subckt amp_032_ti_ldo_error_selfbias vdd vout vinp vinn vss
CC ncz vout 'c_comp'
RND na nd 'r_nd'
RZ nb ncz 'r_z'
XM1 na vinn tail vss sg13_lv_nmos l=x_dut_xm1_l w=x_dut_xm1_w
XM2 nb vinp tail vss sg13_lv_nmos l=x_dut_xm2_l w=x_dut_xm2_w
XM3 na nd vdd vdd sg13_lv_pmos l=x_dut_xm3_l w=x_dut_xm3_w
XM4 nlev na nd vdd sg13_lv_pmos l=x_dut_xm4_l w=x_dut_xm4_w
XM5 nb nd vdd vdd sg13_lv_pmos l=x_dut_xm5_l w=x_dut_xm5_w
XM6 vout nb vdd vdd sg13_lv_pmos l=x_dut_xm6_l w=x_dut_xm6_w
XMB0 ibias ibias vss vss sg13_lv_nmos l=x_dut_xmb0_l w=x_dut_xmb0_w
XMBC tail ibias vss vss sg13_lv_nmos l=x_dut_xmbc_l m=x_dut_xmbc_m w=x_dut_xmbc_w
XMBF nlev ibias vss vss sg13_lv_nmos l=x_dut_xmbf_l w=x_dut_xmbf_w
XMBO vout ibias vss vss sg13_lv_nmos l=x_dut_xmbo_l m=x_dut_xmbo_m w=x_dut_xmbo_w
XMBP ibias ibias vdd vdd sg13_lv_pmos l=x_dut_xmbp_l w=x_dut_xmbp_w
.ends
.end
