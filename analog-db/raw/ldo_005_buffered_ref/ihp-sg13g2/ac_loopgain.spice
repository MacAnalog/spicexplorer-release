** GENERATED by `analog-db export-raw` — DO NOT EDIT.
** circuit=ldo_005_buffered_ref  class=ldo  pdk=ihp-sg13g2  testbench=ac_loopgain  corner=tt
** Self-contained deck: testbench + bound params + lowered DUT (.subckt ldo_005_buffered_ref).
** PDK corner libs resolve by BARE NAME on the image's ngspice sourcepath — run in a
** PDK-enabled env (the base image / api container), NOT a bare host:
**   docker run --rm -i spicexplorer-spice-base:local \
**     bash -lc 'd=$(mktemp -d) && cat > $d/c.spice && cd $d && ngspice -b c.spice' < raw/ldo_005_buffered_ref/ihp-sg13g2/ac_loopgain.spice
*----------------------------------------------------------*
** params: 40 free + 0 frozen knobs (sizing.yaml) · 15 tied · 0 ratio-derived (abstract/params.yaml) · 1 testbench params
** AUTHORED TEMPLATE — ldo/ac_loopgain: TRUE regulation-loop gain, phase margin and gain margin
** by Middlebrook voltage injection at an in-DUT loop-break marker.
**
** Why this exists: an LDO's regulation loop is entirely INSIDE the subckt (vout -> error amp ->
** pass gate -> vout), so it cannot be broken from the [vdd, vout, vss] ports. The class's
** `loop_stability` bench measures closed-loop output-impedance peaking (zout_peak_db) as an
** honest proxy, but peaking is a symptom, not a margin — it cannot tell you HOW MUCH phase you
** have, and a critically-damped loop and a 30-degree loop can show similar peaks under different
** loads. This bench gives the real number.
**
** CONTRACT — the DUT must carry a loop-break marker. Put a 0 V source in the feedback path of the
** abstract netlist, between the driving node and the sensing input:
**     Vlp lp_brk vout dc 0        ; and feed the error amp's sense input from lp_brk, not vout
** A 0 V source with no AC spec is an ideal short, so it is INVISIBLE to every other analysis —
** dc_op / load_regulation / psrr / the transients all see the loop closed exactly as before. Only
** this bench turns it into a generator, via `alter`. This mirrors the amplifier class's `stb`
** bench, which uses the same 0 V VIPRB marker convention (there it becomes a Spectre iprobe).
**
** INJECTION POINT: it must sit where the source-side impedance is LOW and the load-side impedance
** is HIGH — vout (driven hard by the pass device and the output cap) into a MOSFET gate satisfies
** that by a wide margin, which is what makes the Middlebrook approximation valid here.
**
** MATH: the marker forces V(lp_brk) - V(vout) = 1 V AC. With G the transfer once around the rest
** of the loop (lp_brk -> error amp -> pass device -> vout):
**     V(vout) = G * V(lp_brk)  and  V(lp_brk) = V(vout) + 1
**  => V(lp_brk) = 1/(1-G),  V(vout) = G/(1-G),  so  T = v(vout)/v(lp_brk) = G  exactly.
** No small-signal approximation is involved in that algebra; the only assumption is the impedance
** condition above.
**
** VALIDATED 2026-07-20 against a known answer: applied to amp_033_ti_ldo_ref_selfbias closed as a
** unity buffer, this method returns 74.9178 dB / 12.083 MHz / 21.05 deg where the independent
** amplifier `ac_open_loop_biaswrap` bench returns 74.9177 dB / 12.112 MHz / 20.997 deg — agreement
** to the frequency-grid resolution. The phase normalisation (180 + phc - phc[0]) is the same
** sign-convention-agnostic form the amplifier open-loop templates use, so an inverting loop
** (phc[0] ~ 180 deg) and a non-inverting one both report the same physical margin.
**
** Bindings: DUT PORT_LINE VDD ILOAD COUT PPD FSTART FSTOP LP_PROBE PDK_INCLUDE.
** LP_PROBE is the marker's instance name inside the DUT (default `vlp`, see assemble.py).
.lib cornerMOShv.lib mos_tt
.lib cornerRES.lib res_typ
.lib cornerCAP.lib cap_typ
.temp 27

.param VDD=3.3

Vdd  vdd 0 dc {VDD}
Vss  vss 0 dc 0
Iload vout 0 dc 1m
CLoad vout 0 1u

XDUT vdd vout vss ldo_005_buffered_ref

.control
  set filetype=ascii
  * turn the in-loop 0 V marker into a 1 V AC generator (it stays a plain short at DC, so the
  * operating point this measurement rides on is the regulated one)
  alter @v.xdut.vlp[acmag] = 1
  ac dec 51 1 1G
  let tloop = v(vout) / v(xdut.lp_brk)
  let tdb  = db(tloop)
  let tphc = cph(tloop)*180/3.14159265
  let tph  = 180 + tphc - tphc[0]
  meas ac loopgain_db FIND tdb AT=1
  meas ac ugf_loop    WHEN tdb=0 FALL=1
  meas ac pm_loop     FIND tph WHEN tdb=0 FALL=1
  * gain margin: attenuation still in hand where the loop phase reaches 0 (i.e. 180 deg of shift
  * from the DC value). NaN when the phase never gets there — an honest "unconditionally stable"
  * rather than a fabricated number.
  meas ac gm_at_180 FIND tdb WHEN tph=0 FALL=1
  let gm_loop_db = 0 - gm_at_180
  print loopgain_db ugf_loop pm_loop gm_loop_db
  write
  quit
.endc
.param x_dut_xmra_bp_w=5u
.param x_dut_xmra_bp_l=2u
.param x_dut_xmra_b0_w=12u
.param x_dut_xmra_b0_l=2u
.param x_dut_xmra_bc_w=8.316u
.param x_dut_xmra_bo_w=4u
.param x_dut_xmra_1_w=86.42u
.param x_dut_xmra_1_l=0.7u
.param x_dut_xmra_3_w=20u
.param x_dut_xmra_3_l=1u
.param x_dut_xmra_5_w=37.76u
.param x_dut_xmra_5_l=2.646u
.param r_ra_z=30.853k
.param c_ra_comp=4.508p
.param x_dut_xmea_bp_w=8u
.param x_dut_xmea_bp_l=2u
.param x_dut_xmea_b0_w=50u
.param x_dut_xmea_b0_l=2u
.param x_dut_xmea_bf_w=5u
.param x_dut_xmea_1_w=68.542u
.param x_dut_xmea_1_l=0.45u
.param x_dut_xmea_3_w=30u
.param x_dut_xmea_3_l=0.45u
.param x_dut_xmea_4_w=10u
.param x_dut_xmea_4_l=0.5u
.param x_dut_xmea_6_w=8u
.param x_dut_xmea_6_l=0.45u
.param r_ea_z=1k
.param r_ea_nd=500k
.param c_ea_comp=0.2p
.param vref_val=0.8
.param r_ref_top=100k
.param r_ref_bot=100k
.param r_lpf=200k
.param c_lpf=10n
.param x_dut_xmp_w=20u
.param x_dut_xmp_m=4
.param x_dut_xmp_l=0.45u
.param r_bleed=10k
.param c_out_int=10p
* ---- GENERATED parameter ties (abstract/params.yaml groups/ratios) ----
* Each tied symbol is defined exactly once, by its line below; rewrite that
* .param to untie just that symbol (untying = shadowing, plan D-3).
.param x_dut_xmra_bc_l = {x_dut_xmra_b0_l}
.param x_dut_xmra_bo_l = {x_dut_xmra_b0_l}
.param x_dut_xmra_2_w = {x_dut_xmra_1_w}
.param x_dut_xmra_2_l = {x_dut_xmra_1_l}
.param x_dut_xmra_4_w = {x_dut_xmra_3_w}
.param x_dut_xmra_4_l = {x_dut_xmra_3_l}
.param x_dut_xmea_bc_l = {x_dut_xmea_b0_l}
.param x_dut_xmea_bf_l = {x_dut_xmea_b0_l}
.param x_dut_xmea_bo_l = {x_dut_xmea_b0_l}
.param x_dut_xmea_bc_w = {x_dut_xmea_b0_w}
.param x_dut_xmea_bo_w = {x_dut_xmea_b0_w}
.param x_dut_xmea_2_w = {x_dut_xmea_1_w}
.param x_dut_xmea_2_l = {x_dut_xmea_1_l}
.param x_dut_xmea_5_w = {x_dut_xmea_3_w}
.param x_dut_xmea_5_l = {x_dut_xmea_3_l}
.subckt ldo_005_buffered_ref vdd vout vss
C1 vout vss 'c_out_int'
CEAC ea_ncz ea_out 'c_ea_comp'
CRAC ra_ncz v_ref_out 'c_ra_comp'
C_LPF v_lpf_out vss 'c_lpf'
R1 v_ref_out v_ref_fb 'r_ref_top'
R2 v_ref_fb vss 'r_ref_bot'
R3 vout vss 'r_bleed'
REAND ea_na ea_nd 'r_ea_nd'
REAZ ea_nb ea_ncz 'r_ea_z'
RRAZ ra_nb ra_ncz 'r_ra_z'
R_LPF v_ref_out v_lpf_out 'r_lpf'
VLP lp_brk vout dc 0
VREF vref vss dc {vref_val}
XMEA_1 ea_na v_lpf_out ea_tail vss sg13_hv_nmos l=x_dut_xmea_1_l w=x_dut_xmea_1_w
XMEA_2 ea_nb lp_brk ea_tail vss sg13_hv_nmos l=x_dut_xmea_2_l w=x_dut_xmea_2_w
XMEA_3 ea_na ea_nd vdd vdd sg13_hv_pmos l=x_dut_xmea_3_l w=x_dut_xmea_3_w
XMEA_4 ea_nlev ea_na ea_nd vdd sg13_hv_pmos l=x_dut_xmea_4_l w=x_dut_xmea_4_w
XMEA_5 ea_nb ea_nd vdd vdd sg13_hv_pmos l=x_dut_xmea_5_l w=x_dut_xmea_5_w
XMEA_6 ea_out ea_nb vdd vdd sg13_hv_pmos l=x_dut_xmea_6_l w=x_dut_xmea_6_w
XMEA_B0 ea_ibias ea_ibias vss vss sg13_hv_nmos l=x_dut_xmea_b0_l w=x_dut_xmea_b0_w
XMEA_BC ea_tail ea_ibias vss vss sg13_hv_nmos l=x_dut_xmea_bc_l w=x_dut_xmea_bc_w
XMEA_BF ea_nlev ea_ibias vss vss sg13_hv_nmos l=x_dut_xmea_bf_l w=x_dut_xmea_bf_w
XMEA_BO ea_out ea_ibias vss vss sg13_hv_nmos l=x_dut_xmea_bo_l w=x_dut_xmea_bo_w
XMEA_BP ea_ibias ea_ibias vdd vdd sg13_hv_pmos l=x_dut_xmea_bp_l w=x_dut_xmea_bp_w
XMP vout ea_out vdd vdd sg13_hv_pmos l=x_dut_xmp_l m=x_dut_xmp_m w=x_dut_xmp_w
XMRA_1 ra_na v_ref_fb ra_tail vss sg13_hv_nmos l=x_dut_xmra_1_l w=x_dut_xmra_1_w
XMRA_2 ra_nb vref ra_tail vss sg13_hv_nmos l=x_dut_xmra_2_l w=x_dut_xmra_2_w
XMRA_3 ra_na ra_na vdd vdd sg13_hv_pmos l=x_dut_xmra_3_l w=x_dut_xmra_3_w
XMRA_4 ra_nb ra_na vdd vdd sg13_hv_pmos l=x_dut_xmra_4_l w=x_dut_xmra_4_w
XMRA_5 v_ref_out ra_nb vdd vdd sg13_hv_pmos l=x_dut_xmra_5_l w=x_dut_xmra_5_w
XMRA_B0 ra_ibias ra_ibias vss vss sg13_hv_nmos l=x_dut_xmra_b0_l w=x_dut_xmra_b0_w
XMRA_BC ra_tail ra_ibias vss vss sg13_hv_nmos l=x_dut_xmra_bc_l w=x_dut_xmra_bc_w
XMRA_BO v_ref_out ra_ibias vss vss sg13_hv_nmos l=x_dut_xmra_bo_l w=x_dut_xmra_bo_w
XMRA_BP ra_ibias ra_ibias vdd vdd sg13_hv_pmos l=x_dut_xmra_bp_l w=x_dut_xmra_bp_w
.ends
.end
