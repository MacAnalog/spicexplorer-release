** GENERATED by `analog-db export-raw` — DO NOT EDIT.
** circuit=tsn_002_ptat_classic  class=temp_sensor  pdk=ihp-sg13g2  testbench=line_sweep  corner=tt
** Self-contained deck: testbench + bound params + lowered DUT (.subckt tsn_002_ptat_classic).
** PDK corner libs resolve by BARE NAME on the image's ngspice sourcepath — run in a
** PDK-enabled env (the base image / api container), NOT a bare host:
**   docker run --rm -i spicexplorer-spice-base:local \
**     bash -lc 'd=$(mktemp -d) && cat > $d/c.spice && cd $d && ngspice -b c.spice' < raw/tsn_002_ptat_classic/ihp-sg13g2/line_sweep.spice
*----------------------------------------------------------*
** params: 6 free + 4 frozen knobs (sizing.yaml) · 3 tied · 0 ratio-derived (abstract/params.yaml) · 1 testbench params
** AUTHORED TEMPLATE — temp_sensor/line_sweep (plan D-4): supply (line) sensitivity of a PTAT
** sensor. Sweeps the supply and reports the output %-change over the swept range, referred to the
** nominal-supply output. Bindings: DUT PORT_LINE VDD, VDD_LO VDD_HI VDD_STEP, PDK_INCLUDE.
.lib cornerMOSlv.lib mos_tt
.temp 27

.param VDD=1.5

Vdd  vdd 0 dc {VDD}
Vss  vss 0 dc 0

XDUT vdd vout vss tsn_002_ptat_classic

.control
  set filetype=ascii
  dc Vdd 1.3 1.7 0.02
  meas dc v_at_lo  FIND v(vout) AT=1.3
  meas dc v_at_hi  FIND v(vout) AT=1.7
  meas dc v_at_nom FIND v(vout) AT=1.5
  let line_sens_pct = abs((v_at_hi - v_at_lo) / v_at_nom) * 100
  print line_sens_pct
  write
  quit
.endc
.param x_dut_xm3_w=2.0u
.param x_dut_xm3_l=1.0u
.param x_dut_xm0_w=8.0u
.param x_dut_xm1_w=2.0u
.param x_dut_xm0_l=1.0u
.param x_r0=20000
.param x_dut_xm3_m=1
.param x_dut_xm4_m=1
.param x_dut_xm0_m=1
.param x_dut_xm1_m=1
* ---- GENERATED parameter ties (abstract/params.yaml groups/ratios) ----
* Each tied symbol is defined exactly once, by its line below; rewrite that
* .param to untie just that symbol (untying = shadowing, plan D-3).
.param x_dut_xm4_w = {x_dut_xm3_w}
.param x_dut_xm4_l = {x_dut_xm3_l}
.param x_dut_xm1_l = {x_dut_xm0_l}
.subckt tsn_002_ptat_classic vdd vout vss
R0 vout vss x_r0
XM0 vmir net1 vout vout sg13_lv_nmos l=x_dut_xm0_l m=x_dut_xm0_m w=x_dut_xm0_w
XM1 net1 net1 vss vss sg13_lv_nmos l=x_dut_xm1_l m=x_dut_xm1_m w=x_dut_xm1_w
XM3 vmir vmir vdd vdd sg13_lv_pmos l=x_dut_xm3_l m=x_dut_xm3_m w=x_dut_xm3_w
XM4 net1 vmir vdd vdd sg13_lv_pmos l=x_dut_xm4_l m=x_dut_xm4_m w=x_dut_xm4_w
.ends
.end
