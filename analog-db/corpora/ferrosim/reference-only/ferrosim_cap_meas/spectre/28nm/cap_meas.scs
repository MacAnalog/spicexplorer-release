// Runnable AC capacitance sanity check.
// A 1 V AC source drives a 50 fF reference capacitor plus a 100 fF DUT
// capacitor. Expected total current magnitude is 2*pi*f*150 fF.

simulator lang=spectre
global 0

parameters Vbias=0 Vac_mag=1 CREF=50f CDUT=100f

C_ref (PROBE 0) capacitor c=CREF
C_dut (PROBE 0) capacitor c=CDUT

V_drv (PROBE 0) vsource dc=Vbias mag=Vac_mag type=dc

simulatorOptions options psfversion="1.4.0" reltol=1e-4 vabstol=1e-6 \
    iabstol=1e-12 temp=27 tnom=27 scalem=1.0 scale=1.0 \
    gmin=1e-12 rforce=1 maxnotes=5 maxwarns=5 digits=5 cols=80 \
    pivrel=1e-3 sensfile="../psf/sens.output" checklimitdest=psf

dcOp dc write="spectre.dc" maxiters=150 maxsteps=10000 annotate=status
dcOpInfo info what=oppoint where=rawfile

ac ac start=1Meg stop=10G annotate=status

modelParameter info what=models where=rawfile
element info what=inst where=rawfile
outputParameter info what=output where=rawfile
designParamVals info what=parameters where=rawfile
primitives info what=primitives where=rawfile
subckts info what=subckts where=rawfile

save PROBE V_drv:p
saveOptions options save=selected
