** GENERATED by `analog-db export-raw` — DO NOT EDIT.
** Standalone lowered DUT subckt for amp_029_two_stage_miller_comp on tsmc-n65 (sizing .param defaults + .subckt).
** Not a runnable deck on its own — include it under your own testbench:
**   .include _dut.spice
**   XDUT vinp vinn voutp voutn vdd vss amp_029_two_stage_miller_comp
** Source: pdk/tsmc-n65/netlist.spice (run `analog-db generate` to refresh).
*----------------------------------------------------------*
** params: 14 free + 6 frozen knobs (sizing.yaml) · 16 tied · 0 ratio-derived (abstract/params.yaml)
.param x_dut_xm1_w=10u
.param x_dut_xm1_l=0.5u
.param x_dut_xm3_w=10u
.param x_dut_xm3_l=1u
.param x_dut_xm5_w=12u
.param x_dut_xm5_l=0.5u
.param x_dut_xm6_w=2u
.param x_dut_xm6_l=1u
.param x_dut_xm7_w=6u
.param x_dut_xm8_w=2u
.param x_dut_r1_value=2k
.param x_dut_c1_value=1p
.param i_bias=20u
.param vbl=0.71
.param x_dut_xm1_m=1
.param x_dut_xm3_m=1
.param x_dut_xm5_m=1
.param x_dut_xm6_m=1
.param x_dut_xm7_m=1
.param x_dut_xm8_m=1
* ---- GENERATED parameter ties (abstract/params.yaml groups/ratios) ----
* Each tied symbol is defined exactly once, by its line below; rewrite that
* .param to untie just that symbol (untying = shadowing, plan D-3).
.param x_dut_xm10_l = {x_dut_xm6_l}
.param x_dut_xm7_l = {x_dut_xm6_l}
.param x_dut_xm8_l = {x_dut_xm6_l}
.param x_dut_xm2_w = {x_dut_xm1_w}
.param x_dut_xm2_l = {x_dut_xm1_l}
.param x_dut_xm2_m = {x_dut_xm1_m}
.param x_dut_xm4_w = {x_dut_xm3_w}
.param x_dut_xm4_l = {x_dut_xm3_l}
.param x_dut_xm4_m = {x_dut_xm3_m}
.param x_dut_xm9_w = {x_dut_xm5_w}
.param x_dut_xm9_l = {x_dut_xm5_l}
.param x_dut_xm9_m = {x_dut_xm5_m}
.param x_dut_xm10_w = {x_dut_xm7_w}
.param x_dut_xm10_m = {x_dut_xm7_m}
.param x_dut_r2_value = {x_dut_r1_value}
.param x_dut_c2_value = {x_dut_c1_value}
.subckt amp_029_two_stage_miller_comp vinp vinn voutp voutn vdd vss
C1 mill_p voutp 'x_dut_c1_value'
C2 mill_n voutn 'x_dut_c2_value'
IBIAS vdd ref dc {i_bias}
R1 stg1p mill_p 'x_dut_r1_value'
R2 stg1n mill_n 'x_dut_r2_value'
VBL vbl vss dc {vbl}
XM1 stg1p vinp tail vss nch_lvt l=x_dut_xm1_l m=x_dut_xm1_m w=x_dut_xm1_w
XM10 voutn ref vss vss nch_lvt l=x_dut_xm10_l m=x_dut_xm10_m w=x_dut_xm10_w
XM2 stg1n vinn tail vss nch_lvt l=x_dut_xm2_l m=x_dut_xm2_m w=x_dut_xm2_w
XM3 stg1p vbl vdd vdd pch_lvt l=x_dut_xm3_l m=x_dut_xm3_m w=x_dut_xm3_w
XM4 stg1n vbl vdd vdd pch_lvt l=x_dut_xm4_l m=x_dut_xm4_m w=x_dut_xm4_w
XM5 voutp stg1p vdd vdd pch_lvt l=x_dut_xm5_l m=x_dut_xm5_m w=x_dut_xm5_w
XM6 ref ref vss vss nch_lvt l=x_dut_xm6_l m=x_dut_xm6_m w=x_dut_xm6_w
XM7 voutp ref vss vss nch_lvt l=x_dut_xm7_l m=x_dut_xm7_m w=x_dut_xm7_w
XM8 tail ref vss vss nch_lvt l=x_dut_xm8_l m=x_dut_xm8_m w=x_dut_xm8_w
XM9 voutn stg1n vdd vdd pch_lvt l=x_dut_xm9_l m=x_dut_xm9_m w=x_dut_xm9_w
.ends
