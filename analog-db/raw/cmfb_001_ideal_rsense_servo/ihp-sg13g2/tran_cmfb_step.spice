** GENERATED by `analog-db export-raw` — DO NOT EDIT.
** circuit=cmfb_001_ideal_rsense_servo  class=cmfb  pdk=ihp-sg13g2  testbench=tran_cmfb_step  corner=tt
** Self-contained deck: testbench + bound params + lowered DUT (.subckt cmfb_001_ideal_rsense_servo).
** PDK corner libs resolve by BARE NAME on the image's ngspice sourcepath — run in a
** PDK-enabled env (the base image / api container), NOT a bare host:
**   docker run --rm -i spicexplorer-spice-base:local \
**     bash -lc 'd=$(mktemp -d) && cat > $d/c.spice && cd $d && ngspice -b c.spice' < raw/cmfb_001_ideal_rsense_servo/ihp-sg13g2/tran_cmfb_step.spice
*----------------------------------------------------------*
** params: 6 free + 0 frozen knobs (sizing.yaml) · 1 tied · 0 ratio-derived (abstract/params.yaml) · 3 testbench params
** AUTHORED TEMPLATE — cmfb/tran_cmfb_step (time-domain polarity + stability + speed).
** A sensed-CM square step: both sense pins ride Vs, which steps VCM -> VCM+VSTEP at
** TSTEP1 and back at TSTEP2 (edges 10n); the control output drives the bound CL
** (actuator gate proxy). Complements dc_cmfb_transfer (same polarity, measured in
** time domain) and ac_servo (ringing realizes what a shallow phase margin hides).
**   step_delta_v  settled vcmfb shift on the plateau (FIND at TMID) minus the
**                 pre-step level (FIND at TSTEP1/2) — SIGNED: sign must match
**                 cmfb_slope (canonical +, inverted -)
**   ring_v        half-amplitude (max-min)/2 of vcmfb over the SETTLED half of the
**                 plateau (TMID..TSTEP2): ~0 for a clean servo; >0 flags an
**                 underdamped or oscillating error amp under this CL
**   t_cm_settle   release-edge recovery: last |vcmfb - vcmfb(TEND)| = VTOL crossing
**                 minus TSTEP2 (the amplifier/tran_cm_kick settle convention)
** Choose TMID with >= 10 servo time constants after TSTEP1 (bw_servo_hz from ac_servo)
** and TEND likewise after TSTEP2, or the plateau/settle reads transient residue.
** Assumes the CMFB-servo port order:
**   .subckt <id> vinp vinn vcmfb vref vdd vss
** Required bindings: DUT PORT_LINE VDD VCM CL VSTEP TSTEP1 TMID TSTEP2 TEND VTOL
**                    TSTEP TSTOP PDK_INCLUDE.
.lib cornerMOSlv.lib mos_tt
.temp 27

.param VDD=1.2
.param VCM=0.6
.param CL=50f

Vdd  vdd 0 dc {VDD}
Vss  vss 0 dc 0
Vref vref 0 dc {VCM}
* sensed-CM square step, one-shot: VCM -> VCM+VSTEP during TSTEP1..TSTEP2
Vs   vs 0 dc {VCM} pulse({VCM} {0.6+1m} 20u 10n 10n {80u-20u} 1)
Vinp vinp vs dc 0
Vinn vinn vs dc 0
CLoad vcmfb 0 {CL}

XDUT vinp vinn vcmfb vref vdd vss cmfb_001_ideal_rsense_servo

.control
  set filetype=ascii
  tran 50n 160u
  meas tran vpre FIND v(vcmfb) AT={20u/2}
  meas tran von FIND v(vcmfb) AT=60u
  let step_delta_v = von - vpre
  print step_delta_v
  meas tran von_max MAX v(vcmfb) FROM=60u TO=80u
  meas tran von_min MIN v(vcmfb) FROM=60u TO=80u
  let ring_v = (von_max - von_min)/2
  print ring_v
  meas tran vend FIND v(vcmfb) AT=150u
  let verr = abs(v(vcmfb) - vend)
  meas tran tcross WHEN verr=1m FALL=LAST
  let t_cm_settle = tcross - 80u
  print t_cm_settle
  write
  quit
.endc
.param gm_val=100u
.param rout_val=10Meg
.param cout_val=100f
.param rin_val=1e12
.param cin_val=10f
.param x_dut_rmp_value=1Meg
* ---- GENERATED parameter ties (abstract/params.yaml groups/ratios) ----
* Each tied symbol is defined exactly once, by its line below; rewrite that
* .param to untie just that symbol (untying = shadowing, plan D-3).
.param x_dut_rmn_value = {x_dut_rmp_value}
.subckt cmfb_001_ideal_rsense_servo vinp vinn vcmfb vref vdd vss
CIN_SERVO cm_sense vref 'cin_val'
COUT_SERVO vss vcmfb 'cout_val'
GM_SERVO vss vcmfb vref cm_sense {gm_val}
RIN_SERVO cm_sense vref 'rin_val'
RMN vinn cm_sense 'x_dut_rmn_value'
RMP cm_sense vinp 'x_dut_rmp_value'
ROUT_SERVO vss vcmfb 'rout_val'
.ends
.end
