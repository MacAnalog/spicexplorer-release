** GENERATED by `analog-db export-raw` — DO NOT EDIT.
** circuit=ldo_005_buffered_ref  class=ldo  pdk=gf180mcu  testbench=dropout  corner=tt
** Self-contained deck: testbench + bound params + lowered DUT (.subckt ldo_005_buffered_ref).
** PDK corner libs resolve by BARE NAME on the image's ngspice sourcepath — run in a
** PDK-enabled env (the base image / api container), NOT a bare host:
**   docker run --rm -i spicexplorer-spice-base:local \
**     bash -lc 'd=$(mktemp -d) && cat > $d/c.spice && cd $d && ngspice -b c.spice' < raw/ldo_005_buffered_ref/gf180mcu/dropout.spice
*----------------------------------------------------------*
** params: 39 free + 0 frozen knobs (sizing.yaml) · 15 tied · 0 ratio-derived (abstract/params.yaml) · 0 testbench params
** AUTHORED TEMPLATE — ldo/dropout: the smallest (Vin - Vout) at which the regulator still
** REGULATES, under heavy load. Vin is swept upward and dropout is read at the first point where
** the output is genuinely in regulation.
**
** REWRITTEN 2026-07-21. The previous form was
**     meas dc vin_at WHEN v(vout)=1.52 RISE=1
**     let v_dropout = vin_at - 1.52
** i.e. purely "when does vout first rise past a threshold". That cannot tell REGULATION from a
** DEAD PASS DEVICE, and it fails in the worst possible direction — optimistically. When the loop
** is not working the pass transistor sits fully on, so vout simply follows vin; vout then crosses
** VOUT_THRESH at vin ~ VOUT_THRESH and the bench reports a dropout of ~0. A completely broken
** regulator scores a PERFECT dropout number.
**
** That is not hypothetical: it green-lit a real candidate here. A resistor-biased variant of
** ldo_005_buffered_ref reported dropout 0.090 V (against 0.490 V for the working design) while
** actually RAILING below ~3.1 V — vout was 2.59 V at vin 2.6 V. Only line_reg (1.185 V) caught it.
** This is the same class of defect as the amplifier ICMR bench measuring rail coincidence instead
** of tracking, and it takes the same cure: an ACTIVITY criterion alongside the level test.
**
** In regulation now requires BOTH:
**   * the output is at its target:      |vout - VOUT_NOM| <= VREG_TOL
**   * the output is not following vin:  |dvout/dvin| <= REG_SLOPE_MAX
** A regulating LDO has dvout/dvin ~ line-regulation slope (1e-3 or less); a railed one has ~1, so
** the slope test separates them cleanly no matter where the level test happens to land.
**
** Bindings: DUT PORT_LINE ILOAD VDD_START VDD_STOP VDD_STEP VOUT_NOM VREG_TOL REG_SLOPE_MAX
**           PDK_INCLUDE.
** VOUT_NOM defaults to the datasheet's default_conditions.vout typical value; VREG_TOL and
** REG_SLOPE_MAX have defaults in assemble.py, so existing circuits need no edits. The legacy
** VOUT_THRESH binding is no longer used — a threshold alone is exactly what was wrong.
.include design.ngspice
.lib sm141064.ngspice typical
.temp 27

Vdd  vdd 0 dc 1.4
Vss  vss 0 dc 0
Iload vout 0 dc 1m

XDUT vdd vout vss ldo_005_buffered_ref

.control
  set filetype=ascii
  dc Vdd 1.4 3.6 0.01
  let vo    = v(vout)
  let vsw   = v(vdd)
  let dvo   = deriv(vo)
  let dvi   = deriv(vsw)
  let slope = dvo / dvi
  let inreg = (abs(vo - 1.6) <= 0.05) & (abs(slope) <= 0.1)
  let npts  = length(inreg)
  let k     = 0
  let found = 0
  let vin_at = 0
  let vout_at = 0
  while k < npts
    if found < 0.5
      if inreg[k] > 0.5
        let vin_at  = vsw[k]
        let vout_at = vo[k]
        let found   = 1
      end
    end
    let k = k + 1
  end
  * NaN rather than a fabricated number when the sweep never reaches regulation — an honest
  * "this circuit does not regulate anywhere in the swept range".
  if found < 0.5
    let v_dropout = 0/0
  else
    let v_dropout = vin_at - vout_at
  end
  print vin_at vout_at v_dropout
  write
  quit
.endc
.param x_dut_xmra_bp_w=10.844u
.param x_dut_xmra_bp_l=2u
.param x_dut_xmra_b0_w=12u
.param x_dut_xmra_b0_l=2u
.param x_dut_xmra_bc_w=8.316u
.param x_dut_xmra_bo_w=4u
.param x_dut_xmra_1_w=86.42u
.param x_dut_xmra_1_l=0.7u
.param x_dut_xmra_3_w=20u
.param x_dut_xmra_3_l=1u
.param x_dut_xmra_5_w=37.76u
.param x_dut_xmra_5_l=2.646u
.param r_ra_z=30.853k
.param c_ra_comp=4.508p
.param x_dut_xmea_bp_w=6.3111u
.param x_dut_xmea_bp_l=2u
.param x_dut_xmea_b0_w=34.533u
.param x_dut_xmea_b0_l=2u
.param x_dut_xmea_bf_w=5u
.param x_dut_xmea_1_w=68.542u
.param x_dut_xmea_1_l=0.7u
.param x_dut_xmea_3_w=69.545u
.param x_dut_xmea_3_l=0.5u
.param x_dut_xmea_4_w=10u
.param x_dut_xmea_4_l=0.5u
.param x_dut_xmea_6_w=12u
.param x_dut_xmea_6_l=3.8349u
.param r_ea_z=28.429k
.param c_ea_comp=0.2p
.param vref_val=0.8
.param r_ref_top=100k
.param r_ref_bot=100k
.param r_lpf=10k
.param c_lpf=10p
.param x_dut_xmp_w=20u
.param x_dut_xmp_m=20
.param x_dut_xmp_l=0.6u
.param r_bleed=10k
.param c_out_int=10p
* ---- GENERATED parameter ties (abstract/params.yaml groups/ratios) ----
* Each tied symbol is defined exactly once, by its line below; rewrite that
* .param to untie just that symbol (untying = shadowing, plan D-3).
.param x_dut_xmra_bc_l = {x_dut_xmra_b0_l}
.param x_dut_xmra_bo_l = {x_dut_xmra_b0_l}
.param x_dut_xmra_2_w = {x_dut_xmra_1_w}
.param x_dut_xmra_2_l = {x_dut_xmra_1_l}
.param x_dut_xmra_4_w = {x_dut_xmra_3_w}
.param x_dut_xmra_4_l = {x_dut_xmra_3_l}
.param x_dut_xmea_bc_l = {x_dut_xmea_b0_l}
.param x_dut_xmea_bf_l = {x_dut_xmea_b0_l}
.param x_dut_xmea_bo_l = {x_dut_xmea_b0_l}
.param x_dut_xmea_bc_w = {x_dut_xmea_b0_w}
.param x_dut_xmea_bo_w = {x_dut_xmea_b0_w}
.param x_dut_xmea_2_w = {x_dut_xmea_1_w}
.param x_dut_xmea_2_l = {x_dut_xmea_1_l}
.param x_dut_xmea_5_w = {x_dut_xmea_3_w}
.param x_dut_xmea_5_l = {x_dut_xmea_3_l}
.subckt ldo_005_buffered_ref vdd vout vss
C1 vout vss 'c_out_int'
CEAC ea_ncz ea_out 'c_ea_comp'
CRAC ra_ncz v_ref_out 'c_ra_comp'
C_LPF v_lpf_out vss 'c_lpf'
R1 v_ref_out v_ref_fb 'r_ref_top'
R2 v_ref_fb vss 'r_ref_bot'
R3 vout vss 'r_bleed'
REAZ ea_nb ea_ncz 'r_ea_z'
RRAZ ra_nb ra_ncz 'r_ra_z'
R_LPF v_ref_out v_lpf_out 'r_lpf'
VLP lp_brk vout dc 0
VREF vref vss dc {vref_val}
XMEA_1 ea_na v_lpf_out ea_tail vss nfet_06v0 l=x_dut_xmea_1_l w=x_dut_xmea_1_w
XMEA_2 ea_nb lp_brk ea_tail vss nfet_06v0 l=x_dut_xmea_2_l w=x_dut_xmea_2_w
XMEA_3 ea_na ea_nd vdd vdd pfet_06v0 l=x_dut_xmea_3_l w=x_dut_xmea_3_w
XMEA_4 ea_nlev ea_na ea_nd vdd pfet_06v0 l=x_dut_xmea_4_l w=x_dut_xmea_4_w
XMEA_5 ea_nb ea_nd vdd vdd pfet_06v0 l=x_dut_xmea_5_l w=x_dut_xmea_5_w
XMEA_6 ea_out ea_nb vdd vdd pfet_06v0 l=x_dut_xmea_6_l w=x_dut_xmea_6_w
XMEA_B0 ea_ibias ea_ibias vss vss nfet_06v0 l=x_dut_xmea_b0_l w=x_dut_xmea_b0_w
XMEA_BC ea_tail ea_ibias vss vss nfet_06v0 l=x_dut_xmea_bc_l w=x_dut_xmea_bc_w
XMEA_BF ea_nlev ea_ibias vss vss nfet_06v0 l=x_dut_xmea_bf_l w=x_dut_xmea_bf_w
XMEA_BO ea_out ea_ibias vss vss nfet_06v0 l=x_dut_xmea_bo_l w=x_dut_xmea_bo_w
XMEA_BP ea_ibias ea_ibias vdd vdd pfet_06v0 l=x_dut_xmea_bp_l w=x_dut_xmea_bp_w
XMP vout ea_out vdd vdd pfet_06v0 l=x_dut_xmp_l m=x_dut_xmp_m w=x_dut_xmp_w
XMRA_1 ra_na v_ref_fb ra_tail vss nfet_06v0 l=x_dut_xmra_1_l w=x_dut_xmra_1_w
XMRA_2 ra_nb vref ra_tail vss nfet_06v0 l=x_dut_xmra_2_l w=x_dut_xmra_2_w
XMRA_3 ra_na ra_na vdd vdd pfet_06v0 l=x_dut_xmra_3_l w=x_dut_xmra_3_w
XMRA_4 ra_nb ra_na vdd vdd pfet_06v0 l=x_dut_xmra_4_l w=x_dut_xmra_4_w
XMRA_5 v_ref_out ra_nb vdd vdd pfet_06v0 l=x_dut_xmra_5_l w=x_dut_xmra_5_w
XMRA_B0 ra_ibias ra_ibias vss vss nfet_06v0 l=x_dut_xmra_b0_l w=x_dut_xmra_b0_w
XMRA_BC ra_tail ra_ibias vss vss nfet_06v0 l=x_dut_xmra_bc_l w=x_dut_xmra_bc_w
XMRA_BO v_ref_out ra_ibias vss vss nfet_06v0 l=x_dut_xmra_bo_l w=x_dut_xmra_bo_w
XMRA_BP ra_ibias ra_ibias vdd vdd pfet_06v0 l=x_dut_xmra_bp_l w=x_dut_xmra_bp_w
.ends
.end
