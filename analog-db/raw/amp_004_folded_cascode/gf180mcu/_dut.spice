** GENERATED by `analog-db export-raw` — DO NOT EDIT.
** Standalone lowered DUT subckt for amp_004_folded_cascode on gf180mcu (sizing .param defaults + .subckt).
** Not a runnable deck on its own — include it under your own testbench:
**   .include _dut.spice
**   XDUT vinn vinp vout vdd ibias vss amp_004_folded_cascode
** Source: pdk/gf180mcu/netlist.spice (run `analog-db generate` to refresh).
*----------------------------------------------------------*
** params: 16 free + 21 frozen knobs (sizing.yaml) · 21 tied · 0 ratio-derived (abstract/params.yaml)
.param x_dut_xm1_w=96u
.param x_dut_xm1_l=0.5u
.param x_dut_xm13_w=60u
.param x_dut_xm13_l=1u
.param x_dut_xm6_w=30u
.param x_dut_xm6_l=0.5u
.param x_dut_xm7_w=88u
.param x_dut_xm7_l=0.5u
.param x_dut_xm9_w=82u
.param x_dut_xm9_l=1u
.param x_dut_xm11_w=60u
.param x_dut_xm11_l=1u
.param x_dut_xm12_w=60u
.param x_dut_xm12_l=1u
.param x_dut_vb1=1.2
.param x_dut_vb2=1.95
.param x_dut_xm1_ng=12
.param x_dut_xm13_ng=12
.param x_dut_xm6_ng=6
.param x_dut_xm7_ng=11
.param x_dut_xm9_ng=16
.param x_dut_xm11_ng=12
.param x_dut_xm12_ng=12
.param x_dut_xm4_m=1
.param x_dut_xm1_m=1
.param x_dut_xm2_m=1
.param x_dut_xm3_m=1
.param x_dut_xm11_m=2
.param x_dut_xm0_m=2
.param x_dut_xm6_m=1
.param x_dut_xm5_m=1
.param x_dut_xm7_m=1
.param x_dut_xm8_m=1
.param x_dut_xm9_m=1
.param x_dut_xm10_m=1
.param x_dut_xm12_m=2
.param x_dut_xm13_m=1
* ---- GENERATED parameter ties (abstract/params.yaml groups/ratios) ----
* Each tied symbol is defined exactly once, by its line below; rewrite that
* .param to untie just that symbol (untying = shadowing, plan D-3).
.param x_dut_xm4_w = {x_dut_xm13_w}
.param x_dut_xm3_w = {x_dut_xm13_w}
.param x_dut_xm4_l = {x_dut_xm13_l}
.param x_dut_xm3_l = {x_dut_xm13_l}
.param x_dut_xm4_ng = {x_dut_xm13_ng}
.param x_dut_xm3_ng = {x_dut_xm13_ng}
.param x_dut_xm2_w = {x_dut_xm1_w}
.param x_dut_xm2_l = {x_dut_xm1_l}
.param x_dut_xm2_ng = {x_dut_xm1_ng}
.param x_dut_xm0_w = {x_dut_xm11_w}
.param x_dut_xm0_l = {x_dut_xm11_l}
.param x_dut_xm0_ng = {x_dut_xm11_ng}
.param x_dut_xm5_w = {x_dut_xm6_w}
.param x_dut_xm5_l = {x_dut_xm6_l}
.param x_dut_xm5_ng = {x_dut_xm6_ng}
.param x_dut_xm8_w = {x_dut_xm7_w}
.param x_dut_xm8_l = {x_dut_xm7_l}
.param x_dut_xm8_ng = {x_dut_xm7_ng}
.param x_dut_xm10_w = {x_dut_xm9_w}
.param x_dut_xm10_l = {x_dut_xm9_l}
.param x_dut_xm10_ng = {x_dut_xm9_ng}
.subckt amp_004_folded_cascode vinn vinp vout vdd ibias vss
V1 vb1 vss x_dut_vb1
V2 vb2 vss x_dut_vb2
XM0 tail ibias vdd vdd pfet_03v3 l=x_dut_xm0_l m=x_dut_xm0_m nf=x_dut_xm0_ng w=x_dut_xm0_w
XM1 foldp vinp tail vdd pfet_03v3 l=x_dut_xm1_l m=x_dut_xm1_m nf=x_dut_xm1_ng w=x_dut_xm1_w
XM10 s10 cascp vdd vdd pfet_03v3 l=x_dut_xm10_l m=x_dut_xm10_m nf=x_dut_xm10_ng w=x_dut_xm10_w
XM11 ibias ibias vdd vdd pfet_03v3 l=x_dut_xm11_l m=x_dut_xm11_m nf=x_dut_xm11_ng w=x_dut_xm11_w
XM12 nbias ibias vdd vdd pfet_03v3 l=x_dut_xm12_l m=x_dut_xm12_m nf=x_dut_xm12_ng w=x_dut_xm12_w
XM13 nbias nbias vss vss nfet_03v3 l=x_dut_xm13_l m=x_dut_xm13_m nf=x_dut_xm13_ng w=x_dut_xm13_w
XM2 foldn vinn tail vdd pfet_03v3 l=x_dut_xm2_l m=x_dut_xm2_m nf=x_dut_xm2_ng w=x_dut_xm2_w
XM3 foldp nbias vss vss nfet_03v3 l=x_dut_xm3_l m=x_dut_xm3_m nf=x_dut_xm3_ng w=x_dut_xm3_w
XM4 foldn nbias vss vss nfet_03v3 l=x_dut_xm4_l m=x_dut_xm4_m nf=x_dut_xm4_ng w=x_dut_xm4_w
XM5 cascp vb1 foldp vss nfet_03v3 l=x_dut_xm5_l m=x_dut_xm5_m nf=x_dut_xm5_ng w=x_dut_xm5_w
XM6 vout vb1 foldn vss nfet_03v3 l=x_dut_xm6_l m=x_dut_xm6_m nf=x_dut_xm6_ng w=x_dut_xm6_w
XM7 cascp vb2 s9 vdd pfet_03v3 l=x_dut_xm7_l m=x_dut_xm7_m nf=x_dut_xm7_ng w=x_dut_xm7_w
XM8 vout vb2 s10 vdd pfet_03v3 l=x_dut_xm8_l m=x_dut_xm8_m nf=x_dut_xm8_ng w=x_dut_xm8_w
XM9 s9 cascp vdd vdd pfet_03v3 l=x_dut_xm9_l m=x_dut_xm9_m nf=x_dut_xm9_ng w=x_dut_xm9_w
.ends
