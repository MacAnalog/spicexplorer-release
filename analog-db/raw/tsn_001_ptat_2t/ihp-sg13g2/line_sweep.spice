** GENERATED by `analog-db export-raw` — DO NOT EDIT.
** circuit=tsn_001_ptat_2t  class=temp_sensor  pdk=ihp-sg13g2  testbench=line_sweep  corner=tt
** Self-contained deck: testbench + bound params + lowered DUT (.subckt tsn_001_ptat_2t).
** PDK corner libs resolve by BARE NAME on the image's ngspice sourcepath — run in a
** PDK-enabled env (the base image / api container), NOT a bare host:
**   docker run --rm -i spicexplorer-spice-base:local \
**     bash -lc 'd=$(mktemp -d) && cat > $d/c.spice && cd $d && ngspice -b c.spice' < raw/tsn_001_ptat_2t/ihp-sg13g2/line_sweep.spice
*----------------------------------------------------------*
** params: 6 free + 0 frozen knobs (sizing.yaml) · 0 tied · 0 ratio-derived (abstract/params.yaml) · 1 testbench params
** AUTHORED TEMPLATE — temp_sensor/line_sweep (plan D-4): supply (line) sensitivity of a PTAT
** sensor. Sweeps the supply and reports the output %-change over the swept range, referred to the
** nominal-supply output. Bindings: DUT PORT_LINE VDD, VDD_LO VDD_HI VDD_STEP, PDK_INCLUDE.
.lib cornerMOSlv.lib mos_tt
.temp 27

.param VDD=1.2

Vdd  vdd 0 dc {VDD}
Vss  vss 0 dc 0

XDUT vdd vout vss tsn_001_ptat_2t

.control
  set filetype=ascii
  dc Vdd 0.9 1.5 0.02
  meas dc v_at_lo  FIND v(vout) AT=0.9
  meas dc v_at_hi  FIND v(vout) AT=1.5
  meas dc v_at_nom FIND v(vout) AT=1.2
  let line_sens_pct = abs((v_at_hi - v_at_lo) / v_at_nom) * 100
  print line_sens_pct
  write
  quit
.endc
.param x_dut_xm0_w=8.0u
.param x_dut_xm0_l=0.2u
.param x_dut_xm0_m=8
.param x_dut_xm1_w=4.0u
.param x_dut_xm1_l=1.0u
.param x_dut_xm1_m=8
.subckt tsn_001_ptat_2t vdd vout vss
XM0 vdd vout vout vss sg13_lv_nmos l=x_dut_xm0_l m=x_dut_xm0_m w=x_dut_xm0_w
XM1 vout vout vss vss sg13_lv_nmos l=x_dut_xm1_l m=x_dut_xm1_m w=x_dut_xm1_w
.ends
.end
