** GENERATED by `analog-db export-raw` — DO NOT EDIT.
** circuit=amp_033_ti_ldo_ref_selfbias  class=amplifier  pdk=gf180mcu  testbench=ac_open_loop  corner=tt
** Self-contained deck: testbench + bound params + lowered DUT (.subckt amp_033_ti_ldo_ref_selfbias).
** PDK corner libs resolve by BARE NAME on the image's ngspice sourcepath — run in a
** PDK-enabled env (the base image / api container), NOT a bare host:
**   docker run --rm -i spicexplorer-spice-base:local \
**     bash -lc 'd=$(mktemp -d) && cat > $d/c.spice && cd $d && ngspice -b c.spice' < raw/amp_033_ti_ldo_ref_selfbias/gf180mcu/ac_open_loop.spice
*----------------------------------------------------------*
** params: 16 free + 0 frozen knobs (sizing.yaml) · 6 tied · 0 ratio-derived (abstract/params.yaml) · 3 testbench params
** AUTHORED TEMPLATE — amplifier/ac_open_loop_biaswrap (plan D-4; the AnalogGym bias-wrap).
** Open-loop gain measured in closed-loop bias (analoggym-amplifiers skill §5): a 1 TH inductor
** DC-shorts the output back to the inverting input — setting the high-gain operating point —
** while a 1 TF cap AC-opens that feedback and injects the AC input. This is the only way a
** high-gain 3-stage amp biases stably while still exposing its open-loop AC response.
**
** Assumes the AnalogGym canonical DUT port order (self-biased; NO ibias port):
**   .subckt <id> vss vdd vinn vinp vout
** Bindings: DUT VDD VCM CL FSTART FSTOP PPD PDK_INCLUDE.
** FIXED 2026-07-20: this template used to hardcode `X1 0 vdd opout_dc opin opout amp_033_ti_ldo_ref_selfbias`,
** which silently assumed the AnalogGym port order [vss vdd vinn vinp vout] and MIS-WIRED any
** DUT declaring a different order (e.g. the amplifier-class [vdd vout vinp vinn vss] swaps
** vdd<->vss). It now uses XDUT vdd vout vinp vinn vss with canonical node names, exactly like the
** *_biaswrap_ibias sibling. For the AnalogGym DUTs this is a no-op: their vss port binds to
** node `vss`, which `Vss vss 0 dc 0` ties to ground just as the old direct-to-0 wiring did.
.include design.ngspice
.lib sm141064.ngspice typical
.temp 27

.param VDD=3.3
.param VCM=0.8
.param CL=10p

Vdd  vdd 0 dc {VDD}
Vss  vss 0 dc 0
Vcm  vinp 0 dc {VCM}          ; common-mode bias on the non-inverting input
Vac  sigin 0 dc 0 ac 1        ; AC stimulus
Lfb  vout vinn 1T        ; 1 TH: DC short (bias), AC open
Cin  vinn sigin 1T        ; 1 TF: DC open, AC inject into the inverting node
CLoad vout 0 {CL}

XDUT vdd vout vinp vinn vss amp_033_ti_ldo_ref_selfbias
.control
  set filetype=ascii
  ac dec 101 10 100MEG
  meas ac dcgain FIND vdb(vout) AT=10
  meas ac ugf    WHEN vdb(vout)=0 FALL=1
  let phc = cph(vout)*180/3.14159265
  let ph  = 180 + phc - phc[0]
  meas ac pm     FIND ph WHEN vdb(vout)=0 FALL=1
  write
  quit
.endc
.param x_dut_xmbp_w=1.0844e-05
.param x_dut_xmbp_l=2e-06
.param x_dut_xmb0_w=1.2e-05
.param x_dut_xmb0_l=2e-06
.param x_dut_xmbc_w=8.316e-06
.param x_dut_xmbc_m=1
.param x_dut_xmbo_w=4e-06
.param x_dut_xmbo_m=1
.param x_dut_xm1_w=8.642e-05
.param x_dut_xm1_l=7e-07
.param x_dut_xm3_w=2e-05
.param x_dut_xm3_l=1e-06
.param x_dut_xm5_w=3.776e-05
.param x_dut_xm5_l=2.646e-06
.param r_z=30853
.param c_comp=4.508e-12
* ---- GENERATED parameter ties (abstract/params.yaml groups/ratios) ----
* Each tied symbol is defined exactly once, by its line below; rewrite that
* .param to untie just that symbol (untying = shadowing, plan D-3).
.param x_dut_xm4_w = {x_dut_xm3_w}
.param x_dut_xm4_l = {x_dut_xm3_l}
.param x_dut_xm2_w = {x_dut_xm1_w}
.param x_dut_xm2_l = {x_dut_xm1_l}
.param x_dut_xmbc_l = {x_dut_xmb0_l}
.param x_dut_xmbo_l = {x_dut_xmb0_l}
.subckt amp_033_ti_ldo_ref_selfbias vdd vout vinp vinn vss
CC ncz vout 'c_comp'
RZ nb ncz 'r_z'
XM1 na vinn tail vss nfet_06v0 l=x_dut_xm1_l w=x_dut_xm1_w
XM2 nb vinp tail vss nfet_06v0 l=x_dut_xm2_l w=x_dut_xm2_w
XM3 na na vdd vdd pfet_06v0 l=x_dut_xm3_l w=x_dut_xm3_w
XM4 nb na vdd vdd pfet_06v0 l=x_dut_xm4_l w=x_dut_xm4_w
XM5 vout nb vdd vdd pfet_06v0 l=x_dut_xm5_l w=x_dut_xm5_w
XMB0 ibias ibias vss vss nfet_06v0 l=x_dut_xmb0_l w=x_dut_xmb0_w
XMBC tail ibias vss vss nfet_06v0 l=x_dut_xmbc_l m=x_dut_xmbc_m w=x_dut_xmbc_w
XMBO vout ibias vss vss nfet_06v0 l=x_dut_xmbo_l m=x_dut_xmbo_m w=x_dut_xmbo_w
XMBP ibias ibias vdd vdd pfet_06v0 l=x_dut_xmbp_l w=x_dut_xmbp_w
.ends
.end
