** GENERATED by `analog-db export-raw` — DO NOT EDIT.
** circuit=amp_022_fer_two_stage  class=amplifier  pdk=ihp-sg13g2  testbench=ac_open_loop  corner=tt
** Self-contained deck: testbench + bound params + lowered DUT (.subckt amp_022_fer_two_stage).
** PDK corner libs resolve by BARE NAME on the image's ngspice sourcepath — run in a
** PDK-enabled env (the base image / api container), NOT a bare host:
**   docker run --rm -i spicexplorer-spice-base:local \
**     bash -lc 'd=$(mktemp -d) && cat > $d/c.spice && cd $d && ngspice -b c.spice' < raw/amp_022_fer_two_stage/ihp-sg13g2/ac_open_loop.spice
*----------------------------------------------------------*
** params: 10 free + 5 frozen knobs (sizing.yaml) · 12 tied · 4 ratio-derived (abstract/params.yaml) · 4 testbench params
** AUTHORED TEMPLATE — amplifier/ac_open_loop_biaswrap_ibias: the bias-wrap open-loop bench for
** DUTs on the class ibias-port convention (ports vdd vout vinp vinn ibias vss). Same trick as
** ac_open_loop_biaswrap (which hardcodes the 5-port AnalogGym order): a 1 TH inductor DC-shorts
** vout back to the INVERTING input to set the high-gain operating point (mandatory for amps with
** a large systematic offset), while a 1 TF cap AC-opens that loop and injects the stimulus.
** Bindings: DUT PORT_LINE VDD VCM CL IBIAS FSTART FSTOP PPD PDK_INCLUDE.
.lib cornerMOSlv.lib mos_tt
.temp 27

.param VDD=1.5
.param VCM=0.6
.param CL=10p
.param IBIAS=20u

Vdd  vdd 0 dc {VDD}
Vss  vss 0 dc 0
Ibias vdd ibias dc {IBIAS}
Vcm  vinp 0 dc {VCM}          ; common-mode bias on the non-inverting input
Vac  sigin 0 dc 0 ac 1        ; AC stimulus
Lfb  vout vinn 1T             ; 1 TH: DC short (bias), AC open
Cin  vinn sigin 1T            ; 1 TF: DC open, AC inject into the inverting node
CLoad vout 0 {CL}

XDUT vdd vout vinp vinn ibias vss amp_022_fer_two_stage

.control
  set filetype=ascii
  ac dec 50 1 1G
  meas ac dcgain FIND vdb(vout) AT=1
  meas ac ugf    WHEN vdb(vout)=0 FALL=1
  let phc = cph(vout)*180/3.14159265
  let ph  = 180 + phc - phc[0]
  meas ac pm     FIND ph WHEN vdb(vout)=0 FALL=1
  write
  quit
.endc
.param x_dut_xmbd_w=4u
.param x_dut_xm7_w=8u
.param x_dut_xm0_w=8u
.param x_dut_xm3_w=6u
.param x_dut_xm7_l=0.4u
.param x_dut_xm0_l=0.4u
.param x_dut_xm3_l=0.4u
.param x_dut_xm2_l=0.4u
.param x_dut_xmbd_l=0.4u
.param x_dut_cc_value=2e-12
.param x_dut_xm0_m=5
.param x_dut_xm3_m=2
.param x_dut_xm2_m=24
.param x_dut_xm7_m=3
.param x_dut_xmbd_m=1
* ---- GENERATED parameter ties (abstract/params.yaml groups/ratios) ----
* Each tied symbol is defined exactly once, by its line below; rewrite that
* .param to untie just that symbol (untying = shadowing, plan D-3).
.param x_dut_xm1_w = {x_dut_xm0_w}
.param x_dut_xm1_l = {x_dut_xm0_l}
.param x_dut_xm1_m = {x_dut_xm0_m}
.param x_dut_xm4_w = {x_dut_xm3_w}
.param x_dut_xm4_l = {x_dut_xm3_l}
.param x_dut_xm2_w = {x_dut_xm3_w}
.param x_dut_xm5_w = {x_dut_xm7_w}
.param x_dut_xm6_w = {x_dut_xm7_w}
.param x_dut_xm5_l = {x_dut_xm7_l}
.param x_dut_xm6_l = {x_dut_xm7_l}
.param x_dut_xmbs_w = {x_dut_xmbd_w}
.param x_dut_xmbs_l = {x_dut_xmbd_l}
.param x_dut_xm4_m = {x_dut_xm3_m*1}
.param x_dut_xm5_m = {x_dut_xm7_m*1}
.param x_dut_xm6_m = {x_dut_xm7_m*17/3}
.param x_dut_xmbs_m = {x_dut_xmbd_m*1}
.subckt amp_022_fer_two_stage vdd vout vinp vinn ibias vss
CC b vout x_dut_cc_value
XM0 a vinn c vdd sg13_lv_pmos l=x_dut_xm0_l m=x_dut_xm0_m w=x_dut_xm0_w
XM1 b vinp c vdd sg13_lv_pmos l=x_dut_xm1_l m=x_dut_xm1_m w=x_dut_xm1_w
XM2 vout b vss vss sg13_lv_nmos l=x_dut_xm2_l m=x_dut_xm2_m w=x_dut_xm2_w
XM3 a a vss vss sg13_lv_nmos l=x_dut_xm3_l m=x_dut_xm3_m w=x_dut_xm3_w
XM4 b a vss vss sg13_lv_nmos l=x_dut_xm4_l m=x_dut_xm4_m w=x_dut_xm4_w
XM5 c pbias vdd vdd sg13_lv_pmos l=x_dut_xm5_l m=x_dut_xm5_m w=x_dut_xm5_w
XM6 vout pbias vdd vdd sg13_lv_pmos l=x_dut_xm6_l m=x_dut_xm6_m w=x_dut_xm6_w
XM7 pbias pbias vdd vdd sg13_lv_pmos l=x_dut_xm7_l m=x_dut_xm7_m w=x_dut_xm7_w
XMBD ibias ibias vss vss sg13_lv_nmos l=x_dut_xmbd_l m=x_dut_xmbd_m w=x_dut_xmbd_w
XMBS pbias ibias vss vss sg13_lv_nmos l=x_dut_xmbs_l m=x_dut_xmbs_m w=x_dut_xmbs_w
.ends
.end
