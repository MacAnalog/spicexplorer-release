** GENERATED by `analog-db export-raw` — DO NOT EDIT.
** circuit=amp_005_hoilee_affc  class=amplifier  pdk=gf180mcu  testbench=ac_open_loop  corner=tt
** Self-contained deck: testbench + bound params + lowered DUT (.subckt amp_005_hoilee_affc).
** PDK corner libs resolve by BARE NAME on the image's ngspice sourcepath — run in a
** PDK-enabled env (the base image / api container), NOT a bare host:
**   docker run --rm -i spicexplorer-spice-base:local \
**     bash -lc 'd=$(mktemp -d) && cat > $d/c.spice && cd $d && ngspice -b c.spice' < raw/amp_005_hoilee_affc/gf180mcu/ac_open_loop.spice
*----------------------------------------------------------*
** params: 33 free + 0 frozen knobs (sizing.yaml) · 44 tied · 16 ratio-derived (abstract/params.yaml) · 3 testbench params
** AUTHORED TEMPLATE — amplifier/ac_open_loop_biaswrap (plan D-4; the AnalogGym bias-wrap).
** Open-loop gain measured in closed-loop bias (analoggym-amplifiers skill §5): a 1 TH inductor
** DC-shorts the output back to the inverting input — setting the high-gain operating point —
** while a 1 TF cap AC-opens that feedback and injects the AC input. This is the only way a
** high-gain 3-stage amp biases stably while still exposing its open-loop AC response.
**
** Assumes the AnalogGym canonical DUT port order (self-biased; NO ibias port):
**   .subckt <id> vss vdd vinn vinp vout
** Bindings: DUT VDD VCM CL FSTART FSTOP PPD PDK_INCLUDE.
** FIXED 2026-07-20: this template used to hardcode `X1 0 vdd opout_dc opin opout amp_005_hoilee_affc`,
** which silently assumed the AnalogGym port order [vss vdd vinn vinp vout] and MIS-WIRED any
** DUT declaring a different order (e.g. the amplifier-class [vdd vout vinp vinn vss] swaps
** vdd<->vss). It now uses XDUT vss vdd vinn vinp vout with canonical node names, exactly like the
** *_biaswrap_ibias sibling. For the AnalogGym DUTs this is a no-op: their vss port binds to
** node `vss`, which `Vss vss 0 dc 0` ties to ground just as the old direct-to-0 wiring did.
.include design.ngspice
.lib sm141064.ngspice noise_corner
.lib sm141064.ngspice nfet_03v3_t
.lib sm141064.ngspice pfet_03v3_t
.lib sm141064.ngspice fets_mm
.temp 27

.param VDD=1.8
.param VCM=300m
.param CL=100p

Vdd  vdd 0 dc {VDD}
Vss  vss 0 dc 0
Vcm  vinp 0 dc {VCM}          ; common-mode bias on the non-inverting input
Vac  sigin 0 dc 0 ac 1        ; AC stimulus
Lfb  vout vinn 1T        ; 1 TH: DC short (bias), AC open
Cin  vinn sigin 1T        ; 1 TF: DC open, AC inject into the inverting node
CLoad vout 0 {CL}

XDUT vss vdd vinn vinp vout amp_005_hoilee_affc
.control
  set filetype=ascii
  ac dec 50 0.1 1G
  meas ac dcgain FIND vdb(vout) AT=0.1
  meas ac ugf    WHEN vdb(vout)=0 FALL=1
  let phc = cph(vout)*180/3.14159265
  let ph  = 180 + phc - phc[0]
  meas ac pm     FIND ph WHEN vdb(vout)=0 FALL=1
  write
  quit
.endc
.param CAPACITOR_0=18p
.param CAPACITOR_1=3p
.param CURRENT_0_BIAS=20u
.param x_dut_xm7_l=1u
.param x_dut_xm7_m=4
.param x_dut_xm7_w=1u
.param x_dut_xm11_l=1u
.param x_dut_xm11_m=4
.param x_dut_xm11_w=1u
.param x_dut_xm12_l=1u
.param x_dut_xm12_m=4
.param x_dut_xm12_w=1u
.param x_dut_xm16_l=1u
.param x_dut_xm16_m=16
.param x_dut_xm16_w=1u
.param x_dut_xm64_l=1u
.param x_dut_xm15_m=4
.param x_dut_xm64_w=1u
.param x_dut_xm22_l=1u
.param x_dut_xm22_m=4
.param x_dut_xm22_w=1u
.param x_dut_xm25_l=1u
.param x_dut_xm25_m=4
.param x_dut_xm25_w=1u
.param x_dut_xm59_l=1u
.param x_dut_xm59_m=4
.param x_dut_xm59_w=1u
.param x_dut_xm63_l=1u
.param x_dut_xm63_m=4
.param x_dut_xm63_w=1u
.param x_dut_xm10_l=1u
.param x_dut_xm10_m=4
.param x_dut_xm10_w=1u
* ---- GENERATED parameter ties (abstract/params.yaml groups/ratios) ----
* Each tied symbol is defined exactly once, by its line below; rewrite that
* .param to untie just that symbol (untying = shadowing, plan D-3).
.param x_dut_xm62_w = {x_dut_xm59_w}
.param x_dut_xm62_l = {x_dut_xm59_l}
.param x_dut_xm62_m = {x_dut_xm59_m}
.param x_dut_xm6_w = {x_dut_xm7_w}
.param x_dut_xm5_w = {x_dut_xm7_w}
.param x_dut_xm4_w = {x_dut_xm7_w}
.param x_dut_xm3_w = {x_dut_xm7_w}
.param x_dut_xm2_w = {x_dut_xm7_w}
.param x_dut_xm1_w = {x_dut_xm7_w}
.param x_dut_xm0_w = {x_dut_xm7_w}
.param x_dut_xm6_l = {x_dut_xm7_l}
.param x_dut_xm5_l = {x_dut_xm7_l}
.param x_dut_xm4_l = {x_dut_xm7_l}
.param x_dut_xm3_l = {x_dut_xm7_l}
.param x_dut_xm2_l = {x_dut_xm7_l}
.param x_dut_xm1_l = {x_dut_xm7_l}
.param x_dut_xm0_l = {x_dut_xm7_l}
.param x_dut_xm9_w = {x_dut_xm10_w}
.param x_dut_xm9_l = {x_dut_xm10_l}
.param x_dut_xm9_m = {x_dut_xm10_m}
.param x_dut_xm61_w = {x_dut_xm64_w}
.param x_dut_xm20_w = {x_dut_xm64_w}
.param x_dut_xm21_w = {x_dut_xm64_w}
.param x_dut_xm18_w = {x_dut_xm64_w}
.param x_dut_xm15_w = {x_dut_xm64_w}
.param x_dut_xm13_w = {x_dut_xm64_w}
.param x_dut_xm19_w = {x_dut_xm64_w}
.param x_dut_xm14_w = {x_dut_xm64_w}
.param x_dut_xm61_l = {x_dut_xm64_l}
.param x_dut_xm20_l = {x_dut_xm64_l}
.param x_dut_xm21_l = {x_dut_xm64_l}
.param x_dut_xm18_l = {x_dut_xm64_l}
.param x_dut_xm15_l = {x_dut_xm64_l}
.param x_dut_xm13_l = {x_dut_xm64_l}
.param x_dut_xm19_l = {x_dut_xm64_l}
.param x_dut_xm14_l = {x_dut_xm64_l}
.param x_dut_xm60_w = {x_dut_xm63_w}
.param x_dut_xm60_l = {x_dut_xm63_l}
.param x_dut_xm60_m = {x_dut_xm63_m}
.param x_dut_xm23_w = {x_dut_xm22_w}
.param x_dut_xm23_l = {x_dut_xm22_l}
.param x_dut_xm23_m = {x_dut_xm22_m}
.param x_dut_xm17_w = {x_dut_xm16_w}
.param x_dut_xm17_l = {x_dut_xm16_l}
.param x_dut_xm6_m = {x_dut_xm7_m*1}
.param x_dut_xm5_m = {x_dut_xm7_m*1}
.param x_dut_xm4_m = {x_dut_xm7_m*2}
.param x_dut_xm3_m = {x_dut_xm7_m*1}
.param x_dut_xm2_m = {x_dut_xm7_m*1}
.param x_dut_xm1_m = {x_dut_xm7_m*1}
.param x_dut_xm0_m = {x_dut_xm7_m*1}
.param x_dut_xm17_m = {x_dut_xm16_m*1}
.param x_dut_xm64_m = {x_dut_xm15_m*4}
.param x_dut_xm61_m = {x_dut_xm15_m*4}
.param x_dut_xm20_m = {x_dut_xm15_m*8}
.param x_dut_xm21_m = {x_dut_xm15_m*8}
.param x_dut_xm18_m = {x_dut_xm15_m*4}
.param x_dut_xm13_m = {x_dut_xm15_m*4}
.param x_dut_xm19_m = {x_dut_xm15_m*4}
.param x_dut_xm14_m = {x_dut_xm15_m*4}
.subckt amp_005_hoilee_affc vss vdd vinn vinp vout
C0 net049 VOUT 'CAPACITOR_0'
C1 VOUT net1 'CAPACITOR_1'
I0 net013 vss 'CURRENT_0_BIAS'
XM0 net013 net013 vdd vdd pfet_03v3 l=x_dut_xm0_l m=x_dut_xm0_m w=x_dut_xm0_w
XM1 VB4 net013 vdd vdd pfet_03v3 l=x_dut_xm1_l m=x_dut_xm1_m w=x_dut_xm1_w
XM10 net063 VINP net31 net31 pfet_03v3 l=x_dut_xm10_l m=x_dut_xm10_m w=x_dut_xm10_w
XM11 net043 net050 vdd vdd pfet_03v3 l=x_dut_xm11_l m=x_dut_xm11_m w=x_dut_xm11_w
XM12 VOUT net050 vdd vdd pfet_03v3 l=x_dut_xm12_l m=x_dut_xm12_m w=x_dut_xm12_w
XM13 VB4 VB3 net54 vss nfet_03v3 l=x_dut_xm13_l m=x_dut_xm13_m w=x_dut_xm13_w
XM14 DM_1 VB3 net56 vss nfet_03v3 l=x_dut_xm14_l m=x_dut_xm14_m w=x_dut_xm14_w
XM15 VB3 VB3 vss vss nfet_03v3 l=x_dut_xm15_l m=x_dut_xm15_m w=x_dut_xm15_w
XM16 VOUTN VB3 DM_2 vss nfet_03v3 l=x_dut_xm16_l m=x_dut_xm16_m w=x_dut_xm16_w
XM17 net050 VB3 net063 vss nfet_03v3 l=x_dut_xm17_l m=x_dut_xm17_m w=x_dut_xm17_w
XM18 net54 VB4 vss vss nfet_03v3 l=x_dut_xm18_l m=x_dut_xm18_m w=x_dut_xm18_w
XM19 net56 VB4 vss vss nfet_03v3 l=x_dut_xm19_l m=x_dut_xm19_m w=x_dut_xm19_w
XM2 DM_1 net013 vdd vdd pfet_03v3 l=x_dut_xm2_l m=x_dut_xm2_m w=x_dut_xm2_w
XM20 DM_2 VB4 vss vss nfet_03v3 l=x_dut_xm20_l m=x_dut_xm20_m w=x_dut_xm20_w
XM21 net063 VB4 vss vss nfet_03v3 l=x_dut_xm21_l m=x_dut_xm21_m w=x_dut_xm21_w
XM22 net043 net043 vss vss nfet_03v3 l=x_dut_xm22_l m=x_dut_xm22_m w=x_dut_xm22_w
XM23 net049 net043 vss vss nfet_03v3 l=x_dut_xm23_l m=x_dut_xm23_m w=x_dut_xm23_w
XM25 VOUT net049 vss vss nfet_03v3 l=x_dut_xm25_l m=x_dut_xm25_m w=x_dut_xm25_w
XM3 VB3 net013 vdd vdd pfet_03v3 l=x_dut_xm3_l m=x_dut_xm3_m w=x_dut_xm3_w
XM4 net31 net013 vdd vdd pfet_03v3 l=x_dut_xm4_l m=x_dut_xm4_m w=x_dut_xm4_w
XM5 VOUTN VOUTN vdd vdd pfet_03v3 l=x_dut_xm5_l m=x_dut_xm5_m w=x_dut_xm5_w
XM59 net2 net2 vdd vdd pfet_03v3 l=x_dut_xm59_l m=x_dut_xm59_m w=x_dut_xm59_w
XM6 net050 VOUTN vdd vdd pfet_03v3 l=x_dut_xm6_l m=x_dut_xm6_m w=x_dut_xm6_w
XM60 net2 VB3 net3 vss nfet_03v3 l=x_dut_xm60_l m=x_dut_xm60_m w=x_dut_xm60_w
XM61 net3 VB4 vss vss nfet_03v3 l=x_dut_xm61_l m=x_dut_xm61_m w=x_dut_xm61_w
XM62 net050 net2 vdd vdd pfet_03v3 l=x_dut_xm62_l m=x_dut_xm62_m w=x_dut_xm62_w
XM63 net050 VB3 net1 vss nfet_03v3 l=x_dut_xm63_l m=x_dut_xm63_m w=x_dut_xm63_w
XM64 net1 VB4 vss vss nfet_03v3 l=x_dut_xm64_l m=x_dut_xm64_m w=x_dut_xm64_w
XM7 net049 net013 vdd vdd pfet_03v3 l=x_dut_xm7_l m=x_dut_xm7_m w=x_dut_xm7_w
XM9 DM_2 VINN net31 net31 pfet_03v3 l=x_dut_xm9_l m=x_dut_xm9_m w=x_dut_xm9_w
.ends
.end
