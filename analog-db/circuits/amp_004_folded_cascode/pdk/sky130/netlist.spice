** GENERATED by `analog-db generate` — DO NOT EDIT. Source: abstract/netlist.spice → sky130
* amp_004_folded_cascode (emitted by spicexplorer-circuitgraph)
V1 vb1 vss x_dut_vb1
V2 vb2 vss x_dut_vb2
XM0 tail ibias vdd vdd sky130_fd_pr__pfet_01v8 l=x_dut_xm0_l m=x_dut_xm0_m nf=x_dut_xm0_ng w=x_dut_xm0_w
XM1 foldp vinp tail vdd sky130_fd_pr__pfet_01v8 l=x_dut_xm1_l m=x_dut_xm1_m nf=x_dut_xm1_ng w=x_dut_xm1_w
XM10 s10 cascp vdd vdd sky130_fd_pr__pfet_01v8 l=x_dut_xm10_l m=x_dut_xm10_m nf=x_dut_xm10_ng w=x_dut_xm10_w
XM11 ibias ibias vdd vdd sky130_fd_pr__pfet_01v8 l=x_dut_xm11_l m=x_dut_xm11_m nf=x_dut_xm11_ng w=x_dut_xm11_w
XM12 nbias ibias vdd vdd sky130_fd_pr__pfet_01v8 l=x_dut_xm12_l m=x_dut_xm12_m nf=x_dut_xm12_ng w=x_dut_xm12_w
XM13 nbias nbias vss vss sky130_fd_pr__nfet_01v8 l=x_dut_xm13_l m=x_dut_xm13_m nf=x_dut_xm13_ng w=x_dut_xm13_w
XM2 foldn vinn tail vdd sky130_fd_pr__pfet_01v8 l=x_dut_xm2_l m=x_dut_xm2_m nf=x_dut_xm2_ng w=x_dut_xm2_w
XM3 foldp nbias vss vss sky130_fd_pr__nfet_01v8 l=x_dut_xm3_l m=x_dut_xm3_m nf=x_dut_xm3_ng w=x_dut_xm3_w
XM4 foldn nbias vss vss sky130_fd_pr__nfet_01v8 l=x_dut_xm4_l m=x_dut_xm4_m nf=x_dut_xm4_ng w=x_dut_xm4_w
XM5 cascp vb1 foldp vss sky130_fd_pr__nfet_01v8 l=x_dut_xm5_l m=x_dut_xm5_m nf=x_dut_xm5_ng w=x_dut_xm5_w
XM6 vout vb1 foldn vss sky130_fd_pr__nfet_01v8 l=x_dut_xm6_l m=x_dut_xm6_m nf=x_dut_xm6_ng w=x_dut_xm6_w
XM7 cascp vb2 s9 vdd sky130_fd_pr__pfet_01v8 l=x_dut_xm7_l m=x_dut_xm7_m nf=x_dut_xm7_ng w=x_dut_xm7_w
XM8 vout vb2 s10 vdd sky130_fd_pr__pfet_01v8 l=x_dut_xm8_l m=x_dut_xm8_m nf=x_dut_xm8_ng w=x_dut_xm8_w
XM9 s9 cascp vdd vdd sky130_fd_pr__pfet_01v8 l=x_dut_xm9_l m=x_dut_xm9_m nf=x_dut_xm9_ng w=x_dut_xm9_w
.end
