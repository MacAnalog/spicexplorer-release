** GENERATED by `analog-db generate` — DO NOT EDIT. Source: abstract/netlist.spice → ihp-sg13g2
* sup_003_rrl_sc_integrator (emitted by spicexplorer-circuitgraph)
CAZ1 sum_p oa_inp 'x_dut_caz1_value'
CAZ2 sum_n oa_inn 'x_dut_caz2_value'
CINT1 sum_p int_p 'x_dut_cint1_value'
CINT2 sum_n int_n 'x_dut_cint2_value'
CIN_1 int_p int_n 'cin_val'
COUT_1 voutn voutp 'cout_val'
CS1 vinp sc_p 'x_dut_cs1_value'
CS2 vinn sc_n 'x_dut_cs2_value'
GM_1 voutn voutp int_p int_n {gm_val}
RIN_1 int_p int_n 'rin_val'
ROUT_1 voutn voutp 'rout_val'
VB1 vb1 vss dc {vb1}
VB2 vb2 vss dc {vb2}
VB3 vb3 vss dc {vb3}
VB4 vb4 vss dc {vb4}
XM10_OPAMP oa_outp vb1 oa_d1p vdd sg13_lv_pmos l=x_dut_xm10_opamp_l m=x_dut_xm10_opamp_m w=x_dut_xm10_opamp_w
XM11_OPAMP oa_outn vb2 oa_csrc_n vss sg13_lv_nmos l=x_dut_xm11_opamp_l m=x_dut_xm11_opamp_m w=x_dut_xm11_opamp_w
XM12_OPAMP oa_outp vb2 oa_csrc_p vss sg13_lv_nmos l=x_dut_xm12_opamp_l m=x_dut_xm12_opamp_m w=x_dut_xm12_opamp_w
XM13_OPAMP oa_csrc_n oa_cm_bias vss vss sg13_lv_nmos l=x_dut_xm13_opamp_l m=x_dut_xm13_opamp_m w=x_dut_xm13_opamp_w
XM14_OPAMP oa_csrc_p oa_cm_bias vss vss sg13_lv_nmos l=x_dut_xm14_opamp_l m=x_dut_xm14_opamp_m w=x_dut_xm14_opamp_w
XM15_OPAMP oa_cm_bias oa_cm_bias vss vss sg13_lv_nmos l=x_dut_xm15_opamp_l m=x_dut_xm15_opamp_m w=x_dut_xm15_opamp_w
XM16_OPAMP oa_cm_sense oa_cm_sense vss vss sg13_lv_nmos l=x_dut_xm16_opamp_l m=x_dut_xm16_opamp_m w=x_dut_xm16_opamp_w
XM1_CHRRL_1 sum_p clk_ch_rrl sc_p vss sg13_lv_nmos l=x_dut_xm1_chrrl_1_l m=x_dut_xm1_chrrl_1_m w=x_dut_xm1_chrrl_1_w
XM1_CHRRL_2 sum_n clk_ch_rrl sc_n vss sg13_lv_nmos l=x_dut_xm1_chrrl_2_l m=x_dut_xm1_chrrl_2_m w=x_dut_xm1_chrrl_2_w
XM1_CHRRL_3 sum_p clk_ch_rrl_not sc_n vss sg13_lv_nmos l=x_dut_xm1_chrrl_3_l m=x_dut_xm1_chrrl_3_m w=x_dut_xm1_chrrl_3_w
XM1_CHRRL_4 sum_n clk_ch_rrl_not sc_p vss sg13_lv_nmos l=x_dut_xm1_chrrl_4_l m=x_dut_xm1_chrrl_4_m w=x_dut_xm1_chrrl_4_w
XM1_OPAMP oa_tail vb3 vdd vdd sg13_lv_pmos l=x_dut_xm1_opamp_l m=x_dut_xm1_opamp_m w=x_dut_xm1_opamp_w
XM1_S1 sc_n clk_phi_2 vss vss sg13_lv_nmos l=x_dut_xm1_s1_l m=x_dut_xm1_s1_m w=x_dut_xm1_s1_w
XM1_S2 sc_p clk_phi_2 vss vss sg13_lv_nmos l=x_dut_xm1_s2_l m=x_dut_xm1_s2_m w=x_dut_xm1_s2_w
XM1_S3 oa_inp clk_phi_2 oa_outn vss sg13_lv_nmos l=x_dut_xm1_s3_l m=x_dut_xm1_s3_m w=x_dut_xm1_s3_w
XM1_S4 oa_inn clk_phi_2 oa_outp vss sg13_lv_nmos l=x_dut_xm1_s4_l m=x_dut_xm1_s4_m w=x_dut_xm1_s4_w
XM1_S5 oa_outn clk_phi_1 int_p vss sg13_lv_nmos l=x_dut_xm1_s5_l m=x_dut_xm1_s5_m w=x_dut_xm1_s5_w
XM1_S6 oa_outp clk_phi_1 int_n vss sg13_lv_nmos l=x_dut_xm1_s6_l m=x_dut_xm1_s6_m w=x_dut_xm1_s6_w
XM2_CHRRL_1 sc_p clk_ch_rrl_not sum_p vdd sg13_lv_pmos l=x_dut_xm2_chrrl_1_l m=x_dut_xm2_chrrl_1_m w=x_dut_xm2_chrrl_1_w
XM2_CHRRL_2 sc_n clk_ch_rrl_not sum_n vdd sg13_lv_pmos l=x_dut_xm2_chrrl_2_l m=x_dut_xm2_chrrl_2_m w=x_dut_xm2_chrrl_2_w
XM2_CHRRL_3 sc_n clk_ch_rrl sum_p vdd sg13_lv_pmos l=x_dut_xm2_chrrl_3_l m=x_dut_xm2_chrrl_3_m w=x_dut_xm2_chrrl_3_w
XM2_CHRRL_4 sc_p clk_ch_rrl sum_n vdd sg13_lv_pmos l=x_dut_xm2_chrrl_4_l m=x_dut_xm2_chrrl_4_m w=x_dut_xm2_chrrl_4_w
XM2_OPAMP oa_d1n oa_inp oa_tail vdd sg13_lv_pmos l=x_dut_xm2_opamp_l m=x_dut_xm2_opamp_m w=x_dut_xm2_opamp_w
XM2_S1 vss clk_phi_1 sc_n vdd sg13_lv_pmos l=x_dut_xm2_s1_l m=x_dut_xm2_s1_m w=x_dut_xm2_s1_w
XM2_S2 vss clk_phi_1 sc_p vdd sg13_lv_pmos l=x_dut_xm2_s2_l m=x_dut_xm2_s2_m w=x_dut_xm2_s2_w
XM2_S3 oa_outn clk_phi_1 oa_inp vdd sg13_lv_pmos l=x_dut_xm2_s3_l m=x_dut_xm2_s3_m w=x_dut_xm2_s3_w
XM2_S4 oa_outp clk_phi_1 oa_inn vdd sg13_lv_pmos l=x_dut_xm2_s4_l m=x_dut_xm2_s4_m w=x_dut_xm2_s4_w
XM2_S5 int_p clk_phi_2 oa_outn vdd sg13_lv_pmos l=x_dut_xm2_s5_l m=x_dut_xm2_s5_m w=x_dut_xm2_s5_w
XM2_S6 int_n clk_phi_2 oa_outp vdd sg13_lv_pmos l=x_dut_xm2_s6_l m=x_dut_xm2_s6_m w=x_dut_xm2_s6_w
XM3_OPAMP oa_d1p oa_inn oa_tail vdd sg13_lv_pmos l=x_dut_xm3_opamp_l m=x_dut_xm3_opamp_m w=x_dut_xm3_opamp_w
XM4_OPAMP oa_cm_tail vb3 vdd vdd sg13_lv_pmos l=x_dut_xm4_opamp_l m=x_dut_xm4_opamp_m w=x_dut_xm4_opamp_w
XM5_OPAMP oa_cm_sense oa_outn oa_cm_tail vdd sg13_lv_pmos l=x_dut_xm5_opamp_l m=x_dut_xm5_opamp_m w=x_dut_xm5_opamp_w
XM6_OPAMP oa_cm_bias vb4 oa_cm_tail vdd sg13_lv_pmos l=x_dut_xm6_opamp_l m=x_dut_xm6_opamp_m w=x_dut_xm6_opamp_w
XM7_OPAMP oa_cm_sense oa_outp oa_cm_tail vdd sg13_lv_pmos l=x_dut_xm7_opamp_l m=x_dut_xm7_opamp_m w=x_dut_xm7_opamp_w
XM8_OPAMP oa_cm_bias vb4 oa_cm_tail vdd sg13_lv_pmos l=x_dut_xm8_opamp_l m=x_dut_xm8_opamp_m w=x_dut_xm8_opamp_w
XM9_OPAMP oa_outn vb1 oa_d1n vdd sg13_lv_pmos l=x_dut_xm9_opamp_l m=x_dut_xm9_opamp_m w=x_dut_xm9_opamp_w
.end
