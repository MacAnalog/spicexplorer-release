** GENERATED by `analog-db export-raw` — DO NOT EDIT.
** circuit=ia_004_fan_chopper_rrl  class=ia  pdk=ihp-sg13g2  testbench=dc_op  corner=tt
** Self-contained deck: testbench + bound params + lowered DUT (.subckt ia_004_fan_chopper_rrl).
** PDK corner libs resolve by BARE NAME on the image's ngspice sourcepath — run in a
** PDK-enabled env (the base image / api container), NOT a bare host:
**   docker run --rm -i spicexplorer-spice-base:local \
**     bash -lc 'd=$(mktemp -d) && cat > $d/c.spice && cd $d && ngspice -b c.spice' < raw/ia_004_fan_chopper_rrl/ihp-sg13g2/dc_op.spice
*----------------------------------------------------------*
** params: 70 free + 27 frozen knobs (sizing.yaml) · 155 tied · 0 ratio-derived (abstract/params.yaml) · 2 testbench params
** AUTHORED TEMPLATE - ia/dc_op_chopper_rrl .
** dc_op_chopper_diff PLUS the two SC-phase sources. Split out rather than added to the base so the
** non-RRL chopper IAs (ia_002 / ia_003), whose port list has no clk_phi_1/clk_phi_2,
** keep rendering unchanged; an RRL composite selects this via `template:` in its
** analyses/<id>.yaml. Everything else - stimulus, clock freeze, measures - is identical
** to dc_op_chopper_diff, which stays the reference.
.lib cornerMOSlv.lib mos_tt
.temp 27

.param VDD=1.2
.param VCM=0.6

Vdd  vdd 0 dc {VDD}
Vss  vss 0 dc 0
Vref vref 0 dc {VCM}
Vcm  vcm 0 dc {VCM}
Vinp vinp vcm dc 0
Vinn vinn vcm dc 0

* clocks held transparent
Vck_in_a  clk_chin      0 dc {VDD}
Vck_in_b  clk_chin_not  0 dc 0
Vck_fb_a  clk_chfb      0 dc {VDD}
Vck_fb_b  clk_chfb_not  0 dc 0
Vck_out_a clk_chout     0 dc {VDD}
Vck_out_b clk_chout_not 0 dc 0
Vck_pf_a  clk_chpf      0 dc {VDD}
Vck_pf_b  clk_chpf_not  0 dc 0

* SC phase pins DRIVEN (phi_1 high = integrate-connected). Without these the RRL's
* SC switch gates float and the ripple-reduction loop is INERT - the frozen figures
* then describe the CCIA with the RRL disconnected, not the RRL-connected loop.
Vphi1s clk_phi_1 0 dc {VDD}
Vphi2s clk_phi_2 0 dc 0

XDUT vinp vinn voutp voutn vref clk_chin clk_chin_not clk_chfb clk_chfb_not clk_chout clk_chout_not clk_phi_1 clk_phi_2 vdd vss ia_004_fan_chopper_rrl

.control
  set filetype=ascii
  op
  let i_supply = abs(i(Vdd))
  let vos = v(voutp) - v(voutn)
  let vocm = (v(voutp) + v(voutn))/2
  print i_supply vos vocm
  write
  quit
.endc
.param x_dut_xm1_main_w=20u
.param x_dut_xm1_main_l=1u
.param x_dut_xm2_main_w=20u
.param x_dut_xm2_main_l=0.5u
.param x_dut_xm4_main_w=4.7u
.param x_dut_xm4_main_l=1u
.param x_dut_xm6_main_w=10u
.param x_dut_xm8_main_w=6.2u
.param x_dut_xm10_main_w=10u
.param x_dut_xm10_main_l=0.3u
.param x_dut_xm12_main_w=5u
.param x_dut_xm12_main_l=0.3u
.param x_dut_xm14_main_w=6u
.param x_dut_xm14_main_l=0.5u
.param x_dut_xm16_main_w=2u
.param x_dut_xm16_main_l=0.13u
.param x_dut_xm17_main_w=2u
.param x_dut_xm17_main_l=0.13u
.param x_dut_xm20_main_w=2u
.param x_dut_xm20_main_l=0.13u
.param x_dut_xm21_main_w=2u
.param x_dut_xm21_main_l=0.13u
.param x_dut_xm24_main_w=2u
.param x_dut_xm24_main_l=0.13u
.param x_dut_xm25_main_w=2u
.param x_dut_xm25_main_l=0.13u
.param x_dut_cin1_main_value=16p
.param x_dut_cfb1_main_value=0.8p
.param x_dut_cm1_main_value=1p
.param x_dut_rb1_main_value=10Meg
.param vb1_main=0.5
.param vb2_main=0.75
.param vb3_main=0.45
.param vb4_main=0.55
.param x_dut_xm1_main_m=1
.param x_dut_xm2_main_m=1
.param x_dut_xm4_main_m=1
.param x_dut_xm6_main_m=1
.param x_dut_xm8_main_m=1
.param x_dut_xm10_main_m=1
.param x_dut_xm12_main_m=1
.param x_dut_xm14_main_m=1
.param x_dut_xm16_main_m=1
.param x_dut_xm17_main_m=1
.param x_dut_xm20_main_m=1
.param x_dut_xm21_main_m=1
.param x_dut_xm24_main_m=1
.param x_dut_xm25_main_m=1
.param x_dut_xm1_opamp_rrl_w=20u
.param x_dut_xm1_opamp_rrl_l=1u
.param x_dut_xm2_opamp_rrl_w=20u
.param x_dut_xm2_opamp_rrl_l=0.5u
.param x_dut_xm4_opamp_rrl_w=10u
.param x_dut_xm5_opamp_rrl_w=4u
.param x_dut_xm5_opamp_rrl_l=0.5u
.param x_dut_xm6_opamp_rrl_w=4u
.param x_dut_xm6_opamp_rrl_l=0.5u
.param x_dut_xm9_opamp_rrl_w=10u
.param x_dut_xm9_opamp_rrl_l=0.3u
.param x_dut_xm11_opamp_rrl_w=5u
.param x_dut_xm11_opamp_rrl_l=0.3u
.param x_dut_xm13_opamp_rrl_w=6u
.param x_dut_xm15_opamp_rrl_w=2u
.param x_dut_xm15_opamp_rrl_l=1u
.param x_dut_xm1_s1_rrl_w=2u
.param x_dut_xm1_s1_rrl_l=0.13u
.param x_dut_xm2_s1_rrl_w=2u
.param x_dut_xm2_s1_rrl_l=0.13u
.param x_dut_xm1_chrrl_1_rrl_w=2u
.param x_dut_xm1_chrrl_1_rrl_l=0.13u
.param x_dut_xm2_chrrl_1_rrl_w=2u
.param x_dut_xm2_chrrl_1_rrl_l=0.13u
.param x_dut_cs1_rrl_value=1p
.param x_dut_caz1_rrl_value=1p
.param x_dut_cint1_rrl_value=4p
.param gm_val_rrl=10u
.param rout_val_rrl=10Meg
.param cout_val_rrl=100f
.param rin_val_rrl=1T
.param cin_val_rrl=10f
.param vb1_rrl=0.45
.param vb2_rrl=0.75
.param vb3_rrl=0.55
.param vb4_rrl=0.6
.param x_dut_xm1_opamp_rrl_m=1
.param x_dut_xm2_opamp_rrl_m=1
.param x_dut_xm4_opamp_rrl_m=1
.param x_dut_xm5_opamp_rrl_m=1
.param x_dut_xm6_opamp_rrl_m=1
.param x_dut_xm9_opamp_rrl_m=1
.param x_dut_xm11_opamp_rrl_m=1
.param x_dut_xm13_opamp_rrl_m=1
.param x_dut_xm15_opamp_rrl_m=1
.param x_dut_xm1_s1_rrl_m=1
.param x_dut_xm2_s1_rrl_m=1
.param x_dut_xm1_chrrl_1_rrl_m=1
.param x_dut_xm2_chrrl_1_rrl_m=1
* ---- GENERATED parameter ties (abstract/params.yaml groups/ratios) ----
* Each tied symbol is defined exactly once, by its line below; rewrite that
* .param to untie just that symbol (untying = shadowing, plan D-3).
.param x_dut_xm3_main_w = {x_dut_xm2_main_w}
.param x_dut_xm3_main_l = {x_dut_xm2_main_l}
.param x_dut_xm3_main_m = {x_dut_xm2_main_m}
.param x_dut_xm5_main_w = {x_dut_xm4_main_w}
.param x_dut_xm5_main_l = {x_dut_xm4_main_l}
.param x_dut_xm5_main_m = {x_dut_xm4_main_m}
.param x_dut_xm13_main_w = {x_dut_xm12_main_w}
.param x_dut_xm13_main_l = {x_dut_xm12_main_l}
.param x_dut_xm13_main_m = {x_dut_xm12_main_m}
.param x_dut_xm11_main_w = {x_dut_xm10_main_w}
.param x_dut_xm11_main_l = {x_dut_xm10_main_l}
.param x_dut_xm11_main_m = {x_dut_xm10_main_m}
.param x_dut_xm7_main_w = {x_dut_xm6_main_w}
.param x_dut_xm7_main_m = {x_dut_xm6_main_m}
.param x_dut_xm9_main_w = {x_dut_xm8_main_w}
.param x_dut_xm9_main_m = {x_dut_xm8_main_m}
.param x_dut_xm6_main_l = {x_dut_xm1_main_l}
.param x_dut_xm7_main_l = {x_dut_xm1_main_l}
.param x_dut_xm8_main_l = {x_dut_xm1_main_l}
.param x_dut_xm9_main_l = {x_dut_xm1_main_l}
.param x_dut_xm15_main_w = {x_dut_xm14_main_w}
.param x_dut_xm15_main_l = {x_dut_xm14_main_l}
.param x_dut_xm15_main_m = {x_dut_xm14_main_m}
.param x_dut_xm18_main_w = {x_dut_xm16_main_w}
.param x_dut_xm28_main_w = {x_dut_xm16_main_w}
.param x_dut_xm30_main_w = {x_dut_xm16_main_w}
.param x_dut_xm18_main_l = {x_dut_xm16_main_l}
.param x_dut_xm28_main_l = {x_dut_xm16_main_l}
.param x_dut_xm30_main_l = {x_dut_xm16_main_l}
.param x_dut_xm18_main_m = {x_dut_xm16_main_m}
.param x_dut_xm28_main_m = {x_dut_xm16_main_m}
.param x_dut_xm30_main_m = {x_dut_xm16_main_m}
.param x_dut_xm19_main_w = {x_dut_xm17_main_w}
.param x_dut_xm29_main_w = {x_dut_xm17_main_w}
.param x_dut_xm31_main_w = {x_dut_xm17_main_w}
.param x_dut_xm19_main_l = {x_dut_xm17_main_l}
.param x_dut_xm29_main_l = {x_dut_xm17_main_l}
.param x_dut_xm31_main_l = {x_dut_xm17_main_l}
.param x_dut_xm19_main_m = {x_dut_xm17_main_m}
.param x_dut_xm29_main_m = {x_dut_xm17_main_m}
.param x_dut_xm31_main_m = {x_dut_xm17_main_m}
.param x_dut_xm26_main_w = {x_dut_xm24_main_w}
.param x_dut_xm32_main_w = {x_dut_xm24_main_w}
.param x_dut_xm34_main_w = {x_dut_xm24_main_w}
.param x_dut_xm26_main_l = {x_dut_xm24_main_l}
.param x_dut_xm32_main_l = {x_dut_xm24_main_l}
.param x_dut_xm34_main_l = {x_dut_xm24_main_l}
.param x_dut_xm26_main_m = {x_dut_xm24_main_m}
.param x_dut_xm32_main_m = {x_dut_xm24_main_m}
.param x_dut_xm34_main_m = {x_dut_xm24_main_m}
.param x_dut_xm27_main_w = {x_dut_xm25_main_w}
.param x_dut_xm33_main_w = {x_dut_xm25_main_w}
.param x_dut_xm35_main_w = {x_dut_xm25_main_w}
.param x_dut_xm27_main_l = {x_dut_xm25_main_l}
.param x_dut_xm33_main_l = {x_dut_xm25_main_l}
.param x_dut_xm35_main_l = {x_dut_xm25_main_l}
.param x_dut_xm27_main_m = {x_dut_xm25_main_m}
.param x_dut_xm33_main_m = {x_dut_xm25_main_m}
.param x_dut_xm35_main_m = {x_dut_xm25_main_m}
.param x_dut_xm22_main_w = {x_dut_xm20_main_w}
.param x_dut_xm36_main_w = {x_dut_xm20_main_w}
.param x_dut_xm38_main_w = {x_dut_xm20_main_w}
.param x_dut_xm22_main_l = {x_dut_xm20_main_l}
.param x_dut_xm36_main_l = {x_dut_xm20_main_l}
.param x_dut_xm38_main_l = {x_dut_xm20_main_l}
.param x_dut_xm22_main_m = {x_dut_xm20_main_m}
.param x_dut_xm36_main_m = {x_dut_xm20_main_m}
.param x_dut_xm38_main_m = {x_dut_xm20_main_m}
.param x_dut_xm23_main_w = {x_dut_xm21_main_w}
.param x_dut_xm37_main_w = {x_dut_xm21_main_w}
.param x_dut_xm39_main_w = {x_dut_xm21_main_w}
.param x_dut_xm23_main_l = {x_dut_xm21_main_l}
.param x_dut_xm37_main_l = {x_dut_xm21_main_l}
.param x_dut_xm39_main_l = {x_dut_xm21_main_l}
.param x_dut_xm23_main_m = {x_dut_xm21_main_m}
.param x_dut_xm37_main_m = {x_dut_xm21_main_m}
.param x_dut_xm39_main_m = {x_dut_xm21_main_m}
.param x_dut_cin2_main_value = {x_dut_cin1_main_value}
.param x_dut_cfb2_main_value = {x_dut_cfb1_main_value}
.param x_dut_cm2_main_value = {x_dut_cm1_main_value}
.param x_dut_rb2_main_value = {x_dut_rb1_main_value}
.param x_dut_xm13_opamp_rrl_l = {x_dut_xm15_opamp_rrl_l}
.param x_dut_xm14_opamp_rrl_l = {x_dut_xm15_opamp_rrl_l}
.param x_dut_xm3_opamp_rrl_w = {x_dut_xm2_opamp_rrl_w}
.param x_dut_xm3_opamp_rrl_l = {x_dut_xm2_opamp_rrl_l}
.param x_dut_xm3_opamp_rrl_m = {x_dut_xm2_opamp_rrl_m}
.param x_dut_xm10_opamp_rrl_w = {x_dut_xm9_opamp_rrl_w}
.param x_dut_xm10_opamp_rrl_l = {x_dut_xm9_opamp_rrl_l}
.param x_dut_xm10_opamp_rrl_m = {x_dut_xm9_opamp_rrl_m}
.param x_dut_xm12_opamp_rrl_w = {x_dut_xm11_opamp_rrl_w}
.param x_dut_xm12_opamp_rrl_l = {x_dut_xm11_opamp_rrl_l}
.param x_dut_xm12_opamp_rrl_m = {x_dut_xm11_opamp_rrl_m}
.param x_dut_xm14_opamp_rrl_w = {x_dut_xm13_opamp_rrl_w}
.param x_dut_xm14_opamp_rrl_m = {x_dut_xm13_opamp_rrl_m}
.param x_dut_xm7_opamp_rrl_w = {x_dut_xm5_opamp_rrl_w}
.param x_dut_xm7_opamp_rrl_l = {x_dut_xm5_opamp_rrl_l}
.param x_dut_xm7_opamp_rrl_m = {x_dut_xm5_opamp_rrl_m}
.param x_dut_xm8_opamp_rrl_w = {x_dut_xm6_opamp_rrl_w}
.param x_dut_xm8_opamp_rrl_l = {x_dut_xm6_opamp_rrl_l}
.param x_dut_xm8_opamp_rrl_m = {x_dut_xm6_opamp_rrl_m}
.param x_dut_xm16_opamp_rrl_w = {x_dut_xm15_opamp_rrl_w}
.param x_dut_xm16_opamp_rrl_l = {x_dut_xm15_opamp_rrl_l}
.param x_dut_xm16_opamp_rrl_m = {x_dut_xm15_opamp_rrl_m}
.param x_dut_xm4_opamp_rrl_l = {x_dut_xm1_opamp_rrl_l}
.param x_dut_cs2_rrl_value = {x_dut_cs1_rrl_value}
.param x_dut_caz2_rrl_value = {x_dut_caz1_rrl_value}
.param x_dut_cint2_rrl_value = {x_dut_cint1_rrl_value}
.param x_dut_xm1_s2_rrl_w = {x_dut_xm1_s1_rrl_w}
.param x_dut_xm1_s3_rrl_w = {x_dut_xm1_s1_rrl_w}
.param x_dut_xm1_s4_rrl_w = {x_dut_xm1_s1_rrl_w}
.param x_dut_xm1_s5_rrl_w = {x_dut_xm1_s1_rrl_w}
.param x_dut_xm1_s6_rrl_w = {x_dut_xm1_s1_rrl_w}
.param x_dut_xm1_s2_rrl_l = {x_dut_xm1_s1_rrl_l}
.param x_dut_xm1_s3_rrl_l = {x_dut_xm1_s1_rrl_l}
.param x_dut_xm1_s4_rrl_l = {x_dut_xm1_s1_rrl_l}
.param x_dut_xm1_s5_rrl_l = {x_dut_xm1_s1_rrl_l}
.param x_dut_xm1_s6_rrl_l = {x_dut_xm1_s1_rrl_l}
.param x_dut_xm1_s2_rrl_m = {x_dut_xm1_s1_rrl_m}
.param x_dut_xm1_s3_rrl_m = {x_dut_xm1_s1_rrl_m}
.param x_dut_xm1_s4_rrl_m = {x_dut_xm1_s1_rrl_m}
.param x_dut_xm1_s5_rrl_m = {x_dut_xm1_s1_rrl_m}
.param x_dut_xm1_s6_rrl_m = {x_dut_xm1_s1_rrl_m}
.param x_dut_xm2_s2_rrl_w = {x_dut_xm2_s1_rrl_w}
.param x_dut_xm2_s3_rrl_w = {x_dut_xm2_s1_rrl_w}
.param x_dut_xm2_s4_rrl_w = {x_dut_xm2_s1_rrl_w}
.param x_dut_xm2_s5_rrl_w = {x_dut_xm2_s1_rrl_w}
.param x_dut_xm2_s6_rrl_w = {x_dut_xm2_s1_rrl_w}
.param x_dut_xm2_s2_rrl_l = {x_dut_xm2_s1_rrl_l}
.param x_dut_xm2_s3_rrl_l = {x_dut_xm2_s1_rrl_l}
.param x_dut_xm2_s4_rrl_l = {x_dut_xm2_s1_rrl_l}
.param x_dut_xm2_s5_rrl_l = {x_dut_xm2_s1_rrl_l}
.param x_dut_xm2_s6_rrl_l = {x_dut_xm2_s1_rrl_l}
.param x_dut_xm2_s2_rrl_m = {x_dut_xm2_s1_rrl_m}
.param x_dut_xm2_s3_rrl_m = {x_dut_xm2_s1_rrl_m}
.param x_dut_xm2_s4_rrl_m = {x_dut_xm2_s1_rrl_m}
.param x_dut_xm2_s5_rrl_m = {x_dut_xm2_s1_rrl_m}
.param x_dut_xm2_s6_rrl_m = {x_dut_xm2_s1_rrl_m}
.param x_dut_xm1_chrrl_2_rrl_w = {x_dut_xm1_chrrl_1_rrl_w}
.param x_dut_xm1_chrrl_3_rrl_w = {x_dut_xm1_chrrl_1_rrl_w}
.param x_dut_xm1_chrrl_4_rrl_w = {x_dut_xm1_chrrl_1_rrl_w}
.param x_dut_xm1_chrrl_2_rrl_l = {x_dut_xm1_chrrl_1_rrl_l}
.param x_dut_xm1_chrrl_3_rrl_l = {x_dut_xm1_chrrl_1_rrl_l}
.param x_dut_xm1_chrrl_4_rrl_l = {x_dut_xm1_chrrl_1_rrl_l}
.param x_dut_xm1_chrrl_2_rrl_m = {x_dut_xm1_chrrl_1_rrl_m}
.param x_dut_xm1_chrrl_3_rrl_m = {x_dut_xm1_chrrl_1_rrl_m}
.param x_dut_xm1_chrrl_4_rrl_m = {x_dut_xm1_chrrl_1_rrl_m}
.param x_dut_xm2_chrrl_2_rrl_w = {x_dut_xm2_chrrl_1_rrl_w}
.param x_dut_xm2_chrrl_3_rrl_w = {x_dut_xm2_chrrl_1_rrl_w}
.param x_dut_xm2_chrrl_4_rrl_w = {x_dut_xm2_chrrl_1_rrl_w}
.param x_dut_xm2_chrrl_2_rrl_l = {x_dut_xm2_chrrl_1_rrl_l}
.param x_dut_xm2_chrrl_3_rrl_l = {x_dut_xm2_chrrl_1_rrl_l}
.param x_dut_xm2_chrrl_4_rrl_l = {x_dut_xm2_chrrl_1_rrl_l}
.param x_dut_xm2_chrrl_2_rrl_m = {x_dut_xm2_chrrl_1_rrl_m}
.param x_dut_xm2_chrrl_3_rrl_m = {x_dut_xm2_chrrl_1_rrl_m}
.param x_dut_xm2_chrrl_4_rrl_m = {x_dut_xm2_chrrl_1_rrl_m}
.subckt ia_004_fan_chopper_rrl vinp vinn voutp voutn vref clk_chin clk_chin_not clk_chfb clk_chfb_not clk_chout clk_chout_not clk_phi_1 clk_phi_2 vdd vss
CAZ1_RRL rrl__sum_p rrl__oa_inp 'x_dut_caz1_rrl_value'
CAZ2_RRL rrl__sum_n rrl__oa_inn 'x_dut_caz2_rrl_value'
CFB1_MAIN main__fbch_p main__vsum_n 'x_dut_cfb1_main_value'
CFB2_MAIN main__fbch_n main__vsum_p 'x_dut_cfb2_main_value'
CIN1_MAIN main__vsum_n main__inch_n 'x_dut_cin1_main_value'
CIN2_MAIN main__vsum_p main__inch_p 'x_dut_cin2_main_value'
CINT1_RRL rrl__sum_p rrl__int_p 'x_dut_cint1_rrl_value'
CINT2_RRL rrl__sum_n rrl__int_n 'x_dut_cint2_rrl_value'
CIN_1_RRL rrl__int_p rrl__int_n 'cin_val_rrl'
CM1_MAIN main__g2_p voutp 'x_dut_cm1_main_value'
CM2_MAIN main__g2_n voutn 'x_dut_cm2_main_value'
COUT_1_RRL out1_p out1_n 'cout_val_rrl'
CS1_RRL voutp rrl__sc_p 'x_dut_cs1_rrl_value'
CS2_RRL voutn rrl__sc_n 'x_dut_cs2_rrl_value'
GM_1_RRL out1_p out1_n rrl__int_p rrl__int_n {gm_val_rrl}
RB1_MAIN main__vsum_n vref 'x_dut_rb1_main_value'
RB2_MAIN main__vsum_p vref 'x_dut_rb2_main_value'
RIN_1_RRL rrl__int_p rrl__int_n 'rin_val_rrl'
ROUT_1_RRL out1_p out1_n 'rout_val_rrl'
VB1_MAIN main__vb1 vss dc {vb1_main}
VB1_RRL rrl__vb1 vss dc {vb1_rrl}
VB2_MAIN main__vb2 vss dc {vb2_main}
VB2_RRL rrl__vb2 vss dc {vb2_rrl}
VB3_MAIN main__vb3 vss dc {vb3_main}
VB3_RRL rrl__vb3 vss dc {vb3_rrl}
VB4_MAIN main__vb4 vss dc {vb4_main}
VB4_RRL rrl__vb4 vss dc {vb4_rrl}
XM10_MAIN out1_n main__vb3 main__casc_src_n vdd sg13_lv_pmos l=x_dut_xm10_main_l m=x_dut_xm10_main_m w=x_dut_xm10_main_w
XM10_OPAMP_RRL rrl__oa_outp rrl__vb1 rrl__oa_d1p vdd sg13_lv_pmos l=x_dut_xm10_opamp_rrl_l m=x_dut_xm10_opamp_rrl_m w=x_dut_xm10_opamp_rrl_w
XM11_MAIN out1_p main__vb3 main__casc_src_p vdd sg13_lv_pmos l=x_dut_xm11_main_l m=x_dut_xm11_main_m w=x_dut_xm11_main_w
XM11_OPAMP_RRL rrl__oa_outn rrl__vb2 rrl__oa_csrc_n vss sg13_lv_nmos l=x_dut_xm11_opamp_rrl_l m=x_dut_xm11_opamp_rrl_m w=x_dut_xm11_opamp_rrl_w
XM12_MAIN out1_p main__vb2 main__fold_p vss sg13_lv_nmos l=x_dut_xm12_main_l m=x_dut_xm12_main_m w=x_dut_xm12_main_w
XM12_OPAMP_RRL rrl__oa_outp rrl__vb2 rrl__oa_csrc_p vss sg13_lv_nmos l=x_dut_xm12_opamp_rrl_l m=x_dut_xm12_opamp_rrl_m w=x_dut_xm12_opamp_rrl_w
XM13_MAIN out1_n main__vb2 main__fold_n vss sg13_lv_nmos l=x_dut_xm13_main_l m=x_dut_xm13_main_m w=x_dut_xm13_main_w
XM13_OPAMP_RRL rrl__oa_csrc_n rrl__oa_cm_bias vss vss sg13_lv_nmos l=x_dut_xm13_opamp_rrl_l m=x_dut_xm13_opamp_rrl_m w=x_dut_xm13_opamp_rrl_w
XM14_MAIN voutp main__g2_p vss vss sg13_lv_nmos l=x_dut_xm14_main_l m=x_dut_xm14_main_m w=x_dut_xm14_main_w
XM14_OPAMP_RRL rrl__oa_csrc_p rrl__oa_cm_bias vss vss sg13_lv_nmos l=x_dut_xm14_opamp_rrl_l m=x_dut_xm14_opamp_rrl_m w=x_dut_xm14_opamp_rrl_w
XM15_MAIN voutn main__g2_n vss vss sg13_lv_nmos l=x_dut_xm15_main_l m=x_dut_xm15_main_m w=x_dut_xm15_main_w
XM15_OPAMP_RRL rrl__oa_cm_bias rrl__oa_cm_bias vss vss sg13_lv_nmos l=x_dut_xm15_opamp_rrl_l m=x_dut_xm15_opamp_rrl_m w=x_dut_xm15_opamp_rrl_w
XM16_MAIN out1_n clk_chout main__g2_n vss sg13_lv_nmos l=x_dut_xm16_main_l m=x_dut_xm16_main_m w=x_dut_xm16_main_w
XM16_OPAMP_RRL rrl__oa_cm_sense rrl__oa_cm_sense vss vss sg13_lv_nmos l=x_dut_xm16_opamp_rrl_l m=x_dut_xm16_opamp_rrl_m w=x_dut_xm16_opamp_rrl_w
XM17_MAIN main__g2_n clk_chout_not out1_n vdd sg13_lv_pmos l=x_dut_xm17_main_l m=x_dut_xm17_main_m w=x_dut_xm17_main_w
XM18_MAIN out1_p clk_chout main__g2_p vss sg13_lv_nmos l=x_dut_xm18_main_l m=x_dut_xm18_main_m w=x_dut_xm18_main_w
XM19_MAIN main__g2_p clk_chout_not out1_p vdd sg13_lv_pmos l=x_dut_xm19_main_l m=x_dut_xm19_main_m w=x_dut_xm19_main_w
XM1_CHRRL_1_RRL rrl__sum_p clk_chout rrl__sc_p vss sg13_lv_nmos l=x_dut_xm1_chrrl_1_rrl_l m=x_dut_xm1_chrrl_1_rrl_m w=x_dut_xm1_chrrl_1_rrl_w
XM1_CHRRL_2_RRL rrl__sum_n clk_chout rrl__sc_n vss sg13_lv_nmos l=x_dut_xm1_chrrl_2_rrl_l m=x_dut_xm1_chrrl_2_rrl_m w=x_dut_xm1_chrrl_2_rrl_w
XM1_CHRRL_3_RRL rrl__sum_p clk_chout_not rrl__sc_n vss sg13_lv_nmos l=x_dut_xm1_chrrl_3_rrl_l m=x_dut_xm1_chrrl_3_rrl_m w=x_dut_xm1_chrrl_3_rrl_w
XM1_CHRRL_4_RRL rrl__sum_n clk_chout_not rrl__sc_p vss sg13_lv_nmos l=x_dut_xm1_chrrl_4_rrl_l m=x_dut_xm1_chrrl_4_rrl_m w=x_dut_xm1_chrrl_4_rrl_w
XM1_MAIN main__tail main__vb4 vdd vdd sg13_lv_pmos l=x_dut_xm1_main_l m=x_dut_xm1_main_m w=x_dut_xm1_main_w
XM1_OPAMP_RRL rrl__oa_tail rrl__vb3 vdd vdd sg13_lv_pmos l=x_dut_xm1_opamp_rrl_l m=x_dut_xm1_opamp_rrl_m w=x_dut_xm1_opamp_rrl_w
XM1_S1_RRL rrl__sc_n clk_phi_2 vss vss sg13_lv_nmos l=x_dut_xm1_s1_rrl_l m=x_dut_xm1_s1_rrl_m w=x_dut_xm1_s1_rrl_w
XM1_S2_RRL rrl__sc_p clk_phi_2 vss vss sg13_lv_nmos l=x_dut_xm1_s2_rrl_l m=x_dut_xm1_s2_rrl_m w=x_dut_xm1_s2_rrl_w
XM1_S3_RRL rrl__oa_inp clk_phi_2 rrl__oa_outn vss sg13_lv_nmos l=x_dut_xm1_s3_rrl_l m=x_dut_xm1_s3_rrl_m w=x_dut_xm1_s3_rrl_w
XM1_S4_RRL rrl__oa_inn clk_phi_2 rrl__oa_outp vss sg13_lv_nmos l=x_dut_xm1_s4_rrl_l m=x_dut_xm1_s4_rrl_m w=x_dut_xm1_s4_rrl_w
XM1_S5_RRL rrl__oa_outn clk_phi_1 rrl__int_p vss sg13_lv_nmos l=x_dut_xm1_s5_rrl_l m=x_dut_xm1_s5_rrl_m w=x_dut_xm1_s5_rrl_w
XM1_S6_RRL rrl__oa_outp clk_phi_1 rrl__int_n vss sg13_lv_nmos l=x_dut_xm1_s6_rrl_l m=x_dut_xm1_s6_rrl_m w=x_dut_xm1_s6_rrl_w
XM20_MAIN main__fbch_p clk_chfb voutp vss sg13_lv_nmos l=x_dut_xm20_main_l m=x_dut_xm20_main_m w=x_dut_xm20_main_w
XM21_MAIN voutp clk_chfb_not main__fbch_p vdd sg13_lv_pmos l=x_dut_xm21_main_l m=x_dut_xm21_main_m w=x_dut_xm21_main_w
XM22_MAIN main__fbch_n clk_chfb voutn vss sg13_lv_nmos l=x_dut_xm22_main_l m=x_dut_xm22_main_m w=x_dut_xm22_main_w
XM23_MAIN voutn clk_chfb_not main__fbch_n vdd sg13_lv_pmos l=x_dut_xm23_main_l m=x_dut_xm23_main_m w=x_dut_xm23_main_w
XM24_MAIN vinn clk_chin main__inch_n vss sg13_lv_nmos l=x_dut_xm24_main_l m=x_dut_xm24_main_m w=x_dut_xm24_main_w
XM25_MAIN main__inch_n clk_chin_not vinn vdd sg13_lv_pmos l=x_dut_xm25_main_l m=x_dut_xm25_main_m w=x_dut_xm25_main_w
XM26_MAIN vinp clk_chin main__inch_p vss sg13_lv_nmos l=x_dut_xm26_main_l m=x_dut_xm26_main_m w=x_dut_xm26_main_w
XM27_MAIN main__inch_p clk_chin_not vinp vdd sg13_lv_pmos l=x_dut_xm27_main_l m=x_dut_xm27_main_m w=x_dut_xm27_main_w
XM28_MAIN out1_n clk_chout_not main__g2_p vss sg13_lv_nmos l=x_dut_xm28_main_l m=x_dut_xm28_main_m w=x_dut_xm28_main_w
XM29_MAIN main__g2_p clk_chout out1_n vdd sg13_lv_pmos l=x_dut_xm29_main_l m=x_dut_xm29_main_m w=x_dut_xm29_main_w
XM2_CHRRL_1_RRL rrl__sc_p clk_chout_not rrl__sum_p vdd sg13_lv_pmos l=x_dut_xm2_chrrl_1_rrl_l m=x_dut_xm2_chrrl_1_rrl_m w=x_dut_xm2_chrrl_1_rrl_w
XM2_CHRRL_2_RRL rrl__sc_n clk_chout_not rrl__sum_n vdd sg13_lv_pmos l=x_dut_xm2_chrrl_2_rrl_l m=x_dut_xm2_chrrl_2_rrl_m w=x_dut_xm2_chrrl_2_rrl_w
XM2_CHRRL_3_RRL rrl__sc_n clk_chout rrl__sum_p vdd sg13_lv_pmos l=x_dut_xm2_chrrl_3_rrl_l m=x_dut_xm2_chrrl_3_rrl_m w=x_dut_xm2_chrrl_3_rrl_w
XM2_CHRRL_4_RRL rrl__sc_p clk_chout rrl__sum_n vdd sg13_lv_pmos l=x_dut_xm2_chrrl_4_rrl_l m=x_dut_xm2_chrrl_4_rrl_m w=x_dut_xm2_chrrl_4_rrl_w
XM2_MAIN main__fold_p main__vsum_p main__tail vdd sg13_lv_pmos l=x_dut_xm2_main_l m=x_dut_xm2_main_m w=x_dut_xm2_main_w
XM2_OPAMP_RRL rrl__oa_d1n rrl__oa_inp rrl__oa_tail vdd sg13_lv_pmos l=x_dut_xm2_opamp_rrl_l m=x_dut_xm2_opamp_rrl_m w=x_dut_xm2_opamp_rrl_w
XM2_S1_RRL vss clk_phi_1 rrl__sc_n vdd sg13_lv_pmos l=x_dut_xm2_s1_rrl_l m=x_dut_xm2_s1_rrl_m w=x_dut_xm2_s1_rrl_w
XM2_S2_RRL vss clk_phi_1 rrl__sc_p vdd sg13_lv_pmos l=x_dut_xm2_s2_rrl_l m=x_dut_xm2_s2_rrl_m w=x_dut_xm2_s2_rrl_w
XM2_S3_RRL rrl__oa_outn clk_phi_1 rrl__oa_inp vdd sg13_lv_pmos l=x_dut_xm2_s3_rrl_l m=x_dut_xm2_s3_rrl_m w=x_dut_xm2_s3_rrl_w
XM2_S4_RRL rrl__oa_outp clk_phi_1 rrl__oa_inn vdd sg13_lv_pmos l=x_dut_xm2_s4_rrl_l m=x_dut_xm2_s4_rrl_m w=x_dut_xm2_s4_rrl_w
XM2_S5_RRL rrl__int_p clk_phi_2 rrl__oa_outn vdd sg13_lv_pmos l=x_dut_xm2_s5_rrl_l m=x_dut_xm2_s5_rrl_m w=x_dut_xm2_s5_rrl_w
XM2_S6_RRL rrl__int_n clk_phi_2 rrl__oa_outp vdd sg13_lv_pmos l=x_dut_xm2_s6_rrl_l m=x_dut_xm2_s6_rrl_m w=x_dut_xm2_s6_rrl_w
XM30_MAIN out1_p clk_chout_not main__g2_n vss sg13_lv_nmos l=x_dut_xm30_main_l m=x_dut_xm30_main_m w=x_dut_xm30_main_w
XM31_MAIN main__g2_n clk_chout out1_p vdd sg13_lv_pmos l=x_dut_xm31_main_l m=x_dut_xm31_main_m w=x_dut_xm31_main_w
XM32_MAIN vinn clk_chin_not main__inch_p vss sg13_lv_nmos l=x_dut_xm32_main_l m=x_dut_xm32_main_m w=x_dut_xm32_main_w
XM33_MAIN main__inch_p clk_chin vinn vdd sg13_lv_pmos l=x_dut_xm33_main_l m=x_dut_xm33_main_m w=x_dut_xm33_main_w
XM34_MAIN vinp clk_chin_not main__inch_n vss sg13_lv_nmos l=x_dut_xm34_main_l m=x_dut_xm34_main_m w=x_dut_xm34_main_w
XM35_MAIN main__inch_n clk_chin vinp vdd sg13_lv_pmos l=x_dut_xm35_main_l m=x_dut_xm35_main_m w=x_dut_xm35_main_w
XM36_MAIN main__fbch_p clk_chfb_not voutn vss sg13_lv_nmos l=x_dut_xm36_main_l m=x_dut_xm36_main_m w=x_dut_xm36_main_w
XM37_MAIN voutn clk_chfb main__fbch_p vdd sg13_lv_pmos l=x_dut_xm37_main_l m=x_dut_xm37_main_m w=x_dut_xm37_main_w
XM38_MAIN main__fbch_n clk_chfb_not voutp vss sg13_lv_nmos l=x_dut_xm38_main_l m=x_dut_xm38_main_m w=x_dut_xm38_main_w
XM39_MAIN voutp clk_chfb main__fbch_n vdd sg13_lv_pmos l=x_dut_xm39_main_l m=x_dut_xm39_main_m w=x_dut_xm39_main_w
XM3_MAIN main__fold_n main__vsum_n main__tail vdd sg13_lv_pmos l=x_dut_xm3_main_l m=x_dut_xm3_main_m w=x_dut_xm3_main_w
XM3_OPAMP_RRL rrl__oa_d1p rrl__oa_inn rrl__oa_tail vdd sg13_lv_pmos l=x_dut_xm3_opamp_rrl_l m=x_dut_xm3_opamp_rrl_m w=x_dut_xm3_opamp_rrl_w
XM4_MAIN main__fold_p main__vb1 vss vss sg13_lv_nmos l=x_dut_xm4_main_l m=x_dut_xm4_main_m w=x_dut_xm4_main_w
XM4_OPAMP_RRL rrl__oa_cm_tail rrl__vb3 vdd vdd sg13_lv_pmos l=x_dut_xm4_opamp_rrl_l m=x_dut_xm4_opamp_rrl_m w=x_dut_xm4_opamp_rrl_w
XM5_MAIN main__fold_n main__vb1 vss vss sg13_lv_nmos l=x_dut_xm5_main_l m=x_dut_xm5_main_m w=x_dut_xm5_main_w
XM5_OPAMP_RRL rrl__oa_cm_sense rrl__oa_outn rrl__oa_cm_tail vdd sg13_lv_pmos l=x_dut_xm5_opamp_rrl_l m=x_dut_xm5_opamp_rrl_m w=x_dut_xm5_opamp_rrl_w
XM6_MAIN main__casc_src_n main__vb4 vdd vdd sg13_lv_pmos l=x_dut_xm6_main_l m=x_dut_xm6_main_m w=x_dut_xm6_main_w
XM6_OPAMP_RRL rrl__oa_cm_bias rrl__vb4 rrl__oa_cm_tail vdd sg13_lv_pmos l=x_dut_xm6_opamp_rrl_l m=x_dut_xm6_opamp_rrl_m w=x_dut_xm6_opamp_rrl_w
XM7_MAIN main__casc_src_p main__vb4 vdd vdd sg13_lv_pmos l=x_dut_xm7_main_l m=x_dut_xm7_main_m w=x_dut_xm7_main_w
XM7_OPAMP_RRL rrl__oa_cm_sense rrl__oa_outp rrl__oa_cm_tail vdd sg13_lv_pmos l=x_dut_xm7_opamp_rrl_l m=x_dut_xm7_opamp_rrl_m w=x_dut_xm7_opamp_rrl_w
XM8_MAIN voutp main__vb4 vdd vdd sg13_lv_pmos l=x_dut_xm8_main_l m=x_dut_xm8_main_m w=x_dut_xm8_main_w
XM8_OPAMP_RRL rrl__oa_cm_bias rrl__vb4 rrl__oa_cm_tail vdd sg13_lv_pmos l=x_dut_xm8_opamp_rrl_l m=x_dut_xm8_opamp_rrl_m w=x_dut_xm8_opamp_rrl_w
XM9_MAIN voutn main__vb4 vdd vdd sg13_lv_pmos l=x_dut_xm9_main_l m=x_dut_xm9_main_m w=x_dut_xm9_main_w
XM9_OPAMP_RRL rrl__oa_outn rrl__vb1 rrl__oa_d1n vdd sg13_lv_pmos l=x_dut_xm9_opamp_rrl_l m=x_dut_xm9_opamp_rrl_m w=x_dut_xm9_opamp_rrl_w
.ends
.end
