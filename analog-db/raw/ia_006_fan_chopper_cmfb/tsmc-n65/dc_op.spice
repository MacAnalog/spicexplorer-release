** GENERATED by `analog-db export-raw` — DO NOT EDIT.
** circuit=ia_006_fan_chopper_cmfb  class=ia  pdk=tsmc-n65  testbench=dc_op  corner=tt
** Self-contained deck: testbench + bound params + lowered DUT (.subckt ia_006_fan_chopper_cmfb).
** PDK corner libs resolve by BARE NAME on the image's ngspice sourcepath — run in a
** PDK-enabled env (the base image / api container), NOT a bare host:
**   docker run --rm -i spicexplorer-spice-base:local \
**     bash -lc 'd=$(mktemp -d) && cat > $d/c.spice && cd $d && ngspice -b c.spice' < raw/ia_006_fan_chopper_cmfb/tsmc-n65/dc_op.spice
*----------------------------------------------------------*
** params: 47 free + 19 frozen knobs (sizing.yaml) · 88 tied · 0 ratio-derived (abstract/params.yaml) · 2 testbench params
** AUTHORED TEMPLATE — ia/dc_op_chopper_diff (plan_hierarchical_composition P3).
** DC operating point for a chopper-subfamily IA with every chopper clock HELD in the
** transparent state (clk high / clk_not low): the network freezes to its
** straight-through configuration, giving a defined OP for i_supply / vos / vocm.
** (The clocked figures — ripple, residual offset, chopped gain — belong to
** tran_chopper_ripple; this bench only anchors the static bias point.)
**
** Assumes the chopper-IA port convention (extra driven clock nets are harmless):
**   .subckt <id> vinp vinn voutp voutn vref clk_chin clk_chin_not clk_chfb clk_chfb_not
**                clk_chout clk_chout_not [clk_chpf clk_chpf_not] vdd vss
** Required bindings: DUT PORT_LINE VDD VCM PDK_INCLUDE.
.lib tsmc_n65_models.scs tt
.temp 27

.param VDD=1.2
.param VCM=0.6

Vdd  vdd 0 dc {VDD}
Vss  vss 0 dc 0
Vref vref 0 dc {VCM}
Vcm  vcm 0 dc {VCM}
Vinp vinp vcm dc 0
Vinn vinn vcm dc 0

* clocks held transparent
Vck_in_a  clk_chin      0 dc {VDD}
Vck_in_b  clk_chin_not  0 dc 0
Vck_fb_a  clk_chfb      0 dc {VDD}
Vck_fb_b  clk_chfb_not  0 dc 0
Vck_out_a clk_chout     0 dc {VDD}
Vck_out_b clk_chout_not 0 dc 0
Vck_pf_a  clk_chpf      0 dc {VDD}
Vck_pf_b  clk_chpf_not  0 dc 0

XDUT vinp vinn voutp voutn vref clk_chin clk_chin_not clk_chfb clk_chfb_not clk_chout clk_chout_not vdd vss ia_006_fan_chopper_cmfb

.control
  set filetype=ascii
  op
  let i_supply = abs(i(Vdd))
  let vos = v(voutp) - v(voutn)
  let vocm = (v(voutp) + v(voutn))/2
  print i_supply vos vocm
  write
  quit
.endc
.param x_dut_xm4_cmfb_w=6.65u
.param x_dut_xm4_cmfb_l=1u
.param x_dut_xm2_cmfb_w=0.168u
.param x_dut_xm2_cmfb_l=6u
.param x_dut_xm1_cmfb_w=3.82u
.param x_dut_xm7_cmfb_w=0.180u
.param x_dut_xm7_cmfb_l=10u
.param x_dut_xm3_cmfb_w=1.91u
.param x_dut_xm3_cmfb_l=1u
.param x_dut_rmp_cmfb_value=1Meg
.param x_dut_xm1_cmfb_m=1
.param x_dut_xm2_cmfb_m=1
.param x_dut_xm3_cmfb_m=1
.param x_dut_xm4_cmfb_m=1
.param x_dut_xm7_cmfb_m=1
.param x_dut_xm1_core_w=5.629u
.param x_dut_xm1_core_l=1u
.param x_dut_xm2_core_w=4.933u
.param x_dut_xm2_core_l=0.5u
.param x_dut_xm4_core_w=2.51u
.param x_dut_xm4_core_l=1u
.param x_dut_xm6_core_w=2.814u
.param x_dut_xm10_core_w=2.398u
.param x_dut_xm10_core_l=0.3u
.param x_dut_xm12_core_w=0.792u
.param x_dut_xm12_core_l=0.3u
.param x_dut_xm14_core_w=1.043u
.param x_dut_xm14_core_l=0.25u
.param x_dut_xm16_core_w=2u
.param x_dut_xm16_core_l=0.13u
.param x_dut_xm17_core_w=2u
.param x_dut_xm17_core_l=0.13u
.param x_dut_xm20_core_w=2u
.param x_dut_xm20_core_l=0.13u
.param x_dut_xm21_core_w=2u
.param x_dut_xm21_core_l=0.13u
.param x_dut_xm24_core_w=2u
.param x_dut_xm24_core_l=0.13u
.param x_dut_xm25_core_w=2u
.param x_dut_xm25_core_l=0.13u
.param x_dut_cin1_core_value=16p
.param x_dut_cfb1_core_value=0.8p
.param x_dut_cm1_core_value=2p
.param x_dut_rb1_core_value=10Meg
.param vb1_core=0.324117
.param vb2_core=0.472198
.param vb3_core=0.438401
.param vb4_core=0.785955
.param x_dut_xm1_core_m=1
.param x_dut_xm2_core_m=1
.param x_dut_xm4_core_m=1
.param x_dut_xm6_core_m=1
.param x_dut_xm10_core_m=1
.param x_dut_xm12_core_m=1
.param x_dut_xm14_core_m=1
.param x_dut_xm16_core_m=1
.param x_dut_xm17_core_m=1
.param x_dut_xm20_core_m=1
.param x_dut_xm21_core_m=1
.param x_dut_xm24_core_m=1
.param x_dut_xm25_core_m=1
.param vcm_ref=0.6
.param x_dut_xm8o_w=11.257u
.param x_dut_xm8o_l=1u
.param x_dut_xm8o_m=1
.param c_cm=5p
* ---- GENERATED parameter ties (abstract/params.yaml groups/ratios) ----
* Each tied symbol is defined exactly once, by its line below; rewrite that
* .param to untie just that symbol (untying = shadowing, plan D-3).
.param x_dut_xm9o_w = {x_dut_xm8o_w}
.param x_dut_xm9o_l = {x_dut_xm8o_l}
.param x_dut_xm9o_m = {x_dut_xm8o_m}
.param x_dut_xm5_cmfb_w = {x_dut_xm4_cmfb_w}
.param x_dut_xm5_cmfb_l = {x_dut_xm4_cmfb_l}
.param x_dut_xm5_cmfb_m = {x_dut_xm4_cmfb_m}
.param x_dut_xm6_cmfb_w = {x_dut_xm2_cmfb_w}
.param x_dut_xm6_cmfb_l = {x_dut_xm2_cmfb_l}
.param x_dut_xm6_cmfb_m = {x_dut_xm2_cmfb_m}
.param x_dut_rmn_cmfb_value = {x_dut_rmp_cmfb_value}
.param x_dut_xm3_core_w = {x_dut_xm2_core_w}
.param x_dut_xm3_core_l = {x_dut_xm2_core_l}
.param x_dut_xm3_core_m = {x_dut_xm2_core_m}
.param x_dut_xm5_core_w = {x_dut_xm4_core_w}
.param x_dut_xm5_core_l = {x_dut_xm4_core_l}
.param x_dut_xm5_core_m = {x_dut_xm4_core_m}
.param x_dut_xm13_core_w = {x_dut_xm12_core_w}
.param x_dut_xm13_core_l = {x_dut_xm12_core_l}
.param x_dut_xm13_core_m = {x_dut_xm12_core_m}
.param x_dut_xm11_core_w = {x_dut_xm10_core_w}
.param x_dut_xm11_core_l = {x_dut_xm10_core_l}
.param x_dut_xm11_core_m = {x_dut_xm10_core_m}
.param x_dut_xm7_core_w = {x_dut_xm6_core_w}
.param x_dut_xm7_core_m = {x_dut_xm6_core_m}
.param x_dut_xm6_core_l = {x_dut_xm1_core_l}
.param x_dut_xm7_core_l = {x_dut_xm1_core_l}
.param x_dut_xm15_core_w = {x_dut_xm14_core_w}
.param x_dut_xm15_core_l = {x_dut_xm14_core_l}
.param x_dut_xm15_core_m = {x_dut_xm14_core_m}
.param x_dut_xm18_core_w = {x_dut_xm16_core_w}
.param x_dut_xm28_core_w = {x_dut_xm16_core_w}
.param x_dut_xm30_core_w = {x_dut_xm16_core_w}
.param x_dut_xm18_core_l = {x_dut_xm16_core_l}
.param x_dut_xm28_core_l = {x_dut_xm16_core_l}
.param x_dut_xm30_core_l = {x_dut_xm16_core_l}
.param x_dut_xm18_core_m = {x_dut_xm16_core_m}
.param x_dut_xm28_core_m = {x_dut_xm16_core_m}
.param x_dut_xm30_core_m = {x_dut_xm16_core_m}
.param x_dut_xm19_core_w = {x_dut_xm17_core_w}
.param x_dut_xm29_core_w = {x_dut_xm17_core_w}
.param x_dut_xm31_core_w = {x_dut_xm17_core_w}
.param x_dut_xm19_core_l = {x_dut_xm17_core_l}
.param x_dut_xm29_core_l = {x_dut_xm17_core_l}
.param x_dut_xm31_core_l = {x_dut_xm17_core_l}
.param x_dut_xm19_core_m = {x_dut_xm17_core_m}
.param x_dut_xm29_core_m = {x_dut_xm17_core_m}
.param x_dut_xm31_core_m = {x_dut_xm17_core_m}
.param x_dut_xm26_core_w = {x_dut_xm24_core_w}
.param x_dut_xm32_core_w = {x_dut_xm24_core_w}
.param x_dut_xm34_core_w = {x_dut_xm24_core_w}
.param x_dut_xm26_core_l = {x_dut_xm24_core_l}
.param x_dut_xm32_core_l = {x_dut_xm24_core_l}
.param x_dut_xm34_core_l = {x_dut_xm24_core_l}
.param x_dut_xm26_core_m = {x_dut_xm24_core_m}
.param x_dut_xm32_core_m = {x_dut_xm24_core_m}
.param x_dut_xm34_core_m = {x_dut_xm24_core_m}
.param x_dut_xm27_core_w = {x_dut_xm25_core_w}
.param x_dut_xm33_core_w = {x_dut_xm25_core_w}
.param x_dut_xm35_core_w = {x_dut_xm25_core_w}
.param x_dut_xm27_core_l = {x_dut_xm25_core_l}
.param x_dut_xm33_core_l = {x_dut_xm25_core_l}
.param x_dut_xm35_core_l = {x_dut_xm25_core_l}
.param x_dut_xm27_core_m = {x_dut_xm25_core_m}
.param x_dut_xm33_core_m = {x_dut_xm25_core_m}
.param x_dut_xm35_core_m = {x_dut_xm25_core_m}
.param x_dut_xm22_core_w = {x_dut_xm20_core_w}
.param x_dut_xm36_core_w = {x_dut_xm20_core_w}
.param x_dut_xm38_core_w = {x_dut_xm20_core_w}
.param x_dut_xm22_core_l = {x_dut_xm20_core_l}
.param x_dut_xm36_core_l = {x_dut_xm20_core_l}
.param x_dut_xm38_core_l = {x_dut_xm20_core_l}
.param x_dut_xm22_core_m = {x_dut_xm20_core_m}
.param x_dut_xm36_core_m = {x_dut_xm20_core_m}
.param x_dut_xm38_core_m = {x_dut_xm20_core_m}
.param x_dut_xm23_core_w = {x_dut_xm21_core_w}
.param x_dut_xm37_core_w = {x_dut_xm21_core_w}
.param x_dut_xm39_core_w = {x_dut_xm21_core_w}
.param x_dut_xm23_core_l = {x_dut_xm21_core_l}
.param x_dut_xm37_core_l = {x_dut_xm21_core_l}
.param x_dut_xm39_core_l = {x_dut_xm21_core_l}
.param x_dut_xm23_core_m = {x_dut_xm21_core_m}
.param x_dut_xm37_core_m = {x_dut_xm21_core_m}
.param x_dut_xm39_core_m = {x_dut_xm21_core_m}
.param x_dut_cin2_core_value = {x_dut_cin1_core_value}
.param x_dut_cfb2_core_value = {x_dut_cfb1_core_value}
.param x_dut_cm2_core_value = {x_dut_cm1_core_value}
.param x_dut_rb2_core_value = {x_dut_rb1_core_value}
.param x_dut_xm1_cmfb_l = {x_dut_xm3_cmfb_l}
.param x_dut_xm30_core_w = {x_dut_xm16_core_w}
.param x_dut_xm30_core_l = {x_dut_xm16_core_l}
.param x_dut_xm30_core_m = {x_dut_xm16_core_m}
.param x_dut_xm29_core_w = {x_dut_xm17_core_w}
.param x_dut_xm29_core_l = {x_dut_xm17_core_l}
.param x_dut_xm29_core_m = {x_dut_xm17_core_m}
.param x_dut_xm28_core_w = {x_dut_xm18_core_w}
.param x_dut_xm28_core_l = {x_dut_xm18_core_l}
.param x_dut_xm28_core_m = {x_dut_xm18_core_m}
.param x_dut_xm31_core_w = {x_dut_xm19_core_w}
.param x_dut_xm31_core_l = {x_dut_xm19_core_l}
.param x_dut_xm31_core_m = {x_dut_xm19_core_m}
.param x_dut_xm38_core_w = {x_dut_xm20_core_w}
.param x_dut_xm38_core_l = {x_dut_xm20_core_l}
.param x_dut_xm38_core_m = {x_dut_xm20_core_m}
.param x_dut_xm37_core_w = {x_dut_xm21_core_w}
.param x_dut_xm37_core_l = {x_dut_xm21_core_l}
.param x_dut_xm37_core_m = {x_dut_xm21_core_m}
.param x_dut_xm36_core_w = {x_dut_xm22_core_w}
.param x_dut_xm36_core_l = {x_dut_xm22_core_l}
.param x_dut_xm36_core_m = {x_dut_xm22_core_m}
.param x_dut_xm39_core_w = {x_dut_xm23_core_w}
.param x_dut_xm39_core_l = {x_dut_xm23_core_l}
.param x_dut_xm39_core_m = {x_dut_xm23_core_m}
.param x_dut_xm34_core_w = {x_dut_xm24_core_w}
.param x_dut_xm34_core_l = {x_dut_xm24_core_l}
.param x_dut_xm34_core_m = {x_dut_xm24_core_m}
.param x_dut_xm33_core_w = {x_dut_xm25_core_w}
.param x_dut_xm33_core_l = {x_dut_xm25_core_l}
.param x_dut_xm33_core_m = {x_dut_xm25_core_m}
.param x_dut_xm32_core_w = {x_dut_xm26_core_w}
.param x_dut_xm32_core_l = {x_dut_xm26_core_l}
.param x_dut_xm32_core_m = {x_dut_xm26_core_m}
.param x_dut_xm35_core_w = {x_dut_xm27_core_w}
.param x_dut_xm35_core_l = {x_dut_xm27_core_l}
.param x_dut_xm35_core_m = {x_dut_xm27_core_m}
.subckt ia_006_fan_chopper_cmfb vinp vinn voutp voutn vref clk_chin clk_chin_not clk_chfb clk_chfb_not clk_chout clk_chout_not vdd vss
CCM vb4o vss 'c_cm'
CFB1_CORE core__fbch_p core__vsum_n 'x_dut_cfb1_core_value'
CFB2_CORE core__fbch_n core__vsum_p 'x_dut_cfb2_core_value'
CIN1_CORE core__vsum_n core__inch_n 'x_dut_cin1_core_value'
CIN2_CORE core__vsum_p core__inch_p 'x_dut_cin2_core_value'
CM1_CORE core__g2_p voutp 'x_dut_cm1_core_value'
CM2_CORE core__g2_n voutn 'x_dut_cm2_core_value'
RB1_CORE core__vsum_n vref 'x_dut_rb1_core_value'
RB2_CORE core__vsum_p vref 'x_dut_rb2_core_value'
RMN_CMFB voutn cmfb__cm_sense 'x_dut_rmn_cmfb_value'
RMP_CMFB cmfb__cm_sense voutp 'x_dut_rmp_cmfb_value'
VB1_CORE core__vb1 vss dc {vb1_core}
VB2_CORE core__vb2 vss dc {vb2_core}
VB3_CORE core__vb3 vss dc {vb3_core}
VB4_CORE core__vb4 vss dc {vb4_core}
VREFCM vref_cm vss dc {vcm_ref}
XM10_CORE core__out1_n core__vb3 core__casc_src_n vdd pch_lvt l=x_dut_xm10_core_l m=x_dut_xm10_core_m w=x_dut_xm10_core_w
XM11_CORE core__out1_p core__vb3 core__casc_src_p vdd pch_lvt l=x_dut_xm11_core_l m=x_dut_xm11_core_m w=x_dut_xm11_core_w
XM12_CORE core__out1_p core__vb2 core__fold_p vss nch_lvt l=x_dut_xm12_core_l m=x_dut_xm12_core_m w=x_dut_xm12_core_w
XM13_CORE core__out1_n core__vb2 core__fold_n vss nch_lvt l=x_dut_xm13_core_l m=x_dut_xm13_core_m w=x_dut_xm13_core_w
XM14_CORE voutp core__g2_p vss vss nch_lvt l=x_dut_xm14_core_l m=x_dut_xm14_core_m w=x_dut_xm14_core_w
XM15_CORE voutn core__g2_n vss vss nch_lvt l=x_dut_xm15_core_l m=x_dut_xm15_core_m w=x_dut_xm15_core_w
XM16_CORE core__out1_n clk_chout core__g2_n vss nch_lvt l=x_dut_xm16_core_l m=x_dut_xm16_core_m w=x_dut_xm16_core_w
XM17_CORE core__g2_n clk_chout_not core__out1_n vdd pch_lvt l=x_dut_xm17_core_l m=x_dut_xm17_core_m w=x_dut_xm17_core_w
XM18_CORE core__out1_p clk_chout core__g2_p vss nch_lvt l=x_dut_xm18_core_l m=x_dut_xm18_core_m w=x_dut_xm18_core_w
XM19_CORE core__g2_p clk_chout_not core__out1_p vdd pch_lvt l=x_dut_xm19_core_l m=x_dut_xm19_core_m w=x_dut_xm19_core_w
XM1_CMFB cmfb__ptail cmfb__bias vdd vdd pch_lvt l=x_dut_xm1_cmfb_l m=x_dut_xm1_cmfb_m w=x_dut_xm1_cmfb_w
XM1_CORE core__tail core__vb4 vdd vdd pch_lvt l=x_dut_xm1_core_l m=x_dut_xm1_core_m w=x_dut_xm1_core_w
XM20_CORE core__fbch_p clk_chfb voutp vss nch_lvt l=x_dut_xm20_core_l m=x_dut_xm20_core_m w=x_dut_xm20_core_w
XM21_CORE voutp clk_chfb_not core__fbch_p vdd pch_lvt l=x_dut_xm21_core_l m=x_dut_xm21_core_m w=x_dut_xm21_core_w
XM22_CORE core__fbch_n clk_chfb voutn vss nch_lvt l=x_dut_xm22_core_l m=x_dut_xm22_core_m w=x_dut_xm22_core_w
XM23_CORE voutn clk_chfb_not core__fbch_n vdd pch_lvt l=x_dut_xm23_core_l m=x_dut_xm23_core_m w=x_dut_xm23_core_w
XM24_CORE vinn clk_chin core__inch_n vss nch_lvt l=x_dut_xm24_core_l m=x_dut_xm24_core_m w=x_dut_xm24_core_w
XM25_CORE core__inch_n clk_chin_not vinn vdd pch_lvt l=x_dut_xm25_core_l m=x_dut_xm25_core_m w=x_dut_xm25_core_w
XM26_CORE vinp clk_chin core__inch_p vss nch_lvt l=x_dut_xm26_core_l m=x_dut_xm26_core_m w=x_dut_xm26_core_w
XM27_CORE core__inch_p clk_chin_not vinp vdd pch_lvt l=x_dut_xm27_core_l m=x_dut_xm27_core_m w=x_dut_xm27_core_w
XM28_CORE core__out1_n clk_chout_not core__g2_p vss nch_lvt l=x_dut_xm28_core_l m=x_dut_xm28_core_m w=x_dut_xm28_core_w
XM29_CORE core__g2_p clk_chout core__out1_n vdd pch_lvt l=x_dut_xm29_core_l m=x_dut_xm29_core_m w=x_dut_xm29_core_w
XM2_CMFB vb4o cmfb__mirr vss vss nch_lvt l=x_dut_xm2_cmfb_l m=x_dut_xm2_cmfb_m w=x_dut_xm2_cmfb_w
XM2_CORE core__fold_p core__vsum_p core__tail vdd pch_lvt l=x_dut_xm2_core_l m=x_dut_xm2_core_m w=x_dut_xm2_core_w
XM30_CORE core__out1_p clk_chout_not core__g2_n vss nch_lvt l=x_dut_xm30_core_l m=x_dut_xm30_core_m w=x_dut_xm30_core_w
XM31_CORE core__g2_n clk_chout core__out1_p vdd pch_lvt l=x_dut_xm31_core_l m=x_dut_xm31_core_m w=x_dut_xm31_core_w
XM32_CORE vinn clk_chin_not core__inch_p vss nch_lvt l=x_dut_xm32_core_l m=x_dut_xm32_core_m w=x_dut_xm32_core_w
XM33_CORE core__inch_p clk_chin vinn vdd pch_lvt l=x_dut_xm33_core_l m=x_dut_xm33_core_m w=x_dut_xm33_core_w
XM34_CORE vinp clk_chin_not core__inch_n vss nch_lvt l=x_dut_xm34_core_l m=x_dut_xm34_core_m w=x_dut_xm34_core_w
XM35_CORE core__inch_n clk_chin vinp vdd pch_lvt l=x_dut_xm35_core_l m=x_dut_xm35_core_m w=x_dut_xm35_core_w
XM36_CORE core__fbch_p clk_chfb_not voutn vss nch_lvt l=x_dut_xm36_core_l m=x_dut_xm36_core_m w=x_dut_xm36_core_w
XM37_CORE voutn clk_chfb core__fbch_p vdd pch_lvt l=x_dut_xm37_core_l m=x_dut_xm37_core_m w=x_dut_xm37_core_w
XM38_CORE core__fbch_n clk_chfb_not voutp vss nch_lvt l=x_dut_xm38_core_l m=x_dut_xm38_core_m w=x_dut_xm38_core_w
XM39_CORE voutp clk_chfb core__fbch_n vdd pch_lvt l=x_dut_xm39_core_l m=x_dut_xm39_core_m w=x_dut_xm39_core_w
XM3_CMFB cmfb__bias cmfb__bias vdd vdd pch_lvt l=x_dut_xm3_cmfb_l m=x_dut_xm3_cmfb_m w=x_dut_xm3_cmfb_w
XM3_CORE core__fold_n core__vsum_n core__tail vdd pch_lvt l=x_dut_xm3_core_l m=x_dut_xm3_core_m w=x_dut_xm3_core_w
XM4_CMFB cmfb__mirr cmfb__cm_sense cmfb__ptail vdd pch_lvt l=x_dut_xm4_cmfb_l m=x_dut_xm4_cmfb_m w=x_dut_xm4_cmfb_w
XM4_CORE core__fold_p core__vb1 vss vss nch_lvt l=x_dut_xm4_core_l m=x_dut_xm4_core_m w=x_dut_xm4_core_w
XM5_CMFB vb4o vref_cm cmfb__ptail vdd pch_lvt l=x_dut_xm5_cmfb_l m=x_dut_xm5_cmfb_m w=x_dut_xm5_cmfb_w
XM5_CORE core__fold_n core__vb1 vss vss nch_lvt l=x_dut_xm5_core_l m=x_dut_xm5_core_m w=x_dut_xm5_core_w
XM6_CMFB cmfb__mirr cmfb__mirr vss vss nch_lvt l=x_dut_xm6_cmfb_l m=x_dut_xm6_cmfb_m w=x_dut_xm6_cmfb_w
XM6_CORE core__casc_src_n core__vb4 vdd vdd pch_lvt l=x_dut_xm6_core_l m=x_dut_xm6_core_m w=x_dut_xm6_core_w
XM7_CMFB cmfb__bias cmfb__bias vss vss nch_lvt l=x_dut_xm7_cmfb_l m=x_dut_xm7_cmfb_m w=x_dut_xm7_cmfb_w
XM7_CORE core__casc_src_p core__vb4 vdd vdd pch_lvt l=x_dut_xm7_core_l m=x_dut_xm7_core_m w=x_dut_xm7_core_w
XM8O voutp vb4o vdd vdd pch_lvt l=x_dut_xm8o_l m=x_dut_xm8o_m w=x_dut_xm8o_w
XM9O voutn vb4o vdd vdd pch_lvt l=x_dut_xm9o_l m=x_dut_xm9o_m w=x_dut_xm9o_w
.ends
.end
