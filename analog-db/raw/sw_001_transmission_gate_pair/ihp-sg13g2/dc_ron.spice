** GENERATED by `analog-db export-raw` — DO NOT EDIT.
** circuit=sw_001_transmission_gate_pair  class=switch  pdk=ihp-sg13g2  testbench=dc_ron  corner=tt
** Self-contained deck: testbench + bound params + lowered DUT (.subckt sw_001_transmission_gate_pair).
** PDK corner libs resolve by BARE NAME on the image's ngspice sourcepath — run in a
** PDK-enabled env (the base image / api container), NOT a bare host:
**   docker run --rm -i spicexplorer-spice-base:local \
**     bash -lc 'd=$(mktemp -d) && cat > $d/c.spice && cd $d && ngspice -b c.spice' < raw/sw_001_transmission_gate_pair/ihp-sg13g2/dc_ron.spice
*----------------------------------------------------------*
** params: 4 free + 2 frozen knobs (sizing.yaml) · 0 tied · 0 ratio-derived (abstract/params.yaml) · 2 testbench params
** AUTHORED TEMPLATE — switch/dc_ron (plan_hierarchical_composition P3).
** On-resistance of a single pass gate vs signal level: a test current ITEST is pulled
** from port_b while port_a sweeps 0..VDD with the switch ON (vctl=VDD, vctl_not=0);
** r_on(v) = (v(port_a)-v(port_b))/ITEST. Reports mid-range r_on and the sweep maximum.
**
** Assumes the transmission-gate port order:
**   .subckt <id> port_a port_b vctl vctl_not vdd vss
** Required bindings: DUT PORT_LINE VDD VMID ITEST VSWEEP_STEP PDK_INCLUDE.
.lib cornerMOSlv.lib mos_tt
.temp 27

.param VDD=1.2
.param ITEST=10u

Vdd  vdd 0 dc {VDD}
Vss  vss 0 dc 0
Vctl  vctl 0 dc {VDD}
Vctln vctl_not 0 dc 0
Va   port_a 0 dc 0
Isense port_b 0 dc {ITEST}

XDUT port_a port_b vctl vctl_not vdd vss sw_001_transmission_gate_pair

.control
  set filetype=ascii
  dc Va 0 1.2 0.01
  let ron_v = (v(port_a) - v(port_b))/(10u)
  meas dc r_on FIND ron_v AT=0.6
  meas dc r_on_max MAX ron_v
  * MAX meas lines carry an `at=` suffix the result parser skips - re-print clean
  print r_on_max
  write
  quit
.endc
.param x_dut_xm1_w=2u
.param x_dut_xm1_l=0.13u
.param x_dut_xm2_w=2u
.param x_dut_xm2_l=0.13u
.param x_dut_xm1_m=1
.param x_dut_xm2_m=1
.subckt sw_001_transmission_gate_pair port_a port_b vctl vctl_not vdd vss
XM1 port_a vctl port_b vss sg13_lv_nmos l=x_dut_xm1_l m=x_dut_xm1_m w=x_dut_xm1_w
XM2 port_b vctl_not port_a vdd sg13_lv_pmos l=x_dut_xm2_l m=x_dut_xm2_m w=x_dut_xm2_w
.ends
.end
