** sch_path: diff_pair_improved_nmos.sch
**.subckt diff_pair_improved_nmos vinp vinn CM_tail drain_n drain_p VSS VBIAS
*.ipin vinp
*.ipin vinn
*.ipin CM_tail
*.ipin drain_n
*.ipin drain_p
*.ipin VSS
*.ipin VBIAS
XM1 net2 vinp CM_tail VSS sg13_lv_nmos w=0.15u l=0.13u ng=1 m=1
XM2 net1 vinn CM_tail VSS sg13_lv_nmos w=0.15u l=0.13u ng=1 m=1
XM3 drain_n VBIAS net1 VSS sg13_lv_nmos w=0.15u l=0.13u ng=1 m=1
XM4 drain_p VBIAS net2 VSS sg13_lv_nmos w=0.15u l=0.13u ng=1 m=1
**.ends
.end
