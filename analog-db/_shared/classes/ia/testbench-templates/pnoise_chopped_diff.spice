** AUTHORED TEMPLATE — ia/pnoise_chopped_diff (P3-2c: the GOLDEN chopped-noise bench).
** Output noise of a chopper-subfamily IA measured IN OPERATION — all chopper clocks
** RUNNING at FCHOP — via Spectre PSS+pnoise: the periodic noise analysis folds in the
** sidebands of the periodic operating point, capturing exactly what chopping exists to
** do (modulate the amplifier's 1/f noise away from the signal band) and what a
** small-signal `noise` on the frozen network cannot see.
** ngspice lane: no PSS/pnoise — the .control runs a DC op only (payload is
** Spectre-only, like stb).
** Spectre lane: the platform composes `pss` + `pnoise ( voutp voutn )` (differential
** output pair, no iprobe — output-referred only); the V/sqrt(Hz) density lands in the
** swept pnoise.pnoise PSF as trace `out`. Read via the platform registry:
**   {meas: onoise_pnoise_total, out: out}      (V rms over the swept band)
**   {meas: pnoise_spot, out: out, f: F}        (V/sqrt(Hz) at offset F)
** Assumes the chopper-IA port convention (extra driven clock nets are harmless):
**   .subckt <id> vinp vinn voutp voutn vref clk_chin clk_chin_not clk_chfb clk_chfb_not
**                clk_chout clk_chout_not [clk_chpf clk_chpf_not] [clk_phi_1 clk_phi_2]
**                vdd vss
** Required bindings: DUT PORT_LINE VDD VCM CL FCHOP TEDGE FSTART FSTOP PPD PDK_INCLUDE.
${PDK_INCLUDE}

.param VDD=${VDD}
.param VCM=${VCM}
.param CL=${CL}
.param FCHOP=${FCHOP}
.param TCHOP={1/FCHOP}
.param TEDGE=${TEDGE}
.param RCM=${RCM}

Vdd  vdd 0 dc {VDD}
Vss  vss 0 dc 0
CLoadp voutp 0 {CL}
CLoadn voutn 0 {CL}
Vref vref 0 dc {VCM}
* bench-side output-CM anchor/load (P3-2c): the drawn core has NO CMFB, so its output
* common mode has no periodic steady state on its own (pss SPCRTRF-15044 period-2
* bounce, live 2026-07-17; core-CM closure is plan P4-4b). RCM to vref is the CM
* reference a real CCIA gets from its CMFB AND a legitimate next-stage load: at the
* default 30k the diff loop gain stays >> the cap-ratio 20 (closed-loop ~19 V/V) while
* the anchor pins the per-phase output CM (tau = RCM*CL ~ 1.5 ns) so the chopped orbit
* actually closes. A weak 10Meg tie was proven insufficient (60 nA vs ~90 uA device
* currents — the period-2 CM dance survives it).
Rcmp voutp vref {RCM}
Rcmn voutn vref {RCM}
* both inputs stiff at the common mode — the quiet-input noise configuration
Vinp vinp 0 dc {VCM}
Vinn vinn 0 dc {VCM}

* chopper clocks: complementary pairs, all phases aligned at FCHOP (RUNNING — the pss
* fundamental)
Vck_in_a  clk_chin      0 pulse(0 {VDD} 0 {TEDGE} {TEDGE} {TCHOP/2-TEDGE} {TCHOP})
Vck_in_b  clk_chin_not  0 pulse({VDD} 0 0 {TEDGE} {TEDGE} {TCHOP/2-TEDGE} {TCHOP})
Vck_fb_a  clk_chfb      0 pulse(0 {VDD} 0 {TEDGE} {TEDGE} {TCHOP/2-TEDGE} {TCHOP})
Vck_fb_b  clk_chfb_not  0 pulse({VDD} 0 0 {TEDGE} {TEDGE} {TCHOP/2-TEDGE} {TCHOP})
Vck_out_a clk_chout     0 pulse(0 {VDD} 0 {TEDGE} {TEDGE} {TCHOP/2-TEDGE} {TCHOP})
Vck_out_b clk_chout_not 0 pulse({VDD} 0 0 {TEDGE} {TEDGE} {TCHOP/2-TEDGE} {TCHOP})
Vck_pf_a  clk_chpf      0 pulse(0 {VDD} 0 {TEDGE} {TEDGE} {TCHOP/2-TEDGE} {TCHOP})
Vck_pf_b  clk_chpf_not  0 pulse({VDD} 0 0 {TEDGE} {TEDGE} {TCHOP/2-TEDGE} {TCHOP})
Vphi1 clk_phi_1 0 pulse(0 {VDD} 0 {TEDGE} {TEDGE} {TCHOP/2-TEDGE} {TCHOP})
Vphi2 clk_phi_2 0 pulse({VDD} 0 0 {TEDGE} {TEDGE} {TCHOP/2-TEDGE} {TCHOP})

${PORT_LINE} ${DUT}

.control
  set filetype=ascii
  * payload is Spectre-only (PSS+pnoise); a DC op keeps the ngspice deck runnable
  op
  write
  quit
.endc
.end
