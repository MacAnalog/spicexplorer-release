** GENERATED by `analog-db export-raw` — DO NOT EDIT.
** circuit=amp_030_miller_cmfb_composite  class=amplifier  pdk=tsmc-n65  testbench=dc_cm_bias_sweep  corner=tt
** Self-contained deck: testbench + bound params + lowered DUT (.subckt amp_030_miller_cmfb_composite).
** PDK corner libs resolve by BARE NAME on the image's ngspice sourcepath — run in a
** PDK-enabled env (the base image / api container), NOT a bare host:
**   docker run --rm -i spicexplorer-spice-base:local \
**     bash -lc 'd=$(mktemp -d) && cat > $d/c.spice && cd $d && ngspice -b c.spice' < raw/amp_030_miller_cmfb_composite/tsmc-n65/dc_cm_bias_sweep.spice
*----------------------------------------------------------*
** params: 21 free + 6 frozen knobs (sizing.yaml) · 17 tied · 0 ratio-derived (abstract/params.yaml) · 2 testbench params
** AUTHORED TEMPLATE — amplifier/dc_cm_bias_sweep (committed from the amp_029 review
** finding: "no stable interior DC point" deserved a reproducible gate, not scratchpad
** prose). Characterizes the OUTPUT-COMMON-MODE sensitivity of an FD amplifier to one
** internal bias knob: the knob (name bound as CMKNOB, e.g. the stage-1 load-gate bias)
** is stepped across 5 points VB1..VB5 via alterparam+reset; at each point the op's
** output CM vocm_i = (voutp+voutn)/2 is recorded. cm_interior_pts counts how many of
** the 5 land inside VCM +/- VBAND:
**   5..1  = the knob has a usable interior window (its width ~ the passing points'
**           span — pick VB points around the expected balance);
**   0     = the output rails at every sampled bias: no interior operating point at
**           this sizing (e.g. a no-CMFB topology's cascaded gds knife edges).
** Matched DC inputs at VCM; self-biased diff port order:
**   .subckt <id> vinp vinn voutp voutn vdd vss
** Required bindings: DUT PORT_LINE VDD VCM VBAND CMKNOB VB1 VB2 VB3 VB4 VB5
**                    PDK_INCLUDE.
.lib tsmc_n65_models.scs tt
.temp 27

.param VDD=1.2
.param VCM=0.6

Vdd  vdd 0 dc {VDD}
Vss  vss 0 dc 0
Vcm  vcm 0 dc {VCM}
Vinp vinp vcm dc 0
Vinn vinn vcm dc 0

XDUT vinp vinn voutp voutn vdd vss amp_030_miller_cmfb_composite

.control
  set filetype=ascii
  * each op opens a NEW plot: print every vocm_i immediately (the measure parser reads
  * these lines), and the final count reaches back via plot-qualified names (opN.vocm_N).
  alterparam vcm_ref=0.5
  reset
  op
  let vocm_1 = (v(voutp)+v(voutn))/2
  print vocm_1
  alterparam vcm_ref=0.55
  reset
  op
  let vocm_2 = (v(voutp)+v(voutn))/2
  print vocm_2
  alterparam vcm_ref=0.6
  reset
  op
  let vocm_3 = (v(voutp)+v(voutn))/2
  print vocm_3
  alterparam vcm_ref=0.65
  reset
  op
  let vocm_4 = (v(voutp)+v(voutn))/2
  print vocm_4
  alterparam vcm_ref=0.7
  reset
  op
  let vocm_5 = (v(voutp)+v(voutn))/2
  print vocm_5
  let lo = 0.6 - 0.15
  let hi = 0.6 + 0.15
  let cm_interior_pts = ((op1.vocm_1 gt lo) & (op1.vocm_1 lt hi)) + ((op2.vocm_2 gt lo) & (op2.vocm_2 lt hi)) + ((op3.vocm_3 gt lo) & (op3.vocm_3 lt hi)) + ((op4.vocm_4 gt lo) & (op4.vocm_4 lt hi)) + ((vocm_5 gt lo) & (vocm_5 lt hi))
  print cm_interior_pts
  write
  quit
.endc
.param x_dut_xm1_core_w=10u
.param x_dut_xm1_core_l=0.5u
.param x_dut_xm3_core_w=10u
.param x_dut_xm3_core_l=1u
.param x_dut_xm5_core_w=12u
.param x_dut_xm5_core_l=0.5u
.param x_dut_xm6_core_w=2u
.param x_dut_xm6_core_l=1u
.param x_dut_xm7_core_w=6u
.param x_dut_xm8_core_w=2u
.param x_dut_r1_core_value=2k
.param x_dut_c1_core_value=1p
.param i_bias_core=20u
.param x_dut_xm1_core_m=1
.param x_dut_xm3_core_m=1
.param x_dut_xm5_core_m=1
.param x_dut_xm6_core_m=1
.param x_dut_xm7_core_m=1
.param x_dut_xm8_core_m=1
.param gm_val_servo=100u
.param rout_val_servo=10k
.param cout_val_servo=100f
.param rin_val_servo=1e12
.param cin_val_servo=10f
.param x_dut_rmp_servo_value=1Meg
.param vcm_ref=0.6
.param vbl0=0.71
* ---- GENERATED parameter ties (abstract/params.yaml groups/ratios) ----
* Each tied symbol is defined exactly once, by its line below; rewrite that
* .param to untie just that symbol (untying = shadowing, plan D-3).
.param x_dut_xm10_core_l = {x_dut_xm6_core_l}
.param x_dut_xm7_core_l = {x_dut_xm6_core_l}
.param x_dut_xm8_core_l = {x_dut_xm6_core_l}
.param x_dut_xm2_core_w = {x_dut_xm1_core_w}
.param x_dut_xm2_core_l = {x_dut_xm1_core_l}
.param x_dut_xm2_core_m = {x_dut_xm1_core_m}
.param x_dut_xm4_core_w = {x_dut_xm3_core_w}
.param x_dut_xm4_core_l = {x_dut_xm3_core_l}
.param x_dut_xm4_core_m = {x_dut_xm3_core_m}
.param x_dut_xm9_core_w = {x_dut_xm5_core_w}
.param x_dut_xm9_core_l = {x_dut_xm5_core_l}
.param x_dut_xm9_core_m = {x_dut_xm5_core_m}
.param x_dut_xm10_core_w = {x_dut_xm7_core_w}
.param x_dut_xm10_core_m = {x_dut_xm7_core_m}
.param x_dut_r2_core_value = {x_dut_r1_core_value}
.param x_dut_c2_core_value = {x_dut_c1_core_value}
.param x_dut_rmn_servo_value = {x_dut_rmp_servo_value}
.subckt amp_030_miller_cmfb_composite vinp vinn voutp voutn vdd vss
C1_CORE core__mill_p voutp 'x_dut_c1_core_value'
C2_CORE core__mill_n voutn 'x_dut_c2_core_value'
CIN_SERVO_SERVO servo__cm_sense vref_cm 'cin_val_servo'
COUT_SERVO_SERVO vss vcmfb_raw 'cout_val_servo'
GM_SERVO_SERVO vss vcmfb_raw vref_cm servo__cm_sense {gm_val_servo}
IBIAS_CORE vdd core__ref dc {i_bias_core}
R1_CORE core__stg1p core__mill_p 'x_dut_r1_core_value'
R2_CORE core__stg1n core__mill_n 'x_dut_r2_core_value'
RIN_SERVO_SERVO servo__cm_sense vref_cm 'rin_val_servo'
RMN_SERVO voutn servo__cm_sense 'x_dut_rmn_servo_value'
RMP_SERVO servo__cm_sense voutp 'x_dut_rmp_servo_value'
ROUT_SERVO_SERVO vss vcmfb_raw 'rout_val_servo'
VBL0 vbl_ctl vcmfb_raw dc {vbl0}
VREFCM vref_cm vss dc {vcm_ref}
XM10_CORE voutn core__ref vss vss nch_lvt l=x_dut_xm10_core_l m=x_dut_xm10_core_m w=x_dut_xm10_core_w
XM1_CORE core__stg1p vinp core__tail vss nch_lvt l=x_dut_xm1_core_l m=x_dut_xm1_core_m w=x_dut_xm1_core_w
XM2_CORE core__stg1n vinn core__tail vss nch_lvt l=x_dut_xm2_core_l m=x_dut_xm2_core_m w=x_dut_xm2_core_w
XM3_CORE core__stg1p vbl_ctl vdd vdd pch_lvt l=x_dut_xm3_core_l m=x_dut_xm3_core_m w=x_dut_xm3_core_w
XM4_CORE core__stg1n vbl_ctl vdd vdd pch_lvt l=x_dut_xm4_core_l m=x_dut_xm4_core_m w=x_dut_xm4_core_w
XM5_CORE voutp core__stg1p vdd vdd pch_lvt l=x_dut_xm5_core_l m=x_dut_xm5_core_m w=x_dut_xm5_core_w
XM6_CORE core__ref core__ref vss vss nch_lvt l=x_dut_xm6_core_l m=x_dut_xm6_core_m w=x_dut_xm6_core_w
XM7_CORE voutp core__ref vss vss nch_lvt l=x_dut_xm7_core_l m=x_dut_xm7_core_m w=x_dut_xm7_core_w
XM8_CORE core__tail core__ref vss vss nch_lvt l=x_dut_xm8_core_l m=x_dut_xm8_core_m w=x_dut_xm8_core_w
XM9_CORE voutn core__stg1n vdd vdd pch_lvt l=x_dut_xm9_core_l m=x_dut_xm9_core_m w=x_dut_xm9_core_w
.ends
.end
