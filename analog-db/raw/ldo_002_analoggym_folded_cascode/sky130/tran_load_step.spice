** GENERATED by `analog-db export-raw` — DO NOT EDIT.
** circuit=ldo_002_analoggym_folded_cascode  class=ldo  pdk=sky130  testbench=tran_load_step  corner=tt
** Self-contained deck: testbench + bound params + lowered DUT (.subckt ldo_002_analoggym_folded_cascode).
** PDK corner libs resolve by BARE NAME on the image's ngspice sourcepath — run in a
** PDK-enabled env (the base image / api container), NOT a bare host:
**   docker run --rm -i spicexplorer-spice-base:local \
**     bash -lc 'd=$(mktemp -d) && cat > $d/c.spice && cd $d && ngspice -b c.spice' < raw/ldo_002_analoggym_folded_cascode/sky130/tran_load_step.spice
*----------------------------------------------------------*
** params: 19 free + 0 frozen knobs (sizing.yaml) · 8 tied · 0 ratio-derived (abstract/params.yaml) · 1 testbench params
** AUTHORED TEMPLATE — ldo/tran_load_step: fast lo->hi load step into Cout; undershoot + recovery.
** Bindings: DUT PORT_LINE VDD COUT ILOAD_LO ILOAD_HI TSTART TEDGE TPULSE TPER TSTEP TSTOP VTOL
**   PDK_INCLUDE.
.lib sky130.lib.spice tt
.temp 27

.param VDD=2.0

Vdd  vdd 0 dc {VDD}
Vss  vss 0 dc 0
CLoad vout 0 50p
Iload vout 0 pulse(10u 10m 5u 10n 10n 20u 40u)

XDUT vdd vout vss ldo_002_analoggym_folded_cascode

.control
  set filetype=ascii
  tran 10n 30u
  meas tran vout_min  MIN  v(vout) from=5u to=30u
  meas tran vout_post FIND v(vout) AT=30u
  let v_undershoot = vout_post - vout_min
  * recovery: time after the step for v(vout) to re-enter the +/-VTOL band around its final value
  let verr = abs(v(vout) - vout_post)
  meas tran tcross WHEN verr=5m FALL=LAST
  let t_transient = tcross - 5u
  print v_undershoot t_transient
  write
  quit
.endc
.param x_dut_xm1_w=20
.param x_dut_xm1_l=1
.param x_dut_xm3_w=30
.param x_dut_xm3_l=0.5
.param x_dut_xm5_w=10
.param x_dut_xm5_l=0.5
.param x_dut_xm7_w=20
.param x_dut_xm7_l=2
.param x_dut_xm9_w=30
.param x_dut_xm9_l=0.5
.param x_dut_xmp_w=10
.param x_dut_xmp_l=0.5
.param x_dut_xmp_m=250
.param r_z=3k
.param c_comp=2p
.param vref_val=1.8
.param vb1_val=1.0
.param vb2_val=0.025
.param r_bleed=100k
* ---- GENERATED parameter ties (abstract/params.yaml groups/ratios) ----
* Each tied symbol is defined exactly once, by its line below; rewrite that
* .param to untie just that symbol (untying = shadowing, plan D-3).
.param x_dut_xm2_w = {x_dut_xm1_w}
.param x_dut_xm2_l = {x_dut_xm1_l}
.param x_dut_xm4_w = {x_dut_xm3_w}
.param x_dut_xm4_l = {x_dut_xm3_l}
.param x_dut_xm6_w = {x_dut_xm5_w}
.param x_dut_xm6_l = {x_dut_xm5_l}
.param x_dut_xm8_w = {x_dut_xm7_w}
.param x_dut_xm8_l = {x_dut_xm7_l}
.subckt ldo_002_analoggym_folded_cascode vdd vout vss
CC ncz vout 'c_comp'
RZ ncz ngate 'r_z'
R_BLEED vout vss 'r_bleed'
VB1 vb1 vss dc {vb1_val}
VB2 vb2 vss dc {vb2_val}
VLP lp_brk vout dc 0
VREF vref vss dc {vref_val}
XM1 n2 lp_brk n4 vss sky130_fd_pr__nfet_g5v0d10v5 l=x_dut_xm1_l w=x_dut_xm1_w
XM2 n3 vref n4 vss sky130_fd_pr__nfet_g5v0d10v5 l=x_dut_xm2_l w=x_dut_xm2_w
XM3 n2 nmir vdd vdd sky130_fd_pr__pfet_g5v0d10v5 l=x_dut_xm3_l w=x_dut_xm3_w
XM4 n3 nmir vdd vdd sky130_fd_pr__pfet_g5v0d10v5 l=x_dut_xm4_l w=x_dut_xm4_w
XM5 nmir vb2 n2 vdd sky130_fd_pr__pfet_g5v0d10v5 l=x_dut_xm5_l w=x_dut_xm5_w
XM6 ngate vb2 n3 vdd sky130_fd_pr__pfet_g5v0d10v5 l=x_dut_xm6_l w=x_dut_xm6_w
XM7 nmir vb1 vss vss sky130_fd_pr__nfet_g5v0d10v5 l=x_dut_xm7_l w=x_dut_xm7_w
XM8 ngate vb1 vss vss sky130_fd_pr__nfet_g5v0d10v5 l=x_dut_xm8_l w=x_dut_xm8_w
XM9 n4 vb1 vss vss sky130_fd_pr__nfet_g5v0d10v5 l=x_dut_xm9_l w=x_dut_xm9_w
XMP vout ngate vdd vdd sky130_fd_pr__pfet_g5v0d10v5 l=x_dut_xmp_l m=x_dut_xmp_m w=x_dut_xmp_w
.ends
.end
