** GENERATED by `analog-db export-raw` — DO NOT EDIT.
** circuit=ldo_008_fer_mirror_ota  class=ldo  pdk=gf180mcu  testbench=psrr  corner=tt
** Self-contained deck: testbench + bound params + lowered DUT (.subckt ldo_008_fer_mirror_ota).
** PDK corner libs resolve by BARE NAME on the image's ngspice sourcepath — run in a
** PDK-enabled env (the base image / api container), NOT a bare host:
**   docker run --rm -i spicexplorer-spice-base:local \
**     bash -lc 'd=$(mktemp -d) && cat > $d/c.spice && cd $d && ngspice -b c.spice' < raw/ldo_008_fer_mirror_ota/gf180mcu/psrr.spice
*----------------------------------------------------------*
** params: 11 free + 9 frozen knobs (sizing.yaml) · 7 tied · 0 ratio-derived (abstract/params.yaml) · 1 testbench params
** AUTHORED TEMPLATE — ldo/psrr: AC supply rejection (Vdd -> Vout), closed loop.
** Inject AC=1 on the supply; psrr_vdd_db = -vdb(vout) (output rejection in dB). The feedback loop
** stays naturally closed (vout feeds the internal divider), so no loop-break trick is needed.
** Bindings: DUT PORT_LINE VDD ILOAD COUT PPD FSTART FSTOP FMEAS PDK_INCLUDE.
.include design.ngspice
.lib sm141064.ngspice noise_corner
.lib sm141064.ngspice nfet_03v3_t
.lib sm141064.ngspice pfet_03v3_t
.lib sm141064.ngspice fets_mm
.lib sm141064.ngspice res_typical
.lib sm141064.ngspice mimcap_typical
.lib sm141064.ngspice cap_mim
.temp 27

.param VDD=1.8

Vdd  vdd 0 dc {VDD} ac 1
Vss  vss 0 dc 0
Iload vout 0 dc 1m
CLoad vout 0 1u

XDUT vdd vout vss ldo_008_fer_mirror_ota

.control
  set filetype=ascii
  ac dec 20 10 10meg
  meas ac vout_db FIND vdb(vout) AT=1k
  let psrr_vdd_db = 0 - vout_db
  print psrr_vdd_db
  write
  quit
.endc
.param x_dut_xmnb_w=8u
.param x_dut_xmnb_l=0.5u
.param x_dut_xmdr_w=6u
.param x_dut_xmdr_l=0.3u
.param x_dut_xmld_w=8u
.param x_dut_xmld_l=0.5u
.param x_dut_xmp_w=8u
.param x_dut_xmp_l=0.28u
.param x_rcomp=2000
.param x_ccomp=160e-12
.param x_dut_rt_value=9000
.param x_vref_val=0.6
.param x_ibias_val=20e-6
.param x_dut_xmnb_m=1
.param x_dut_xmnt_m=4
.param x_dut_xmdr_m=4
.param x_dut_xmdf_m=4
.param x_dut_xmld_m=4
.param x_dut_xmlm_m=4
.param x_dut_xmp_m=60
* ---- GENERATED parameter ties (abstract/params.yaml groups/ratios) ----
* Each tied symbol is defined exactly once, by its line below; rewrite that
* .param to untie just that symbol (untying = shadowing, plan D-3).
.param x_dut_xmnt_w = {x_dut_xmnb_w}
.param x_dut_xmnt_l = {x_dut_xmnb_l}
.param x_dut_xmdf_w = {x_dut_xmdr_w}
.param x_dut_xmdf_l = {x_dut_xmdr_l}
.param x_dut_xmlm_w = {x_dut_xmld_w}
.param x_dut_xmlm_l = {x_dut_xmld_l}
.param x_dut_rb_value = {x_dut_rt_value}
.subckt ldo_008_fer_mirror_ota vdd vout vss
CC czero vout x_ccomp
IBI vdd nbias dc {x_ibias_val}
RB fb vss x_dut_rb_value
RC egate czero x_rcomp
RT lp_brk fb x_dut_rt_value
VLP lp_brk vout dc 0
VREF vref vss dc {x_vref_val}
XMDF ldiode fb tail vss nfet_03v3 l=x_dut_xmdf_l m=x_dut_xmdf_m w=x_dut_xmdf_w
XMDR egate vref tail vss nfet_03v3 l=x_dut_xmdr_l m=x_dut_xmdr_m w=x_dut_xmdr_w
XMLD ldiode ldiode vdd vdd pfet_03v3 l=x_dut_xmld_l m=x_dut_xmld_m w=x_dut_xmld_w
XMLM egate ldiode vdd vdd pfet_03v3 l=x_dut_xmlm_l m=x_dut_xmlm_m w=x_dut_xmlm_w
XMNB nbias nbias vss vss nfet_03v3 l=x_dut_xmnb_l m=x_dut_xmnb_m w=x_dut_xmnb_w
XMNT tail nbias vss vss nfet_03v3 l=x_dut_xmnt_l m=x_dut_xmnt_m w=x_dut_xmnt_w
XMP vout egate vdd vdd pfet_03v3 l=x_dut_xmp_l m=x_dut_xmp_m w=x_dut_xmp_w
.ends
.end
