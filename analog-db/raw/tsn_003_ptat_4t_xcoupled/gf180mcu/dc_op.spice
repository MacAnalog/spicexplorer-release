** GENERATED by `analog-db export-raw` — DO NOT EDIT.
** circuit=tsn_003_ptat_4t_xcoupled  class=temp_sensor  pdk=gf180mcu  testbench=dc_op  corner=tt
** Self-contained deck: testbench + bound params + lowered DUT (.subckt tsn_003_ptat_4t_xcoupled).
** PDK corner libs resolve by BARE NAME on the image's ngspice sourcepath — run in a
** PDK-enabled env (the base image / api container), NOT a bare host:
**   docker run --rm -i spicexplorer-spice-base:local \
**     bash -lc 'd=$(mktemp -d) && cat > $d/c.spice && cd $d && ngspice -b c.spice' < raw/tsn_003_ptat_4t_xcoupled/gf180mcu/dc_op.spice
*----------------------------------------------------------*
** params: 5 free + 4 frozen knobs (sizing.yaml) · 3 tied · 0 ratio-derived (abstract/params.yaml) · 1 testbench params
** AUTHORED TEMPLATE — temp_sensor/dc_op (plan D-4): DC operating point of a PTAT sensor core.
** Supply-only 3-terminal block (vdd vout vss); reports the DC output and the supply current
** (power). Bindings: DUT PORT_LINE VDD PDK_INCLUDE.
.include design.ngspice
.lib sm141064.ngspice noise_corner
.lib sm141064.ngspice nfet_03v3_t
.lib sm141064.ngspice pfet_03v3_t
.lib sm141064.ngspice fets_mm
.lib sm141064.ngspice res_typical
.lib sm141064.ngspice mimcap_typical
.lib sm141064.ngspice cap_mim
.temp 27

.param VDD=1.5

Vdd  vdd 0 dc {VDD}
Vss  vss 0 dc 0

XDUT vdd vout vss tsn_003_ptat_4t_xcoupled

.control
  set filetype=ascii
  op
  let i_supply = abs(i(Vdd))
  let v_out = v(vout)
  print i_supply
  print v_out
  write
  quit
.endc
.param x_dut_xm1_w=1u
.param x_dut_xm0_w=4u
.param x_dut_xm1_l=3u
.param x_dut_xm3_w=2u
.param x_dut_xm3_l=3u
.param x_dut_xm1_m=1
.param x_dut_xm0_m=1
.param x_dut_xm3_m=1
.param x_dut_xm4_m=1
* ---- GENERATED parameter ties (abstract/params.yaml groups/ratios) ----
* Each tied symbol is defined exactly once, by its line below; rewrite that
* .param to untie just that symbol (untying = shadowing, plan D-3).
.param x_dut_xm0_l = {x_dut_xm1_l}
.param x_dut_xm4_w = {x_dut_xm3_w}
.param x_dut_xm4_l = {x_dut_xm3_l}
.subckt tsn_003_ptat_4t_xcoupled vdd vout vss
XM0 vout na vss vss nfet_03v3 l=x_dut_xm0_l m=x_dut_xm0_m w=x_dut_xm0_w
XM1 na na vss vss nfet_03v3 l=x_dut_xm1_l m=x_dut_xm1_m w=x_dut_xm1_w
XM3 vout vout vdd vdd pfet_03v3 l=x_dut_xm3_l m=x_dut_xm3_m w=x_dut_xm3_w
XM4 na vout vdd vdd pfet_03v3 l=x_dut_xm4_l m=x_dut_xm4_m w=x_dut_xm4_w
.ends
.end
