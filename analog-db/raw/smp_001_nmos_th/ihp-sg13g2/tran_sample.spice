** GENERATED by `analog-db export-raw` — DO NOT EDIT.
** circuit=smp_001_nmos_th  class=sampler  pdk=ihp-sg13g2  testbench=tran_sample  corner=tt
** Self-contained deck: testbench + bound params + lowered DUT (.subckt smp_001_nmos_th).
** PDK corner libs resolve by BARE NAME on the image's ngspice sourcepath — run in a
** PDK-enabled env (the base image / api container), NOT a bare host:
**   docker run --rm -i spicexplorer-spice-base:local \
**     bash -lc 'd=$(mktemp -d) && cat > $d/c.spice && cd $d && ngspice -b c.spice' < raw/smp_001_nmos_th/ihp-sg13g2/tran_sample.spice
*----------------------------------------------------------*
** params: 4 free + 0 frozen knobs (sizing.yaml) · 0 tied · 0 ratio-derived (abstract/params.yaml) · 4 testbench params
** AUTHORED TEMPLATE — sampler/tran_sample: clocked track/hold transient (pedestal + droop).
** Drives a held analog input Vin and a sampling clock (track = clk high on [0,TCLK/2], hold = clk
** low on [TCLK/2,TCLK]). From v(vout): pedestal_v = the charge-injection step at the track->hold
** edge; droop_v_per_s = the hold-mode output drift rate. The `.control` block cannot evaluate {}
** brace expressions, so the sample instants (T_TRK/T_HS/T_HE) + step (TSTEP) arrive as bench params.
** Port convention: vdd vin clk vout vss.
** Bindings: DUT PORT_LINE VDD VCM VCLK TCLK TSTEP TSTOP T_TRK T_HS T_HE T_HOLD PDK_INCLUDE.
.lib cornerMOSlv.lib mos_tt
.temp 27

.param VDD=1.2
.param VCM=0.6
.param VCLK=1.2
.param TCLK=1e-6

Vdd vdd 0 dc {VDD}
Vss vss 0 dc 0
Vin vin 0 dc {VCM}
Vclk clk 0 dc 0 pulse(0 {VCLK} 0 {TCLK/100} {TCLK/100} {TCLK/2} {TCLK})

XDUT vdd vin clk vout vss smp_001_nmos_th

.control
  set filetype=ascii
  tran 2e-9 1e-6
  meas tran v_track FIND v(vout) AT=4.75e-07
  meas tran v_hs    FIND v(vout) AT=5.25e-07
  meas tran v_he    FIND v(vout) AT=9.75e-07
  let pedestal_v = v_hs - v_track
  let droop_v_per_s = (v_he - v_hs) / 4.5e-07
  print pedestal_v droop_v_per_s
  write
  quit
.endc
.param x_dut_xm0_w=2.0u
.param x_dut_xm0_l=0.13u
.param x_dut_xm0_m=1
.param x_dut_c0_value=500f
.subckt smp_001_nmos_th vdd vin clk vout vss
C0 vout vss x_dut_c0_value
XM0 vin clk vout vss sg13_lv_nmos l=x_dut_xm0_l m=x_dut_xm0_m w=x_dut_xm0_w
.ends
.end
