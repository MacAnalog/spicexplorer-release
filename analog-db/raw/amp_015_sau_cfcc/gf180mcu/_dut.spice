** GENERATED by `analog-db export-raw` — DO NOT EDIT.
** Standalone lowered DUT subckt for amp_015_sau_cfcc on gf180mcu (sizing .param defaults + .subckt).
** Not a runnable deck on its own — include it under your own testbench:
**   .include _dut.spice
**   XDUT vss vdd vinn vinp vout amp_015_sau_cfcc
** Source: pdk/gf180mcu/netlist.spice (run `analog-db generate` to refresh).
*----------------------------------------------------------*
** params: 29 free + 0 frozen knobs (sizing.yaml) · 32 tied · 13 ratio-derived (abstract/params.yaml)
.param CAPACITOR_0=2.34081194378892e-12
.param CURRENT_0_BIAS=1.3332881196942044e-05
.param x_dut_xm6_l=7.646278928995416e-07
.param x_dut_xm6_m=4
.param x_dut_xm6_w=6.928099546778253e-07
.param x_dut_xm10_l=6.769921313100113e-07
.param x_dut_xm10_m=8
.param x_dut_xm10_w=2.3704767656746498e-06
.param x_dut_xm11_l=7.015256759586033e-07
.param x_dut_xm11_m=8
.param x_dut_xm11_w=7.00996157596126e-07
.param x_dut_xm15_l=1.383943826260017e-06
.param x_dut_xm15_m=8
.param x_dut_xm15_w=2.214469042862151e-06
.param x_dut_xm19_l=1.0127537594566725e-06
.param x_dut_xm14_m=8
.param x_dut_xm19_w=5.442420082479648e-07
.param x_dut_xm21_l=1.1626015329118608e-06
.param x_dut_xm21_m=8
.param x_dut_xm21_w=4.3172498761281673e-07
.param x_dut_xm23_l=8.632929828172252e-07
.param x_dut_xm23_m=4
.param x_dut_xm23_w=2.7428565527795896e-06
.param x_dut_xm7_l=1.2494277880754684e-06
.param x_dut_xm7_m=4
.param x_dut_xm7_w=2.1729516479947147e-06
.param x_dut_xm9_l=1.467887276256674e-06
.param x_dut_xm9_m=4
.param x_dut_xm9_w=2.4396721931031143e-06
* ---- GENERATED parameter ties (abstract/params.yaml groups/ratios) ----
* Each tied symbol is defined exactly once, by its line below; rewrite that
* .param to untie just that symbol (untying = shadowing, plan D-3).
.param x_dut_xm5_w = {x_dut_xm6_w}
.param x_dut_xm4_w = {x_dut_xm6_w}
.param x_dut_xm3_w = {x_dut_xm6_w}
.param x_dut_xm2_w = {x_dut_xm6_w}
.param x_dut_xm1_w = {x_dut_xm6_w}
.param x_dut_xm0_w = {x_dut_xm6_w}
.param x_dut_xm5_l = {x_dut_xm6_l}
.param x_dut_xm4_l = {x_dut_xm6_l}
.param x_dut_xm3_l = {x_dut_xm6_l}
.param x_dut_xm2_l = {x_dut_xm6_l}
.param x_dut_xm1_l = {x_dut_xm6_l}
.param x_dut_xm0_l = {x_dut_xm6_l}
.param x_dut_xm8_w = {x_dut_xm9_w}
.param x_dut_xm8_l = {x_dut_xm9_l}
.param x_dut_xm8_m = {x_dut_xm9_m}
.param x_dut_xm22_w = {x_dut_xm21_w}
.param x_dut_xm22_l = {x_dut_xm21_l}
.param x_dut_xm20_w = {x_dut_xm19_w}
.param x_dut_xm17_w = {x_dut_xm19_w}
.param x_dut_xm14_w = {x_dut_xm19_w}
.param x_dut_xm12_w = {x_dut_xm19_w}
.param x_dut_xm18_w = {x_dut_xm19_w}
.param x_dut_xm13_w = {x_dut_xm19_w}
.param x_dut_xm20_l = {x_dut_xm19_l}
.param x_dut_xm17_l = {x_dut_xm19_l}
.param x_dut_xm14_l = {x_dut_xm19_l}
.param x_dut_xm12_l = {x_dut_xm19_l}
.param x_dut_xm18_l = {x_dut_xm19_l}
.param x_dut_xm13_l = {x_dut_xm19_l}
.param x_dut_xm16_w = {x_dut_xm15_w}
.param x_dut_xm16_l = {x_dut_xm15_l}
.param x_dut_xm16_m = {x_dut_xm15_m}
.param x_dut_xm5_m = {x_dut_xm6_m*1}
.param x_dut_xm4_m = {x_dut_xm6_m*2}
.param x_dut_xm3_m = {x_dut_xm6_m*1}
.param x_dut_xm2_m = {x_dut_xm6_m*1}
.param x_dut_xm1_m = {x_dut_xm6_m*1}
.param x_dut_xm0_m = {x_dut_xm6_m*1}
.param x_dut_xm22_m = {x_dut_xm21_m*3}
.param x_dut_xm19_m = {x_dut_xm14_m*8}
.param x_dut_xm20_m = {x_dut_xm14_m*8}
.param x_dut_xm17_m = {x_dut_xm14_m*4}
.param x_dut_xm12_m = {x_dut_xm14_m*4}
.param x_dut_xm18_m = {x_dut_xm14_m*4}
.param x_dut_xm13_m = {x_dut_xm14_m*4}
.subckt amp_015_sau_cfcc vss vdd vinn vinp vout
C0 net063 VOUT 'CAPACITOR_0'
I0 net013 vss 'CURRENT_0_BIAS'
XM0 net013 net013 vdd vdd pfet_03v3 l=x_dut_xm0_l m=x_dut_xm0_m w=x_dut_xm0_w
XM1 VB4 net013 vdd vdd pfet_03v3 l=x_dut_xm1_l m=x_dut_xm1_m w=x_dut_xm1_w
XM10 net043 net050 vdd vdd pfet_03v3 l=x_dut_xm10_l m=x_dut_xm10_m w=x_dut_xm10_w
XM11 VOUT net050 vdd vdd pfet_03v3 l=x_dut_xm11_l m=x_dut_xm11_m w=x_dut_xm11_w
XM12 VB4 VB3 net54 vss nfet_03v3 l=x_dut_xm12_l m=x_dut_xm12_m w=x_dut_xm12_w
XM13 DM_1 VB3 net56 vss nfet_03v3 l=x_dut_xm13_l m=x_dut_xm13_m w=x_dut_xm13_w
XM14 VB3 VB3 vss vss nfet_03v3 l=x_dut_xm14_l m=x_dut_xm14_m w=x_dut_xm14_w
XM15 VOUTN VB3 DM_2 vss nfet_03v3 l=x_dut_xm15_l m=x_dut_xm15_m w=x_dut_xm15_w
XM16 net050 VB3 net063 vss nfet_03v3 l=x_dut_xm16_l m=x_dut_xm16_m w=x_dut_xm16_w
XM17 net54 VB4 vss vss nfet_03v3 l=x_dut_xm17_l m=x_dut_xm17_m w=x_dut_xm17_w
XM18 net56 VB4 vss vss nfet_03v3 l=x_dut_xm18_l m=x_dut_xm18_m w=x_dut_xm18_w
XM19 DM_2 VB4 vss vss nfet_03v3 l=x_dut_xm19_l m=x_dut_xm19_m w=x_dut_xm19_w
XM2 DM_1 net013 vdd vdd pfet_03v3 l=x_dut_xm2_l m=x_dut_xm2_m w=x_dut_xm2_w
XM20 net063 VB4 vss vss nfet_03v3 l=x_dut_xm20_l m=x_dut_xm20_m w=x_dut_xm20_w
XM21 net043 net043 vss vss nfet_03v3 l=x_dut_xm21_l m=x_dut_xm21_m w=x_dut_xm21_w
XM22 net049 net043 vss vss nfet_03v3 l=x_dut_xm22_l m=x_dut_xm22_m w=x_dut_xm22_w
XM23 VOUT net049 vss vss nfet_03v3 l=x_dut_xm23_l m=x_dut_xm23_m w=x_dut_xm23_w
XM3 VB3 net013 vdd vdd pfet_03v3 l=x_dut_xm3_l m=x_dut_xm3_m w=x_dut_xm3_w
XM4 net31 net013 vdd vdd pfet_03v3 l=x_dut_xm4_l m=x_dut_xm4_m w=x_dut_xm4_w
XM5 VOUTN VOUTN vdd vdd pfet_03v3 l=x_dut_xm5_l m=x_dut_xm5_m w=x_dut_xm5_w
XM6 net050 VOUTN vdd vdd pfet_03v3 l=x_dut_xm6_l m=x_dut_xm6_m w=x_dut_xm6_w
XM7 net049 VOUTN vdd vdd pfet_03v3 l=x_dut_xm7_l m=x_dut_xm7_m w=x_dut_xm7_w
XM8 DM_2 VINN net31 net31 pfet_03v3 l=x_dut_xm8_l m=x_dut_xm8_m w=x_dut_xm8_w
XM9 net063 VINP net31 net31 pfet_03v3 l=x_dut_xm9_l m=x_dut_xm9_m w=x_dut_xm9_w
.ends
