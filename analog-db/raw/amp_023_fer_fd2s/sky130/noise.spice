** GENERATED by `analog-db export-raw` — DO NOT EDIT.
** circuit=amp_023_fer_fd2s  class=amplifier  pdk=sky130  testbench=noise  corner=tt
** Self-contained deck: testbench + bound params + lowered DUT (.subckt amp_023_fer_fd2s).
** PDK corner libs resolve by BARE NAME on the image's ngspice sourcepath — run in a
** PDK-enabled env (the base image / api container), NOT a bare host:
**   docker run --rm -i spicexplorer-spice-base:local \
**     bash -lc 'd=$(mktemp -d) && cat > $d/c.spice && cd $d && ngspice -b c.spice' < raw/amp_023_fer_fd2s/sky130/noise.spice
*----------------------------------------------------------*
** params: 20 free + 30 frozen knobs (sizing.yaml) · 44 tied · 0 ratio-derived (abstract/params.yaml) · 3 testbench params
** AUTHORED TEMPLATE — amplifier/noise_diff (self-biased, differential-output noise).
** Input-referred noise over a band for a DUT with no external ibias port and a true
** differential output. Single-ended AC stimulus into the inverting input (Vinn grounded
** AC), differential output noise sensed directly via ngspice's two-node `.noise` form. No
** bias-wrap needed — see ac_open_loop_diff.spice for why a symmetric FD topology with
** matched DC inputs doesn't need one.
**
** Assumes a self-biased, differential-output DUT port order:
**   .subckt <id> vinp vinn voutp voutn vdd vss
** Required bindings: DUT PORT_LINE VDD VCM CL FSTART FSTOP PPD PDK_INCLUDE.
.lib sky130.lib.spice tt
.temp 27

.param VDD=1.5
.param VCM=0.9
.param CL=500f

Vdd  vdd 0 dc {VDD}
Vss  vss 0 dc 0
CLoadp voutp 0 {CL}
CLoadn voutn 0 {CL}
Vcm  vcm 0 dc {VCM}
Vinp vinp vcm dc 0 ac 1
Vinn vinn vcm dc 0

XDUT vinp vinn voutp voutn vdd vss amp_023_fer_fd2s

.control
  set filetype=ascii
  noise v(voutp,voutn) Vinp dec 50 1k 100MEG
  print inoise_total onoise_total
  write
  quit
.endc
.param x_dut_xmbd_w=4
.param x_dut_xmpd1_w=6
.param x_dut_xmpd2_w=1.5
.param x_dut_xmnd1_w=0.75
.param x_dut_xmi1_w=6
.param x_dut_xmsa_w=6
.param x_dut_xmca_w=6
.param x_dut_xmna_w=4
.param x_dut_xmka_w=3
.param x_dut_xm2a_w=8
.param x_dut_xmla_w=6
.param x_dut_xmepd_w=3
.param x_dut_xmncd_w=1.5
.param x_dut_xmbd_l=0.4
.param x_dut_xmi1_l=0.3
.param x_dut_xmca_l=0.2
.param x_dut_rza_value=800
.param x_dut_cca_value=350e-15
.param x_dut_rca_value=2e5
.param x_dut_cma_value=150e-15
.param x_ibias_val=20e-6
.param x_vcmr_val=0.75
.param x_dut_xmbd_m=1
.param x_dut_xmb1_m=1
.param x_dut_xmpd1_m=1
.param x_dut_xmb2_m=1
.param x_dut_xmpd2_m=1
.param x_dut_xmpm1_m=1
.param x_dut_xmnd1_m=1
.param x_dut_xmt_m=2
.param x_dut_xmi1_m=2
.param x_dut_xmi2_m=2
.param x_dut_xmsa_m=2
.param x_dut_xmsb_m=2
.param x_dut_xmca_m=1
.param x_dut_xmcb_m=1
.param x_dut_xmna_m=1
.param x_dut_xmnb_m=1
.param x_dut_xmka_m=1
.param x_dut_xmkb_m=1
.param x_dut_xm2a_m=4
.param x_dut_xm2b_m=4
.param x_dut_xmla_m=6
.param x_dut_xmlb_m=6
.param x_dut_xmea1_m=1
.param x_dut_xmea2_m=1
.param x_dut_xmepd_m=1
.param x_dut_xmepm_m=2
.param x_dut_xmncd_m=1
.param x_dut_xmeat_m=1
* ---- GENERATED parameter ties (abstract/params.yaml groups/ratios) ----
* Each tied symbol is defined exactly once, by its line below; rewrite that
* .param to untie just that symbol (untying = shadowing, plan D-3).
.param x_dut_xmb1_l = {x_dut_xmbd_l}
.param x_dut_xmpd1_l = {x_dut_xmbd_l}
.param x_dut_xmb2_l = {x_dut_xmbd_l}
.param x_dut_xmpd2_l = {x_dut_xmbd_l}
.param x_dut_xmpm1_l = {x_dut_xmbd_l}
.param x_dut_xmnd1_l = {x_dut_xmbd_l}
.param x_dut_xmt_l = {x_dut_xmbd_l}
.param x_dut_xmsa_l = {x_dut_xmbd_l}
.param x_dut_xmsb_l = {x_dut_xmbd_l}
.param x_dut_xmka_l = {x_dut_xmbd_l}
.param x_dut_xmkb_l = {x_dut_xmbd_l}
.param x_dut_xmla_l = {x_dut_xmbd_l}
.param x_dut_xmlb_l = {x_dut_xmbd_l}
.param x_dut_xmepd_l = {x_dut_xmbd_l}
.param x_dut_xmepm_l = {x_dut_xmbd_l}
.param x_dut_xmncd_l = {x_dut_xmbd_l}
.param x_dut_xmeat_l = {x_dut_xmbd_l}
.param x_dut_xmb1_w = {x_dut_xmbd_w}
.param x_dut_xmb2_w = {x_dut_xmbd_w}
.param x_dut_xmt_w = {x_dut_xmbd_w}
.param x_dut_xmea1_w = {x_dut_xmbd_w}
.param x_dut_xmea2_w = {x_dut_xmbd_w}
.param x_dut_xmeat_w = {x_dut_xmbd_w}
.param x_dut_xmpm1_w = {x_dut_xmpd1_w}
.param x_dut_xmi2_l = {x_dut_xmi1_l}
.param x_dut_xm2a_l = {x_dut_xmi1_l}
.param x_dut_xm2b_l = {x_dut_xmi1_l}
.param x_dut_xmi2_w = {x_dut_xmi1_w}
.param x_dut_xmsb_w = {x_dut_xmsa_w}
.param x_dut_xmcb_l = {x_dut_xmca_l}
.param x_dut_xmna_l = {x_dut_xmca_l}
.param x_dut_xmnb_l = {x_dut_xmca_l}
.param x_dut_xmea1_l = {x_dut_xmca_l}
.param x_dut_xmea2_l = {x_dut_xmca_l}
.param x_dut_xmcb_w = {x_dut_xmca_w}
.param x_dut_xmnb_w = {x_dut_xmna_w}
.param x_dut_xmkb_w = {x_dut_xmka_w}
.param x_dut_xm2b_w = {x_dut_xm2a_w}
.param x_dut_xmlb_w = {x_dut_xmla_w}
.param x_dut_xmepm_w = {x_dut_xmepd_w}
.param x_dut_rzb_value = {x_dut_rza_value}
.param x_dut_ccb_value = {x_dut_cca_value}
.param x_dut_rcb_value = {x_dut_rca_value}
.param x_dut_cmb_value = {x_dut_cma_value}
.subckt amp_023_fer_fd2s vinp vinn voutp voutn vdd vss
CCA za voutp x_dut_cca_value
CCB zb voutn x_dut_ccb_value
CMA voutp vsen x_dut_cma_value
CMB voutn vsen x_dut_cmb_value
IB vdd ibias dc {x_ibias_val}
RCA voutp vsen x_dut_rca_value
RCB voutn vsen x_dut_rcb_value
RZA o1a za x_dut_rza_value
RZB o1b zb x_dut_rzb_value
VCR vcmr vss dc {x_vcmr_val}
XM2A voutp o1a vss vss sky130_fd_pr__nfet_01v8 l=x_dut_xm2a_l m=x_dut_xm2a_m w=x_dut_xm2a_w
XM2B voutn o1b vss vss sky130_fd_pr__nfet_01v8 l=x_dut_xm2b_l m=x_dut_xm2b_m w=x_dut_xm2b_w
XMB1 vbp ibias vss vss sky130_fd_pr__nfet_01v8 l=x_dut_xmb1_l m=x_dut_xmb1_m w=x_dut_xmb1_w
XMB2 vcp ibias vss vss sky130_fd_pr__nfet_01v8 l=x_dut_xmb2_l m=x_dut_xmb2_m w=x_dut_xmb2_w
XMBD ibias ibias vss vss sky130_fd_pr__nfet_01v8 l=x_dut_xmbd_l m=x_dut_xmbd_m w=x_dut_xmbd_w
XMCA o1a vcp fp vdd sky130_fd_pr__pfet_01v8 l=x_dut_xmca_l m=x_dut_xmca_m w=x_dut_xmca_w
XMCB o1b vcp fn vdd sky130_fd_pr__pfet_01v8 l=x_dut_xmcb_l m=x_dut_xmcb_m w=x_dut_xmcb_w
XMEA1 ead vcmr eatail vss sky130_fd_pr__nfet_01v8 l=x_dut_xmea1_l m=x_dut_xmea1_m w=x_dut_xmea1_w
XMEA2 vcmfb vsen eatail vss sky130_fd_pr__nfet_01v8 l=x_dut_xmea2_l m=x_dut_xmea2_m w=x_dut_xmea2_w
XMEAT eatail ibias vss vss sky130_fd_pr__nfet_01v8 l=x_dut_xmeat_l m=x_dut_xmeat_m w=x_dut_xmeat_w
XMEPD ead ead vdd vdd sky130_fd_pr__pfet_01v8 l=x_dut_xmepd_l m=x_dut_xmepd_m w=x_dut_xmepd_w
XMEPM vcmfb ead vdd vdd sky130_fd_pr__pfet_01v8 l=x_dut_xmepm_l m=x_dut_xmepm_m w=x_dut_xmepm_w
XMI1 fp vinp tail vss sky130_fd_pr__nfet_01v8 l=x_dut_xmi1_l m=x_dut_xmi1_m w=x_dut_xmi1_w
XMI2 fn vinn tail vss sky130_fd_pr__nfet_01v8 l=x_dut_xmi2_l m=x_dut_xmi2_m w=x_dut_xmi2_w
XMKA x1a vcmfb vss vss sky130_fd_pr__nfet_01v8 l=x_dut_xmka_l m=x_dut_xmka_m w=x_dut_xmka_w
XMKB x1b vcmfb vss vss sky130_fd_pr__nfet_01v8 l=x_dut_xmkb_l m=x_dut_xmkb_m w=x_dut_xmkb_w
XMLA voutp vbp vdd vdd sky130_fd_pr__pfet_01v8 l=x_dut_xmla_l m=x_dut_xmla_m w=x_dut_xmla_w
XMLB voutn vbp vdd vdd sky130_fd_pr__pfet_01v8 l=x_dut_xmlb_l m=x_dut_xmlb_m w=x_dut_xmlb_w
XMNA o1a vcn x1a vss sky130_fd_pr__nfet_01v8 l=x_dut_xmna_l m=x_dut_xmna_m w=x_dut_xmna_w
XMNB o1b vcn x1b vss sky130_fd_pr__nfet_01v8 l=x_dut_xmnb_l m=x_dut_xmnb_m w=x_dut_xmnb_w
XMNCD vcmfb vcmfb vss vss sky130_fd_pr__nfet_01v8 l=x_dut_xmncd_l m=x_dut_xmncd_m w=x_dut_xmncd_w
XMND1 vcn vcn vss vss sky130_fd_pr__nfet_01v8 l=x_dut_xmnd1_l m=x_dut_xmnd1_m w=x_dut_xmnd1_w
XMPD1 vbp vbp vdd vdd sky130_fd_pr__pfet_01v8 l=x_dut_xmpd1_l m=x_dut_xmpd1_m w=x_dut_xmpd1_w
XMPD2 vcp vcp vdd vdd sky130_fd_pr__pfet_01v8 l=x_dut_xmpd2_l m=x_dut_xmpd2_m w=x_dut_xmpd2_w
XMPM1 vcn vbp vdd vdd sky130_fd_pr__pfet_01v8 l=x_dut_xmpm1_l m=x_dut_xmpm1_m w=x_dut_xmpm1_w
XMSA fp vbp vdd vdd sky130_fd_pr__pfet_01v8 l=x_dut_xmsa_l m=x_dut_xmsa_m w=x_dut_xmsa_w
XMSB fn vbp vdd vdd sky130_fd_pr__pfet_01v8 l=x_dut_xmsb_l m=x_dut_xmsb_m w=x_dut_xmsb_w
XMT tail ibias vss vss sky130_fd_pr__nfet_01v8 l=x_dut_xmt_l m=x_dut_xmt_m w=x_dut_xmt_w
.ends
.end
