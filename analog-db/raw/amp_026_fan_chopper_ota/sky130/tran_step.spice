** GENERATED by `analog-db export-raw` — DO NOT EDIT.
** circuit=amp_026_fan_chopper_ota  class=amplifier  pdk=sky130  testbench=tran_step  corner=tt
** Self-contained deck: testbench + bound params + lowered DUT (.subckt amp_026_fan_chopper_ota).
** PDK corner libs resolve by BARE NAME on the image's ngspice sourcepath — run in a
** PDK-enabled env (the base image / api container), NOT a bare host:
**   docker run --rm -i spicexplorer-spice-base:local \
**     bash -lc 'd=$(mktemp -d) && cat > $d/c.spice && cd $d && ngspice -b c.spice' < raw/amp_026_fan_chopper_ota/sky130/tran_step.spice
*----------------------------------------------------------*
** params: 23 free + 10 frozen knobs (sizing.yaml) · 42 tied · 0 ratio-derived (abstract/params.yaml) · 4 testbench params
** AUTHORED TEMPLATE — amplifier/tran_step_diff (self-biased, differential-output step).
** Unity-gain step -> slew + settling for a DUT with no external ibias port and a true
** differential output. Closes ONE feedback path (vinn <- voutp) and steps vinp; by the
** differential pair's own symmetry (and, for a DUT like amp_020_two_stage_miller_cmfb, its
** internal common-mode servo) voutn tracks the complementary swing, so the DIFFERENTIAL
** output (voutp-voutn) is the correct unity-gain-follower signal to settle on.
**
** Assumes a self-biased, differential-output DUT port order:
**   .subckt <id> vinp vinn voutp voutn vdd vss
** Required bindings: DUT PORT_LINE VDD VCM CL VSTEP TSTART TSTEP TSTOP VTOL PDK_INCLUDE.
.lib sky130.lib.spice tt
.temp 27

.param VDD=1.8
.param VCM=0.6
.param CL=10p
.param VSTEP=50m

Vdd  vdd 0 dc {VDD}
Vss  vss 0 dc 0
CLoadp voutp 0 {CL}
CLoadn voutn 0 {CL}

* unity-gain differential follower: vinn <- voutp (single feedback wire; 0 V source = ideal
* wire). vinp gets the step relative to the input common mode.
Vinp vinp 0 dc {VCM} pulse({VCM} {VCM+VSTEP} 1u 1n 1n 1 1)
Vfb  vinn voutp dc 0

XDUT vinp vinn voutp voutn vdd vss amp_026_fan_chopper_ota

.control
  set filetype=ascii
  tran 1n 20u
  let vodm = v(voutp) - v(voutn)
  * settle to the FINAL differential value, not the input step size — see tran_step.spice
  * (universal) for why: a systematic offset would otherwise keep the error band open forever.
  meas tran vfinal FIND vodm AT=20u
  let verr = abs(vodm - vfinal)
  meas tran tcross WHEN verr=5m FALL=LAST
  let t_settle = tcross - 1u
  print t_settle
  write
  quit
.endc
.param x_dut_xm1_w=20
.param x_dut_xm1_l=1
.param x_dut_xm2_w=20
.param x_dut_xm2_l=0.5
.param x_dut_xm4_w=10
.param x_dut_xm4_l=1
.param x_dut_xm6_w=10
.param x_dut_xm8_w=50
.param x_dut_xm10_w=10
.param x_dut_xm10_l=0.3
.param x_dut_xm12_w=5
.param x_dut_xm12_l=0.3
.param x_dut_xm14_w=50
.param x_dut_xm14_l=0.25
.param x_dut_xm16_w=2
.param x_dut_xm16_l=0.15
.param x_dut_xm17_w=2
.param x_dut_xm17_l=0.15
.param x_dut_cm1_value=3p
.param vb1=0.697441489
.param vb2=0.9
.param vb3=0.7
.param vb4=0.6
.param x_dut_xm1_m=1
.param x_dut_xm2_m=1
.param x_dut_xm4_m=1
.param x_dut_xm6_m=1
.param x_dut_xm8_m=1
.param x_dut_xm10_m=1
.param x_dut_xm12_m=1
.param x_dut_xm14_m=1
.param x_dut_xm16_m=1
.param x_dut_xm17_m=1
* ---- GENERATED parameter ties (abstract/params.yaml groups/ratios) ----
* Each tied symbol is defined exactly once, by its line below; rewrite that
* .param to untie just that symbol (untying = shadowing, plan D-3).
.param x_dut_xm3_w = {x_dut_xm2_w}
.param x_dut_xm3_l = {x_dut_xm2_l}
.param x_dut_xm3_m = {x_dut_xm2_m}
.param x_dut_xm5_w = {x_dut_xm4_w}
.param x_dut_xm5_l = {x_dut_xm4_l}
.param x_dut_xm5_m = {x_dut_xm4_m}
.param x_dut_xm13_w = {x_dut_xm12_w}
.param x_dut_xm13_l = {x_dut_xm12_l}
.param x_dut_xm13_m = {x_dut_xm12_m}
.param x_dut_xm11_w = {x_dut_xm10_w}
.param x_dut_xm11_l = {x_dut_xm10_l}
.param x_dut_xm11_m = {x_dut_xm10_m}
.param x_dut_xm7_w = {x_dut_xm6_w}
.param x_dut_xm7_m = {x_dut_xm6_m}
.param x_dut_xm9_w = {x_dut_xm8_w}
.param x_dut_xm9_m = {x_dut_xm8_m}
.param x_dut_xm6_l = {x_dut_xm1_l}
.param x_dut_xm7_l = {x_dut_xm1_l}
.param x_dut_xm8_l = {x_dut_xm1_l}
.param x_dut_xm9_l = {x_dut_xm1_l}
.param x_dut_xm15_w = {x_dut_xm14_w}
.param x_dut_xm15_l = {x_dut_xm14_l}
.param x_dut_xm15_m = {x_dut_xm14_m}
.param x_dut_xm18_w = {x_dut_xm16_w}
.param x_dut_xm20_w = {x_dut_xm16_w}
.param x_dut_xm22_w = {x_dut_xm16_w}
.param x_dut_xm18_l = {x_dut_xm16_l}
.param x_dut_xm20_l = {x_dut_xm16_l}
.param x_dut_xm22_l = {x_dut_xm16_l}
.param x_dut_xm18_m = {x_dut_xm16_m}
.param x_dut_xm20_m = {x_dut_xm16_m}
.param x_dut_xm22_m = {x_dut_xm16_m}
.param x_dut_xm19_w = {x_dut_xm17_w}
.param x_dut_xm21_w = {x_dut_xm17_w}
.param x_dut_xm23_w = {x_dut_xm17_w}
.param x_dut_xm19_l = {x_dut_xm17_l}
.param x_dut_xm21_l = {x_dut_xm17_l}
.param x_dut_xm23_l = {x_dut_xm17_l}
.param x_dut_xm19_m = {x_dut_xm17_m}
.param x_dut_xm21_m = {x_dut_xm17_m}
.param x_dut_xm23_m = {x_dut_xm17_m}
.param x_dut_cm2_value = {x_dut_cm1_value}
.subckt amp_026_fan_chopper_ota vinp vinn voutp voutn vdd vss
CM1 g2_p voutp 'x_dut_cm1_value'
CM2 g2_n voutn 'x_dut_cm2_value'
VB1 vb1 vss dc {vb1}
VB2 vb2 vss dc {vb2}
VB3 vb3 vss dc {vb3}
VB4 vb4 vss dc {vb4}
XM1 tail vb4 vdd vdd sky130_fd_pr__pfet_01v8 l=x_dut_xm1_l m=x_dut_xm1_m w=x_dut_xm1_w
XM10 out1_n vb3 casc_src_n vdd sky130_fd_pr__pfet_01v8 l=x_dut_xm10_l m=x_dut_xm10_m w=x_dut_xm10_w
XM11 out1_p vb3 casc_src_p vdd sky130_fd_pr__pfet_01v8 l=x_dut_xm11_l m=x_dut_xm11_m w=x_dut_xm11_w
XM12 out1_p vb2 fold_p vss sky130_fd_pr__nfet_01v8 l=x_dut_xm12_l m=x_dut_xm12_m w=x_dut_xm12_w
XM13 out1_n vb2 fold_n vss sky130_fd_pr__nfet_01v8 l=x_dut_xm13_l m=x_dut_xm13_m w=x_dut_xm13_w
XM14 voutp g2_p vss vss sky130_fd_pr__nfet_01v8 l=x_dut_xm14_l m=x_dut_xm14_m w=x_dut_xm14_w
XM15 voutn g2_n vss vss sky130_fd_pr__nfet_01v8 l=x_dut_xm15_l m=x_dut_xm15_m w=x_dut_xm15_w
XM16 out1_n vdd g2_n vss sky130_fd_pr__nfet_01v8 l=x_dut_xm16_l m=x_dut_xm16_m w=x_dut_xm16_w
XM17 g2_n vss out1_n vdd sky130_fd_pr__pfet_01v8 l=x_dut_xm17_l m=x_dut_xm17_m w=x_dut_xm17_w
XM18 out1_p vdd g2_p vss sky130_fd_pr__nfet_01v8 l=x_dut_xm18_l m=x_dut_xm18_m w=x_dut_xm18_w
XM19 g2_p vss out1_p vdd sky130_fd_pr__pfet_01v8 l=x_dut_xm19_l m=x_dut_xm19_m w=x_dut_xm19_w
XM2 fold_p vinp tail vdd sky130_fd_pr__pfet_01v8 l=x_dut_xm2_l m=x_dut_xm2_m w=x_dut_xm2_w
XM20 out1_p vss g2_n vss sky130_fd_pr__nfet_01v8 l=x_dut_xm20_l m=x_dut_xm20_m w=x_dut_xm20_w
XM21 g2_n vdd out1_p vdd sky130_fd_pr__pfet_01v8 l=x_dut_xm21_l m=x_dut_xm21_m w=x_dut_xm21_w
XM22 out1_n vss g2_p vss sky130_fd_pr__nfet_01v8 l=x_dut_xm22_l m=x_dut_xm22_m w=x_dut_xm22_w
XM23 g2_p vdd out1_n vdd sky130_fd_pr__pfet_01v8 l=x_dut_xm23_l m=x_dut_xm23_m w=x_dut_xm23_w
XM3 fold_n vinn tail vdd sky130_fd_pr__pfet_01v8 l=x_dut_xm3_l m=x_dut_xm3_m w=x_dut_xm3_w
XM4 fold_p vb1 vss vss sky130_fd_pr__nfet_01v8 l=x_dut_xm4_l m=x_dut_xm4_m w=x_dut_xm4_w
XM5 fold_n vb1 vss vss sky130_fd_pr__nfet_01v8 l=x_dut_xm5_l m=x_dut_xm5_m w=x_dut_xm5_w
XM6 casc_src_n vb4 vdd vdd sky130_fd_pr__pfet_01v8 l=x_dut_xm6_l m=x_dut_xm6_m w=x_dut_xm6_w
XM7 casc_src_p vb4 vdd vdd sky130_fd_pr__pfet_01v8 l=x_dut_xm7_l m=x_dut_xm7_m w=x_dut_xm7_w
XM8 voutp vb4 vdd vdd sky130_fd_pr__pfet_01v8 l=x_dut_xm8_l m=x_dut_xm8_m w=x_dut_xm8_w
XM9 voutn vb4 vdd vdd sky130_fd_pr__pfet_01v8 l=x_dut_xm9_l m=x_dut_xm9_m w=x_dut_xm9_w
.ends
.end
