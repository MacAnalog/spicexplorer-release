** GENERATED by `analog-db export-raw` — DO NOT EDIT.
** circuit=ldo_003_analoggym_simple  class=ldo  pdk=gf180mcu  testbench=loop_stability  corner=tt
** Self-contained deck: testbench + bound params + lowered DUT (.subckt ldo_003_analoggym_simple).
** PDK corner libs resolve by BARE NAME on the image's ngspice sourcepath — run in a
** PDK-enabled env (the base image / api container), NOT a bare host:
**   docker run --rm -i spicexplorer-spice-base:local \
**     bash -lc 'd=$(mktemp -d) && cat > $d/c.spice && cd $d && ngspice -b c.spice' < raw/ldo_003_analoggym_simple/gf180mcu/loop_stability.spice
*----------------------------------------------------------*
** params: 14 free + 0 frozen knobs (sizing.yaml) · 4 tied · 0 ratio-derived (abstract/params.yaml) · 1 testbench params
** AUTHORED TEMPLATE — ldo/loop_stability: closed-loop output-impedance peaking (stability proxy).
** Drive an AC current of 1 A into vout; v(vout) = Zout(f). A resonant peak above the DC value =
** ringing / low phase margin. This is the honest stability metric reachable from the
** [vdd,vout,vss] ports — a true loop-gain phase margin needs an internal loop-break node (a future
** ac_loopgain probe), since this LDO's regulation loop is entirely inside the subckt.
** Bindings: DUT PORT_LINE VDD ILOAD COUT PPD FSTART FSTOP PDK_INCLUDE.
.include design.ngspice
.lib sm141064.ngspice typical
.temp 27

.param VDD=2.0

Vdd  vdd 0 dc {VDD}
Vss  vss 0 dc 0
Iload vout 0 dc 10m
CLoad vout 0 50p
Iac  vout 0 dc 0 ac 1

XDUT vdd vout vss ldo_003_analoggym_simple

.control
  set filetype=ascii
  ac dec 20 10 10meg
  meas ac zout_dc  FIND vdb(vout) AT=10
  meas ac zout_max MAX  vdb(vout)
  let zout_peak_db = zout_max - zout_dc
  print zout_peak_db
  write
  quit
.endc
.param x_dut_xm1_w=2u
.param x_dut_xm1_l=2u
.param x_dut_xm4_w=80u
.param x_dut_xm4_l=0.5u
.param x_dut_xm5_w=100u
.param x_dut_xm5_l=0.6u
.param x_dut_xmp_w=20u
.param x_dut_xmp_l=0.5u
.param x_dut_xmp_m=360
.param r_z=3k
.param c_comp=1p
.param vref_val=1.8
.param vb_val=1.2
.param r_bleed=100k
* ---- GENERATED parameter ties (abstract/params.yaml groups/ratios) ----
* Each tied symbol is defined exactly once, by its line below; rewrite that
* .param to untie just that symbol (untying = shadowing, plan D-3).
.param x_dut_xm2_w = {x_dut_xm1_w}
.param x_dut_xm2_l = {x_dut_xm1_l}
.param x_dut_xm3_w = {x_dut_xm4_w}
.param x_dut_xm3_l = {x_dut_xm4_l}
.subckt ldo_003_analoggym_simple vdd vout vss
CC ncz vout 'c_comp'
RZ ncz ngate 'r_z'
R_BLEED vout vss 'r_bleed'
VB vb vss dc {vb_val}
VREF vref vss dc {vref_val}
XM1 ndiode vout ntail vss nfet_06v0 l=x_dut_xm1_l w=x_dut_xm1_w
XM2 ngate vref ntail vss nfet_06v0 l=x_dut_xm2_l w=x_dut_xm2_w
XM3 ngate ndiode vdd vdd pfet_06v0 l=x_dut_xm3_l w=x_dut_xm3_w
XM4 ndiode ndiode vdd vdd pfet_06v0 l=x_dut_xm4_l w=x_dut_xm4_w
XM5 ntail vb vss vss nfet_06v0 l=x_dut_xm5_l w=x_dut_xm5_w
XMP vout ngate vdd vdd pfet_06v0 l=x_dut_xmp_l m=x_dut_xmp_m w=x_dut_xmp_w
.ends
.end
