** GENERATED by `analog-db export-raw` — DO NOT EDIT.
** circuit=tsn_003_ptat_4t_xcoupled  class=temp_sensor  pdk=ihp-sg13g2  testbench=psrr  corner=tt
** Self-contained deck: testbench + bound params + lowered DUT (.subckt tsn_003_ptat_4t_xcoupled).
** PDK corner libs resolve by BARE NAME on the image's ngspice sourcepath — run in a
** PDK-enabled env (the base image / api container), NOT a bare host:
**   docker run --rm -i spicexplorer-spice-base:local \
**     bash -lc 'd=$(mktemp -d) && cat > $d/c.spice && cd $d && ngspice -b c.spice' < raw/tsn_003_ptat_4t_xcoupled/ihp-sg13g2/psrr.spice
*----------------------------------------------------------*
** params: 5 free + 4 frozen knobs (sizing.yaml) · 3 tied · 0 ratio-derived (abstract/params.yaml) · 1 testbench params
** AUTHORED TEMPLATE — temp_sensor/psrr (plan D-4): low-frequency supply rejection (PSR) of a
** PTAT sensor. Drives the supply with a 1 V AC and reports the supply→output gain at the low
** frequency edge (dB; more-negative = better rejection).
** Bindings: DUT PORT_LINE VDD, FSTART FSTOP PPD, PDK_INCLUDE.
.lib cornerMOSlv.lib mos_tt
.temp 27

.param VDD=1.5

Vdd  vdd 0 dc {VDD} ac 1
Vss  vss 0 dc 0

XDUT vdd vout vss tsn_003_ptat_4t_xcoupled

.control
  set filetype=ascii
  ac dec 10 10 10meg
  meas ac psr_db FIND vdb(vout) AT=10
  write
  quit
.endc
.param x_dut_xm1_w=1u
.param x_dut_xm0_w=4u
.param x_dut_xm1_l=3u
.param x_dut_xm3_w=2u
.param x_dut_xm3_l=3u
.param x_dut_xm1_m=1
.param x_dut_xm0_m=1
.param x_dut_xm3_m=1
.param x_dut_xm4_m=1
* ---- GENERATED parameter ties (abstract/params.yaml groups/ratios) ----
* Each tied symbol is defined exactly once, by its line below; rewrite that
* .param to untie just that symbol (untying = shadowing, plan D-3).
.param x_dut_xm0_l = {x_dut_xm1_l}
.param x_dut_xm4_w = {x_dut_xm3_w}
.param x_dut_xm4_l = {x_dut_xm3_l}
.subckt tsn_003_ptat_4t_xcoupled vdd vout vss
XM0 vout na vss vss sg13_lv_nmos l=x_dut_xm0_l m=x_dut_xm0_m w=x_dut_xm0_w
XM1 na na vss vss sg13_lv_nmos l=x_dut_xm1_l m=x_dut_xm1_m w=x_dut_xm1_w
XM3 vout vout vdd vdd sg13_lv_pmos l=x_dut_xm3_l m=x_dut_xm3_m w=x_dut_xm3_w
XM4 na vout vdd vdd sg13_lv_pmos l=x_dut_xm4_l m=x_dut_xm4_m w=x_dut_xm4_w
.ends
.end
