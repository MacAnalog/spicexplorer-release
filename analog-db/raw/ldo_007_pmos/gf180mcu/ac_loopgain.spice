** GENERATED by `analog-db export-raw` — DO NOT EDIT.
** circuit=ldo_007_pmos  class=ldo  pdk=gf180mcu  testbench=ac_loopgain  corner=tt
** Self-contained deck: testbench + bound params + lowered DUT (.subckt ldo_007_pmos).
** PDK corner libs resolve by BARE NAME on the image's ngspice sourcepath — run in a
** PDK-enabled env (the base image / api container), NOT a bare host:
**   docker run --rm -i spicexplorer-spice-base:local \
**     bash -lc 'd=$(mktemp -d) && cat > $d/c.spice && cd $d && ngspice -b c.spice' < raw/ldo_007_pmos/gf180mcu/ac_loopgain.spice
*----------------------------------------------------------*
** params: 16 free + 0 frozen knobs (sizing.yaml) · 6 tied · 0 ratio-derived (abstract/params.yaml) · 1 testbench params
** AUTHORED TEMPLATE — ldo/ac_loopgain: TRUE regulation-loop gain, phase margin and gain margin
** by Middlebrook voltage injection at an in-DUT loop-break marker.
**
** Why this exists: an LDO's regulation loop is entirely INSIDE the subckt (vout -> error amp ->
** pass gate -> vout), so it cannot be broken from the [vdd, vout, vss] ports. The class's
** `loop_stability` bench measures closed-loop output-impedance peaking (zout_peak_db) as an
** honest proxy, but peaking is a symptom, not a margin — it cannot tell you HOW MUCH phase you
** have, and a critically-damped loop and a 30-degree loop can show similar peaks under different
** loads. This bench gives the real number.
**
** CONTRACT — the DUT must carry a loop-break marker. Put a 0 V source in the feedback path of the
** abstract netlist, between the driving node and the sensing input:
**     Vlp lp_brk vout dc 0        ; and feed the error amp's sense input from lp_brk, not vout
** A 0 V source with no AC spec is an ideal short, so it is INVISIBLE to every other analysis —
** dc_op / load_regulation / psrr / the transients all see the loop closed exactly as before. Only
** this bench turns it into a generator, via `alter`. This mirrors the amplifier class's `stb`
** bench, which uses the same 0 V VIPRB marker convention (there it becomes a Spectre iprobe).
**
** INJECTION POINT: it must sit where the source-side impedance is LOW and the load-side impedance
** is HIGH — vout (driven hard by the pass device and the output cap) into a MOSFET gate satisfies
** that by a wide margin, which is what makes the Middlebrook approximation valid here.
**
** MATH: the marker forces V(lp_brk) - V(vout) = 1 V AC. With G the transfer once around the rest
** of the loop (lp_brk -> error amp -> pass device -> vout):
**     V(vout) = G * V(lp_brk)  and  V(lp_brk) = V(vout) + 1
**  => V(lp_brk) = 1/(1-G),  V(vout) = G/(1-G),  so  T = v(vout)/v(lp_brk) = G  exactly.
** No small-signal approximation is involved in that algebra; the only assumption is the impedance
** condition above.
**
** VALIDATED 2026-07-20 against a known answer: applied to amp_033_ti_ldo_ref_selfbias closed as a
** unity buffer, this method returns 74.9178 dB / 12.083 MHz / 21.05 deg where the independent
** amplifier `ac_open_loop_biaswrap` bench returns 74.9177 dB / 12.112 MHz / 20.997 deg — agreement
** to the frequency-grid resolution. The phase normalisation (180 + phc - phc[0]) is the same
** sign-convention-agnostic form the amplifier open-loop templates use, so an inverting loop
** (phc[0] ~ 180 deg) and a non-inverting one both report the same physical margin.
**
** Bindings: DUT PORT_LINE VDD ILOAD COUT PPD FSTART FSTOP LP_PROBE PDK_INCLUDE.
** LP_PROBE is the marker's instance name inside the DUT (default `vlp`, see assemble.py).
.include design.ngspice
.lib sm141064.ngspice noise_corner
.lib sm141064.ngspice nfet_03v3_t
.lib sm141064.ngspice pfet_03v3_t
.lib sm141064.ngspice fets_mm
.temp 27

.param VDD=1.8

Vdd  vdd 0 dc {VDD}
Vss  vss 0 dc 0
Iload vout 0 dc 1m
CLoad vout 0 1u

XDUT vdd vout vss ldo_007_pmos

.control
  set filetype=ascii
  * turn the in-loop 0 V marker into a 1 V AC generator (it stays a plain short at DC, so the
  * operating point this measurement rides on is the regulated one)
  alter @v.xdut.vlp[acmag] = 1
  ac dec 51 1 1G
  let tloop = v(vout) / v(xdut.lp_brk)
  let tdb  = db(tloop)
  let tphc = cph(tloop)*180/3.14159265
  let tph  = 180 + tphc - tphc[0]
  meas ac loopgain_db FIND tdb AT=1
  meas ac ugf_loop    WHEN tdb=0 FALL=1
  meas ac pm_loop     FIND tph WHEN tdb=0 FALL=1
  * gain margin: attenuation still in hand where the loop phase reaches 0 (i.e. 180 deg of shift
  * from the DC value). NaN when the phase never gets there — an honest "unconditionally stable"
  * rather than a fabricated number.
  meas ac gm_at_180 FIND tdb WHEN tph=0 FALL=1
  let gm_loop_db = 0 - gm_at_180
  * SENSITIVITY-FUNCTION PEAK. For a regulator, Zout_cl = Zout_ol/(1+T_rr), so
  * |Zout_cl|/|Zout_ol| = |1/(1+T_rr)| = |S| exactly, and its peak Ms is the damping
  * figure the zout_peak_db proxy was standing in for. Ms comes free from THIS sweep:
  * no open-loop Zout run is needed.
  * SIGN: tloop is the raw around-the-loop transfer measured at the marker, and it is
  * NEGATIVE at DC for a negative-feedback loop (vout up -> pass current down -> vout
  * down), i.e. tphc[0] ~ +/-180 deg. The return ratio is therefore T_rr = -tloop, and
  * S = 1/(1 - tloop). This was ADJUDICATED by measurement, not assumed: on
  * ldo_005/ihp-sg13g2 the two candidate conventions give 4.3447 dB and 4.2e-06 dB,
  * and only the first is admissible, because Ms >= 1/(2 sin(PM/2)) forces Ms >= 1.270
  * (2.07 dB) at that run's 46.39 deg phase margin. The 1/(1+tloop) form collapses to
  * 0 dB exactly as expected for the wrong sign: |1+T| is huge in band, so its peak is
  * just the high-frequency limit where the loop gain dies and |S| -> 1.
  * tloop_ph_dc is recorded on every run as the standing guard: a circuit whose DC loop
  * phase is NOT near +/-180 does not satisfy this convention and its ms_peak must not
  * be trusted.
  let s_db = db(1/(1-tloop))
  meas ac ms_peak     MAX s_db
  meas ac tloop_ph_dc FIND tphc AT=1
  print loopgain_db ugf_loop pm_loop gm_loop_db ms_peak tloop_ph_dc
  write
  quit
.endc
.param x_dut_xmp_w=20u
.param x_dut_xmp_m=140
.param x_dut_xmp_l=0.5u
.param x_dut_xm1_w=16u
.param x_dut_xm1_l=0.5u
.param x_dut_xm3_w=25u
.param x_dut_xm3_l=0.5u
.param x_dut_xm6_w=48u
.param x_dut_xm6_l=0.5u
.param r_top=5k
.param r_bot=35k
.param c_ff=60p
.param c_comp=0.05p
.param r_z=1
.param vref_val=1.05
.param i_tail=60u
* ---- GENERATED parameter ties (abstract/params.yaml groups/ratios) ----
* Each tied symbol is defined exactly once, by its line below; rewrite that
* .param to untie just that symbol (untying = shadowing, plan D-3).
.param x_dut_xm2_w = {x_dut_xm1_w}
.param x_dut_xm2_l = {x_dut_xm1_l}
.param x_dut_xm4_w = {x_dut_xm3_w}
.param x_dut_xm4_l = {x_dut_xm3_l}
.param x_dut_xm5_w = {x_dut_xm6_w}
.param x_dut_xm5_l = {x_dut_xm6_l}
.subckt ldo_007_pmos vdd vout vss
CC ncz vout 'c_comp'
CFF lp_brk fb 'c_ff'
IBIAS vdd ebias dc {i_tail}
R1 lp_brk fb 'r_top'
R2 fb vss 'r_bot'
RZ egate ncz 'r_z'
VLP lp_brk vout dc 0
VREF vref vss dc {vref_val}
XM1 noutm fb etail vss nfet_03v3 l=x_dut_xm1_l w=x_dut_xm1_w
XM2 egate vref etail vss nfet_03v3 l=x_dut_xm2_l w=x_dut_xm2_w
XM3 noutm noutm vdd vdd pfet_03v3 l=x_dut_xm3_l w=x_dut_xm3_w
XM4 egate noutm vdd vdd pfet_03v3 l=x_dut_xm4_l w=x_dut_xm4_w
XM5 etail ebias vss vss nfet_03v3 l=x_dut_xm5_l w=x_dut_xm5_w
XM6 ebias ebias vss vss nfet_03v3 l=x_dut_xm6_l w=x_dut_xm6_w
XMP vout egate vdd vdd pfet_03v3 l=x_dut_xmp_l m=x_dut_xmp_m w=x_dut_xmp_w
.ends
.end
