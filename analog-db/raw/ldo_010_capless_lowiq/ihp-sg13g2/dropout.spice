** GENERATED by `analog-db export-raw` — DO NOT EDIT.
** circuit=ldo_010_capless_lowiq  class=ldo  pdk=ihp-sg13g2  testbench=dropout  corner=tt
** Self-contained deck: testbench + bound params + lowered DUT (.subckt ldo_010_capless_lowiq).
** PDK corner libs resolve by BARE NAME on the image's ngspice sourcepath — run in a
** PDK-enabled env (the base image / api container), NOT a bare host:
**   docker run --rm -i spicexplorer-spice-base:local \
**     bash -lc 'd=$(mktemp -d) && cat > $d/c.spice && cd $d && ngspice -b c.spice' < raw/ldo_010_capless_lowiq/ihp-sg13g2/dropout.spice
*----------------------------------------------------------*
** params: 33 free + 0 frozen knobs (sizing.yaml) · 0 tied · 0 ratio-derived (abstract/params.yaml) · 0 testbench params
** AUTHORED TEMPLATE — ldo/dropout: the smallest (Vin - Vout) at which the regulator still
** REGULATES, under heavy load. Vin is swept upward and dropout is read at the first point where
** the output is genuinely in regulation.
**
** REWRITTEN 2026-07-21. The previous form was (VOUT_THRESH written as prose below, NOT as a
** ${...} placeholder: assemble() scans the RENDERED deck, comments included, so quoting a
** superseded placeholder here would make it a REQUIRED binding no line reads)
**     meas dc vin_at WHEN v(vout)=VOUT_THRESH RISE=1
**     let v_dropout = vin_at - VOUT_THRESH
** i.e. purely "when does vout first rise past a threshold". That cannot tell REGULATION from a
** DEAD PASS DEVICE, and it fails in the worst possible direction — optimistically. When the loop
** is not working the pass transistor sits fully on, so vout simply follows vin; vout then crosses
** VOUT_THRESH at vin ~ VOUT_THRESH and the bench reports a dropout of ~0. A completely broken
** regulator scores a PERFECT dropout number.
**
** That is not hypothetical: it green-lit a real candidate here. A resistor-biased variant of
** ldo_005_buffered_ref reported dropout 0.090 V (against 0.490 V for the working design) while
** actually RAILING below ~3.1 V — vout was 2.59 V at vin 2.6 V. Only line_reg (1.185 V) caught it.
** This is the same class of defect as the amplifier ICMR bench measuring rail coincidence instead
** of tracking, and it takes the same cure: an ACTIVITY criterion alongside the level test.
**
** In regulation now requires BOTH:
**   * the output is at its target:      |vout - VOUT_NOM| <= VREG_TOL
**   * the output is not following vin:  |dvout/dvin| <= REG_SLOPE_MAX
** A regulating LDO has dvout/dvin ~ line-regulation slope (1e-3 or less); a railed one has ~1, so
** the slope test separates them cleanly no matter where the level test happens to land.
**
** Bindings: DUT PORT_LINE ILOAD VDD_START VDD_STOP VDD_STEP VOUT_NOM VREG_TOL REG_SLOPE_MAX
**           PDK_INCLUDE.
** VOUT_NOM defaults to the datasheet's default_conditions.vout typical value; VREG_TOL and
** REG_SLOPE_MAX have defaults in assemble.py, so existing circuits need no edits. The legacy
** VOUT_THRESH binding is gone — a threshold alone is exactly what was wrong. A circuit that
** still binds it is harmless (safe_substitute ignores unused mapping keys), just dead weight.
.lib cornerMOSlv.lib mos_tt
.lib cornerRES.lib res_typ
.lib cornerCAP.lib cap_typ
.temp 27

Vdd  vdd 0 dc 0.9
Vss  vss 0 dc 0
Iload vout 0 dc 10m

XDUT vdd vout vss ldo_010_capless_lowiq

.control
  set filetype=ascii
  dc Vdd 0.9 1.6 0.002
  let vo    = v(vout)
  let vsw   = v(vdd)
  let dvo   = deriv(vo)
  let dvi   = deriv(vsw)
  let slope = dvo / dvi
  let inreg = (abs(vo - 1.2) <= 0.05) & (abs(slope) <= 0.1)
  let npts  = length(inreg)
  let k     = 0
  let found = 0
  let vin_at = 0
  let vout_at = 0
  while k < npts
    if found < 0.5
      if inreg[k] > 0.5
        let vin_at  = vsw[k]
        let vout_at = vo[k]
        let found   = 1
      end
    end
    let k = k + 1
  end
  * NaN rather than a fabricated number when the sweep never reaches regulation — an honest
  * "this circuit does not regulate anywhere in the swept range".
  if found < 0.5
    * 0*log(0) — NOT 0/0: ngspice-45 hard-errors on 0/0 ("argument out of range for
    * divide"), so the vector never exists and the runner reports sim_error instead of
    * the intended honest NaN (found live on ldo_004's committed sizing, 2026-07-24).
    let v_dropout = 0*log(0)
  else
    let v_dropout = vin_at - vout_at
  end
  print vin_at vout_at v_dropout
  write
  quit
.endc
.param vref_val=0.6
.param r_w=0.5u
.param r_fb_l=340u
.param c_ff_w=8u
.param r_bias_l=138.5u
.param x_dut_xmb0_w=1u
.param x_dut_xmb0_l=1u
.param x_dut_xmb1_w=1.39u
.param x_dut_xmbp_w=10u
.param x_dut_xmbp_l=1u
.param x_dut_xmt_w=10u
.param x_dut_xm1_w=9.53u
.param x_dut_xm1_l=0.5u
.param x_dut_xm3_w=2.95u
.param x_dut_xm3_l=1u
.param x_dut_xm5_w=2.42u
.param x_dut_xm5_l=0.5u
.param x_dut_xm6_w=5.53u
.param c_comp_w=54u
.param x_dut_xmc_w=15.76u
.param x_dut_xmc_l=0.36u
.param x_dut_xma_w=5.79u
.param x_dut_xma_l=0.5u
.param x_dut_xmcp_w=9.02u
.param x_dut_xmcp_l=0.5u
.param x_dut_xms_w=2.2u
.param x_dut_xms_l=0.95u
.param x_dut_xmp_w=10u
.param x_dut_xmp_l=0.13u
.param x_dut_xmp_m=19
.param x_dut_xmp_nf_mult=4
.param c_out_w=58u
.param c_out_m=4
.subckt ldo_010_capless_lowiq vdd vout vss
VLP lp_brk vout dc 0
VREF vref vss dc {vref_val}
XCC ea_out ea_o1 cap_cmim l=c_comp_w w=c_comp_w
XCFF lp_brk fb cap_cmim l=c_ff_w w=c_ff_w
XCOUT vout vss cap_cmim l=c_out_w m=c_out_m w=c_out_w
XM1A ea_n fb ea_tail vdd sg13_lv_pmos l=x_dut_xm1_l w={x_dut_xm1_w/2}
XM1B ea_n fb ea_tail vdd sg13_lv_pmos l=x_dut_xm1_l w={x_dut_xm1_w/2}
XM2A ea_o1 vref ea_tail vdd sg13_lv_pmos l=x_dut_xm1_l w={x_dut_xm1_w/2}
XM2B ea_o1 vref ea_tail vdd sg13_lv_pmos l=x_dut_xm1_l w={x_dut_xm1_w/2}
XM3A ea_n ea_n vss vss sg13_lv_nmos l=x_dut_xm3_l w={x_dut_xm3_w/2}
XM3B ea_n ea_n vss vss sg13_lv_nmos l=x_dut_xm3_l w={x_dut_xm3_w/2}
XM4A ea_o1 ea_n vss vss sg13_lv_nmos l=x_dut_xm3_l w={x_dut_xm3_w/2}
XM4B ea_o1 ea_n vss vss sg13_lv_nmos l=x_dut_xm3_l w={x_dut_xm3_w/2}
XM5 ea_out ea_o1 vss vss sg13_lv_nmos l=x_dut_xm5_l w=x_dut_xm5_w
XM6 ea_out pbias vdd vdd sg13_lv_pmos l=x_dut_xmbp_l w=x_dut_xm6_w
XMA x1 x1 vss vss sg13_lv_nmos l=x_dut_xma_l w=x_dut_xma_w
XMB y x1 vss vss sg13_lv_nmos l=x_dut_xma_l w=x_dut_xma_w
XMB0A nbias nbias vss vss sg13_lv_nmos l=x_dut_xmb0_l w={x_dut_xmb0_w/2}
XMB0B nbias nbias vss vss sg13_lv_nmos l=x_dut_xmb0_l w={x_dut_xmb0_w/2}
XMB1A pbias nbias vss vss sg13_lv_nmos l=x_dut_xmb0_l w={x_dut_xmb1_w/2}
XMB1B pbias nbias vss vss sg13_lv_nmos l=x_dut_xmb0_l w={x_dut_xmb1_w/2}
XMBP pbias pbias vdd vdd sg13_lv_pmos l=x_dut_xmbp_l w=x_dut_xmbp_w
XMC x1 ea_out vout vdd sg13_lv_pmos l=x_dut_xmc_l w=x_dut_xmc_w
XMCP y y vdd vdd sg13_lv_pmos l=x_dut_xmcp_l w=x_dut_xmcp_w
XMD gate y vdd vdd sg13_lv_pmos l=x_dut_xmcp_l w=x_dut_xmcp_w
XMP vout gate vdd vdd sg13_lv_pmos l=x_dut_xmp_l m={x_dut_xmp_m*x_dut_xmp_nf_mult} w={x_dut_xmp_w/x_dut_xmp_nf_mult}
XMSA gate nbias vss vss sg13_lv_nmos l=x_dut_xms_l w={x_dut_xms_w/2}
XMSB gate nbias vss vss sg13_lv_nmos l=x_dut_xms_l w={x_dut_xms_w/2}
XMT ea_tail pbias vdd vdd sg13_lv_pmos l=x_dut_xmbp_l w=x_dut_xmt_w
XR1_1 lp_brk n_r1_1 vss rhigh l={r_fb_l/8} w=r_w
XR1_2 n_r1_1 n_r1_2 vss rhigh l={r_fb_l/8} w=r_w
XR1_3 n_r1_2 n_r1_3 vss rhigh l={r_fb_l/8} w=r_w
XR1_4 n_r1_3 n_r1_4 vss rhigh l={r_fb_l/8} w=r_w
XR1_5 n_r1_4 n_r1_5 vss rhigh l={r_fb_l/8} w=r_w
XR1_6 n_r1_5 n_r1_6 vss rhigh l={r_fb_l/8} w=r_w
XR1_7 n_r1_6 n_r1_7 vss rhigh l={r_fb_l/8} w=r_w
XR1_8 n_r1_7 fb vss rhigh l={r_fb_l/8} w=r_w
XR2_1 fb n_r2_1 vss rhigh l={r_fb_l/8} w=r_w
XR2_2 n_r2_1 n_r2_2 vss rhigh l={r_fb_l/8} w=r_w
XR2_3 n_r2_2 n_r2_3 vss rhigh l={r_fb_l/8} w=r_w
XR2_4 n_r2_3 n_r2_4 vss rhigh l={r_fb_l/8} w=r_w
XR2_5 n_r2_4 n_r2_5 vss rhigh l={r_fb_l/8} w=r_w
XR2_6 n_r2_5 n_r2_6 vss rhigh l={r_fb_l/8} w=r_w
XR2_7 n_r2_6 n_r2_7 vss rhigh l={r_fb_l/8} w=r_w
XR2_8 n_r2_7 vss vss rhigh l={r_fb_l/8} w=r_w
XRB_1 vdd n_rb_1 vss rhigh l={r_bias_l/5} w=r_w
XRB_2 n_rb_1 n_rb_2 vss rhigh l={r_bias_l/5} w=r_w
XRB_3 n_rb_2 n_rb_3 vss rhigh l={r_bias_l/5} w=r_w
XRB_4 n_rb_3 n_rb_4 vss rhigh l={r_bias_l/5} w=r_w
XRB_5 n_rb_4 nbias vss rhigh l={r_bias_l/5} w=r_w
.ends
.end
