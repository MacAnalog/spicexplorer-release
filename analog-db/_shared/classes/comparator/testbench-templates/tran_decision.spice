** AUTHORED TEMPLATE — comparator/tran_decision: clocked decision transient (StrongARM-style).
** A fixed differential overdrive VOD straddles VCM; the clock runs two full periods and the
** SECOND rising edge (a settled, post-startup evaluation) is measured: clk->voutp propagation
** delay, decided output levels mid-evaluation (AT=TMEAS, inside the clk-high window), and the
** clock-period average supply current. TRIG/TARG + AVG meas lines carry suffixes the result
** parser skips, so scalars are re-printed clean.
** Port convention: vdd voutp voutn vinp vinn clk vss. voutp is the side that decides HIGH for
** vinp > vinn.
** Bindings: DUT PORT_LINE VDD VCM VOD TEDGE TDELAY THI TPER TSTEP TSTOP TMEAS PDK_INCLUDE.
${PDK_INCLUDE}

.param VDD=${VDD}
.param VCM=${VCM}
.param VOD=${VOD}

Vdd  vdd 0 dc {VDD}
Vss  vss 0 dc 0
Vinp vinp 0 dc {VCM+VOD/2}
Vinn vinn 0 dc {VCM-VOD/2}
Vclk clk 0 dc 0 pulse(0 {VDD} ${TDELAY} ${TEDGE} ${TEDGE} ${THI} ${TPER})

${PORT_LINE} ${DUT}

.control
  set filetype=ascii
  let vmid = ${VDD}/2
  tran ${TSTEP} ${TSTOP}
  meas tran t_prop TRIG v(clk) VAL=vmid RISE=2 TARG v(voutp) VAL=vmid RISE=2
  meas tran v_out_high FIND v(voutp) AT=${TMEAS}
  meas tran v_out_low  FIND v(voutn) AT=${TMEAS}
  meas tran i_avg AVG i(Vdd) FROM=${TDELAY} TO=${TSTOP}
  let i_supply = abs(i_avg)
  print t_prop i_supply
  write
  quit
.endc
.end
