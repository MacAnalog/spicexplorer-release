** Example of simple 5-transistor OTA transient analysis testbench
**.subckt ota-5t_tb-tran
*----------------------------------------------------------*
* Testbench
*----------------------------------------------------------*
Vdd v_dd GND VDD
xota v_dd v_out v_in v_out net1 v_ena v_ss ota-5t
Vss v_ss GND 0
C1 v_out v_ss CL m=1
Vin v_in v_ss VREF_IN
I0 v_dd net1 dc 0 pwl(0 0 1.1u 0 1.2u 20u)
Venable v_ena v_ss dc 0 pwl(0 0 1u 0 1.1u 1.5)
.save v(v_in)
.save v(v_out)
.save v(v_ena)

*----------------------------------------------------------*
* Technology Library
*----------------------------------------------------------*
.lib cornerMOSlv.lib mos_tt

.temp 27

.ic v(v_out)=0
.option method=gear
*----------------------------------------------------------*
* Control Block
*----------------------------------------------------------*
.control
  echo ==================================
  echo start of Control
  echo ==================================

  echo
  echo (C) start of Transient Sim
  echo ----------------------------------
  tran 0.005u 15u uic
  * plot v_ena v_out

  echo
  echo Calculating tsettle
  let vout_limit=0.8*0.99
  meas tran tcross WHEN v(v_out)=vout_limit
  let vena_limit=0.5*1.5
  meas tran tstart WHEN v(v_ena)=vena_limit
  let tsettle=tcross-tstart
  print tsettle

  echo
  echo SAVING SIMULATION RESULTS IN THE RAW FILE
  remzerovec
  write

  echo ==================================
  echo END of Control
  echo ==================================
  quit
  * ^ This is needed for spicelib (uncommented)

.endc

*----------------------------------------------------------*
* Parameter Definitions
*----------------------------------------------------------*

.param VDD=1.5
.param CL=50f
.param VREF_IN=0.8

.param x_dut_nfet_input_w=0.5u
.param x_dut_nfet_input_l=5.0u

.param x_dut_nfet_mirror_w=2.0u
.param x_dut_nfet_mirror_l=5.0u

.param x_dut_pfet_load_w=1.5u
.param x_dut_pfet_load_l=5.0u

.param x_dut_nfet_mirror_ref_w=2.0u
.param x_dut_nfet_mirror_ref_l=5.0u

**** end user architecture code
**.ends

*----------------------------------------------------------*
* Subcircuit Definition
*----------------------------------------------------------*
* expanding   symbol:  ota-5t.sym # of pins=7
** sym_path: ota-5t.sym
** sch_path: ota-5t.sch
.subckt ota-5t vdd vout vinp vinn ibias_20u d_ena vss
*.ipin ibias_20u
*.iopin vdd
*.iopin vss
*.ipin vinp
*.ipin vinn
*.opin vout
*.ipin d_ena
XM5 tail gate_n vss vss sg13_lv_nmos w=x_dut_nfet_mirror_w l=x_dut_nfet_mirror_l ng=1 m=1
XM4 vout gate_p vdd vdd sg13_lv_pmos w=x_dut_pfet_load_w l=x_dut_pfet_load_l ng=1 m=1
XM1 gate_p vinp tail vss sg13_lv_nmos w=x_dut_nfet_input_w l=x_dut_nfet_input_l ng=1 m=1
XM2 vout vinn tail vss sg13_lv_nmos w=x_dut_nfet_input_w l=x_dut_nfet_input_l ng=1 m=1
XM3 gate_p gate_p vdd vdd sg13_lv_pmos w=x_dut_pfet_load_w l=x_dut_pfet_load_l ng=1 m=1
XM6 ibias_20u gate_n vss vss sg13_lv_nmos w=x_dut_nfet_mirror_ref_w l=x_dut_nfet_mirror_ref_l ng=1 m=1
XM9 gate_n ena_n vss vss sg13_lv_nmos w=0.5u l=0.13u ng=1 m=1
XM11 gate_p ena vdd vdd sg13_lv_pmos w=1.5u l=0.13u ng=1 m=1
XM7 ena ena_n vss vss sg13_lv_nmos w=0.5u l=0.13u ng=1 m=1
XM8 ena ena_n vdd vdd sg13_lv_pmos w=1.5u l=0.13u ng=1 m=1
XM10 ibias_20u ena gate_n vss sg13_lv_nmos w=0.5u l=0.13u ng=1 m=1
XM12 ena_n d_ena vss vss sg13_lv_nmos w=0.5u l=0.13u ng=1 m=1
XM13 ena_n d_ena vdd vdd sg13_lv_pmos w=1.5u l=0.13u ng=1 m=1
.ends

.GLOBAL GND
.end
