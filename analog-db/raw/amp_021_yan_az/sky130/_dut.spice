** GENERATED by `analog-db export-raw` — DO NOT EDIT.
** Standalone lowered DUT subckt for amp_021_yan_az on sky130 (sizing .param defaults + .subckt).
** Not a runnable deck on its own — include it under your own testbench:
**   .include _dut.spice
**   XDUT vss vdd vinn vinp vout amp_021_yan_az
** Source: pdk/sky130/netlist.spice (run `analog-db generate` to refresh).
*----------------------------------------------------------*
** params: 36 free + 0 frozen knobs (sizing.yaml) · 27 tied · 6 ratio-derived (abstract/params.yaml)
.param CAPACITOR_0=3.458877584486538e-12
.param CAPACITOR_1=3.0507658439580926e-12
.param CURRENT_1_BIAS=1.3433787567603088e-05
.param x_dut_xm67_l=1.280483608542843
.param x_dut_xm67_m=4
.param x_dut_xm67_w=0.812584856306191
.param x_dut_xm11_l=0.41991635246489656
.param x_dut_xm11_m=4
.param x_dut_xm11_w=1.303441089469606
.param x_dut_xm13_l=2.719269089317299
.param x_dut_xm13_m=4
.param x_dut_xm13_w=1.8433608471255465
.param x_dut_xm14_l=1.9007336631384961
.param x_dut_xm14_m=4
.param x_dut_xm14_w=2.7209581091133175
.param x_dut_xm16_l=0.38932112227696614
.param x_dut_xm16_m=4
.param x_dut_xm16_w=2.253034247752003
.param x_dut_xm18_l=1.6662631310875642
.param x_dut_xm18_m=4
.param x_dut_xm18_w=1.04924880144302
.param x_dut_xm19_l=0.8280466670814688
.param x_dut_xm19_m=4
.param x_dut_xm19_w=0.746561623054721
.param x_dut_xm22_l=0.7782864823091848
.param x_dut_xm22_m=4
.param x_dut_xm22_w=2.374100801686893
.param x_dut_xm23_l=0.4760704258362352
.param x_dut_xm23_m=4
.param x_dut_xm23_w=1.2073216696924558
.param x_dut_xm10_l=0.5246246830395339
.param x_dut_xm10_m=4
.param x_dut_xm10_w=0.8264772026846
.param RESISTOR_0=269734.82360887644
.param RESISTOR_1=31632.802717808896
.param RESISTOR_2=223442.2185020715
* ---- GENERATED parameter ties (abstract/params.yaml groups/ratios) ----
* Each tied symbol is defined exactly once, by its line below; rewrite that
* .param to untie just that symbol (untying = shadowing, plan D-3).
.param x_dut_xm3_w = {x_dut_xm67_w}
.param x_dut_xm5_w = {x_dut_xm67_w}
.param x_dut_xm4_w = {x_dut_xm67_w}
.param x_dut_xm2_w = {x_dut_xm67_w}
.param x_dut_xm1_w = {x_dut_xm67_w}
.param x_dut_xm0_w = {x_dut_xm67_w}
.param x_dut_xm3_l = {x_dut_xm67_l}
.param x_dut_xm5_l = {x_dut_xm67_l}
.param x_dut_xm4_l = {x_dut_xm67_l}
.param x_dut_xm2_l = {x_dut_xm67_l}
.param x_dut_xm1_l = {x_dut_xm67_l}
.param x_dut_xm0_l = {x_dut_xm67_l}
.param x_dut_xm9_w = {x_dut_xm10_w}
.param x_dut_xm9_l = {x_dut_xm10_l}
.param x_dut_xm9_m = {x_dut_xm10_m}
.param x_dut_xm17_w = {x_dut_xm16_w}
.param x_dut_xm17_l = {x_dut_xm16_l}
.param x_dut_xm17_m = {x_dut_xm16_m}
.param x_dut_xm20_w = {x_dut_xm19_w}
.param x_dut_xm21_w = {x_dut_xm19_w}
.param x_dut_xm20_l = {x_dut_xm19_l}
.param x_dut_xm21_l = {x_dut_xm19_l}
.param x_dut_xm20_m = {x_dut_xm19_m}
.param x_dut_xm21_m = {x_dut_xm19_m}
.param x_dut_xm15_w = {x_dut_xm14_w}
.param x_dut_xm15_l = {x_dut_xm14_l}
.param x_dut_xm15_m = {x_dut_xm14_m}
.param x_dut_xm3_m = {x_dut_xm67_m*4}
.param x_dut_xm5_m = {x_dut_xm67_m*1}
.param x_dut_xm4_m = {x_dut_xm67_m*1}
.param x_dut_xm2_m = {x_dut_xm67_m*2}
.param x_dut_xm1_m = {x_dut_xm67_m*1}
.param x_dut_xm0_m = {x_dut_xm67_m*1}
.subckt amp_021_yan_az vss vdd vinn vinp vout
C0 net063 VOUT 'CAPACITOR_1'
C1 net051 vss 'CAPACITOR_0'
I0 VB1 vss 'CURRENT_1_BIAS'
R0 net078 net077 'RESISTOR_1'
R1 net078 net082 'RESISTOR_2'
R2 net094 net051 'RESISTOR_0'
XM0 VB1 VB1 vdd vdd sky130_fd_pr__pfet_01v8 l=x_dut_xm0_l m=x_dut_xm0_m w=x_dut_xm0_w
XM1 VB4 VB1 vdd vdd sky130_fd_pr__pfet_01v8 l=x_dut_xm1_l m=x_dut_xm1_m w=x_dut_xm1_w
XM10 net063 VINP net019 net019 sky130_fd_pr__pfet_01v8 l=x_dut_xm10_l m=x_dut_xm10_m w=x_dut_xm10_w
XM11 net094 net050 vdd vdd sky130_fd_pr__pfet_01v8 l=x_dut_xm11_l m=x_dut_xm11_m w=x_dut_xm11_w
XM13 VOUT net050 vdd vdd sky130_fd_pr__pfet_01v8 l=x_dut_xm13_l m=x_dut_xm13_m w=x_dut_xm13_w
XM14 VOUTN net077 DM_2 vss sky130_fd_pr__nfet_01v8 l=x_dut_xm14_l m=x_dut_xm14_m w=x_dut_xm14_w
XM15 net050 net082 net063 vss sky130_fd_pr__nfet_01v8 l=x_dut_xm15_l m=x_dut_xm15_m w=x_dut_xm15_w
XM16 net077 DM_2 vss vss sky130_fd_pr__nfet_01v8 l=x_dut_xm16_l m=x_dut_xm16_m w=x_dut_xm16_w
XM17 net082 net063 vss vss sky130_fd_pr__nfet_01v8 l=x_dut_xm17_l m=x_dut_xm17_m w=x_dut_xm17_w
XM18 VOUT net057 vss vss sky130_fd_pr__nfet_01v8 l=x_dut_xm18_l m=x_dut_xm18_m w=x_dut_xm18_w
XM19 VB4 VB4 vss vss sky130_fd_pr__nfet_01v8 l=x_dut_xm19_l m=x_dut_xm19_m w=x_dut_xm19_w
XM2 net019 VB1 vdd vdd sky130_fd_pr__pfet_01v8 l=x_dut_xm2_l m=x_dut_xm2_m w=x_dut_xm2_w
XM20 DM_2 VB4 vss vss sky130_fd_pr__nfet_01v8 l=x_dut_xm20_l m=x_dut_xm20_m w=x_dut_xm20_w
XM21 net063 VB4 vss vss sky130_fd_pr__nfet_01v8 l=x_dut_xm21_l m=x_dut_xm21_m w=x_dut_xm21_w
XM22 net094 net051 vss vss sky130_fd_pr__nfet_01v8 l=x_dut_xm22_l m=x_dut_xm22_m w=x_dut_xm22_w
XM23 net057 net094 vss vss sky130_fd_pr__nfet_01v8 l=x_dut_xm23_l m=x_dut_xm23_m w=x_dut_xm23_w
XM3 net078 VB1 vdd vdd sky130_fd_pr__pfet_01v8 l=x_dut_xm3_l m=x_dut_xm3_m w=x_dut_xm3_w
XM4 VOUTN VOUTN vdd vdd sky130_fd_pr__pfet_01v8 l=x_dut_xm4_l m=x_dut_xm4_m w=x_dut_xm4_w
XM5 net050 VOUTN vdd vdd sky130_fd_pr__pfet_01v8 l=x_dut_xm5_l m=x_dut_xm5_m w=x_dut_xm5_w
XM67 net057 VOUTN vdd vdd sky130_fd_pr__pfet_01v8 l=x_dut_xm67_l m=x_dut_xm67_m w=x_dut_xm67_w
XM9 DM_2 VINN net019 net019 sky130_fd_pr__pfet_01v8 l=x_dut_xm9_l m=x_dut_xm9_m w=x_dut_xm9_w
.ends
