** GENERATED by `analog-db generate` — DO NOT EDIT. Source: abstract/netlist.spice → sky130
* ldo_006_stub (emitted by spicexplorer-circuitgraph)
R1 vdd vref r_top
R2 vref vss r_bot
XM1 vdd vref vout vss sky130_fd_pr__nfet_01v8 l=x_dut_xm1_l m=x_dut_xm1_m w=x_dut_xm1_w
.end
