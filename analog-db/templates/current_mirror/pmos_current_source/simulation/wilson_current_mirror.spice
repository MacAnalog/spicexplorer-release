** sch_path: wilson_current_mirror.sch
**.subckt wilson_current_mirror VDD iin iout
*.iopin VDD
*.iopin iin
*.iopin iout
XM1 net1 net1 VDD VDD sg13_lv_pmos w=0.15u l=0.13u ng=1 m=1
XM2 iout iin net1 VDD sg13_lv_pmos w=0.15u l=0.13u ng=1 m=1
XM3 iin net1 VDD VDD sg13_lv_pmos w=0.15u l=0.13u ng=1 m=1
**.ends
.end
