** GENERATED by `analog-db export-raw` — DO NOT EDIT.
** circuit=amp_032_ti_ldo_error_selfbias  class=amplifier  pdk=sky130  testbench=ac_open_loop  corner=tt
** Self-contained deck: testbench + bound params + lowered DUT (.subckt amp_032_ti_ldo_error_selfbias).
** PDK corner libs resolve by BARE NAME on the image's ngspice sourcepath — run in a
** PDK-enabled env (the base image / api container), NOT a bare host:
**   docker run --rm -i spicexplorer-spice-base:local \
**     bash -lc 'd=$(mktemp -d) && cat > $d/c.spice && cd $d && ngspice -b c.spice' < raw/amp_032_ti_ldo_error_selfbias/sky130/ac_open_loop.spice
*----------------------------------------------------------*
** params: 18 free + 0 frozen knobs (sizing.yaml) · 9 tied · 0 ratio-derived (abstract/params.yaml) · 3 testbench params
** AUTHORED TEMPLATE — amplifier/ac_open_loop_biaswrap (plan D-4; the AnalogGym bias-wrap).
** Open-loop gain measured in closed-loop bias (analoggym-amplifiers skill §5): a 1 TH inductor
** DC-shorts the output back to the inverting input — setting the high-gain operating point —
** while a 1 TF cap AC-opens that feedback and injects the AC input. This is the only way a
** high-gain 3-stage amp biases stably while still exposing its open-loop AC response.
**
** Assumes the AnalogGym canonical DUT port order (self-biased; NO ibias port):
**   .subckt <id> vss vdd vinn vinp vout
** Bindings: DUT VDD VCM CL FSTART FSTOP PPD PDK_INCLUDE.
** FIXED 2026-07-20: this template used to hardcode `X1 0 vdd opout_dc opin opout amp_032_ti_ldo_error_selfbias`,
** which silently assumed the AnalogGym port order [vss vdd vinn vinp vout] and MIS-WIRED any
** DUT declaring a different order (e.g. the amplifier-class [vdd vout vinp vinn vss] swaps
** vdd<->vss). It now uses XDUT vdd vout vinp vinn vss with canonical node names, exactly like the
** *_biaswrap_ibias sibling. For the AnalogGym DUTs this is a no-op: their vss port binds to
** node `vss`, which `Vss vss 0 dc 0` ties to ground just as the old direct-to-0 wiring did.
.lib sky130.lib.spice tt
.temp 27

.param VDD=1.8
.param VCM=0.9
.param CL=10p

Vdd  vdd 0 dc {VDD}
Vss  vss 0 dc 0
Vcm  vinp 0 dc {VCM}          ; common-mode bias on the non-inverting input
Vac  sigin 0 dc 0 ac 1        ; AC stimulus
Lfb  vout vinn 1T        ; 1 TH: DC short (bias), AC open
Cin  vinn sigin 1T        ; 1 TF: DC open, AC inject into the inverting node
CLoad vout 0 {CL}

XDUT vdd vout vinp vinn vss amp_032_ti_ldo_error_selfbias
.control
  set filetype=ascii
  ac dec 101 10 100MEG
  meas ac dcgain FIND vdb(vout) AT=10
  meas ac ugf    WHEN vdb(vout)=0 FALL=1
  let phc = cph(vout)*180/3.14159265
  let ph  = 180 + phc - phc[0]
  meas ac pm     FIND ph WHEN vdb(vout)=0 FALL=1
  * STABILITY GUARDS (2026-08-18, tcas-2026 E-041). `pm` above is a Bode margin and a Bode margin
  * assumes the open loop has no right-half-plane poles. Multistage amps with internal
  * compensation loops (Peng IAC / TCFC and kin) can lose that at a random sizing: the small-
  * signal response then shows phase LEAD instead of lag, `pm` reads 140-585 deg, and the sizing
  * oscillates rail-to-rail in the closed-loop step bench (301/301 such "feasible" sizings did).
  * Finer PPD does not change it (checked at 50/200/1000): the unwrap is right, the premise is
  * wrong. Two additive readings so a reader (or an optimizer spec) can see it without a tran:
  *   pm_min  worst phase distance to -180 deg anywhere |A| > 0 dB (equals pm when the phase is
  *           monotone; <= 0 when the phase touches -180 while the gain is still above unity)
  *   gm      gain margin at the first -180 deg crossing, -999 when the phase never gets there
  * `pm` itself is unchanged. Neither guard replaces the closed-loop step: a sizing with RHP
  * poles can pass both (pm 178, pm_min 22, gm +72 measured on one) and still oscillate. The
  * settling bench (tran_step) is the stability verdict; keep it scored.
  * (masks use `<=` and `1 - mask` only -- see the `>` parser gotcha in stb.spice.)
  let gdb    = vdb(vout)
  let mb     = (gdb <= 0)
  let ma     = 1 - mb
  let pm_min = minimum(ph*ma + 999*mb)
  * |A| never above 0 dB -> no band to take a minimum over -> the NEGATIVE sentinel, so a
  * min-bound spec fails instead of sailing past (stb.spice, 'THE SEED MUST NOT BE A MEASUREMENT')
  let mok    = (pm_min <= 998)
  let pm_min = pm_min*mok + (-999)*(1 - mok)
  let ngdb   = 0 - gdb
  let gm     = -999
  meas ac gm FIND ngdb WHEN ph=0 CROSS=1
  print pm_min gm
  write
  quit
.endc
.param x_dut_xmbp_w=41.49398303677232
.param x_dut_xmbp_l=2.329224498945873
.param x_dut_xmb0_w=58.50180313844321
.param x_dut_xmb0_l=1.482196715977639
.param x_dut_xmbc_m=1
.param x_dut_xmbo_m=1
.param x_dut_xm1_w=54.99700606429666
.param x_dut_xm1_l=0.47938582647537475
.param x_dut_xm3_w=87.01219712226481
.param x_dut_xm3_l=3.4338542074883858
.param x_dut_xm4_w=96.52927518861148
.param x_dut_xm4_l=4.243509159874362
.param x_dut_xm6_w=22.347200240809872
.param x_dut_xm6_l=1.08924987055143
.param r_z=30158.889051230384
.param c_comp=1.0277210259907484e-11
.param x_dut_xmbf_w=9.512915640352748
.param r_nd=7561703.647450356
* ---- GENERATED parameter ties (abstract/params.yaml groups/ratios) ----
* Each tied symbol is defined exactly once, by its line below; rewrite that
* .param to untie just that symbol (untying = shadowing, plan D-3).
.param x_dut_xmbc_l = {x_dut_xmb0_l}
.param x_dut_xmbf_l = {x_dut_xmb0_l}
.param x_dut_xmbo_l = {x_dut_xmb0_l}
.param x_dut_xmbc_w = {x_dut_xmb0_w}
.param x_dut_xmbo_w = {x_dut_xmb0_w}
.param x_dut_xm2_w = {x_dut_xm1_w}
.param x_dut_xm2_l = {x_dut_xm1_l}
.param x_dut_xm5_w = {x_dut_xm3_w}
.param x_dut_xm5_l = {x_dut_xm3_l}
.subckt amp_032_ti_ldo_error_selfbias vdd vout vinp vinn vss
CC ncz vout 'c_comp'
RND na nd 'r_nd'
RZ nb ncz 'r_z'
XM1 na vinn tail vss sky130_fd_pr__nfet_01v8 l=x_dut_xm1_l w=x_dut_xm1_w
XM2 nb vinp tail vss sky130_fd_pr__nfet_01v8 l=x_dut_xm2_l w=x_dut_xm2_w
XM3 na nd vdd vdd sky130_fd_pr__pfet_01v8 l=x_dut_xm3_l w=x_dut_xm3_w
XM4 nlev na nd vdd sky130_fd_pr__pfet_01v8 l=x_dut_xm4_l w=x_dut_xm4_w
XM5 nb nd vdd vdd sky130_fd_pr__pfet_01v8 l=x_dut_xm5_l w=x_dut_xm5_w
XM6 vout nb vdd vdd sky130_fd_pr__pfet_01v8 l=x_dut_xm6_l w=x_dut_xm6_w
XMB0 ibias ibias vss vss sky130_fd_pr__nfet_01v8 l=x_dut_xmb0_l w=x_dut_xmb0_w
XMBC tail ibias vss vss sky130_fd_pr__nfet_01v8 l=x_dut_xmbc_l m=x_dut_xmbc_m w=x_dut_xmbc_w
XMBF nlev ibias vss vss sky130_fd_pr__nfet_01v8 l=x_dut_xmbf_l w=x_dut_xmbf_w
XMBO vout ibias vss vss sky130_fd_pr__nfet_01v8 l=x_dut_xmbo_l m=x_dut_xmbo_m w=x_dut_xmbo_w
XMBP ibias ibias vdd vdd sky130_fd_pr__pfet_01v8 l=x_dut_xmbp_l w=x_dut_xmbp_w
.ends
.end
