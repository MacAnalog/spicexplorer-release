** GENERATED by `analog-db export-raw` — DO NOT EDIT.
** Standalone lowered DUT subckt for ia_003_fan_chopper_pf on ihp-sg13g2 (sizing .param defaults + .subckt).
** Not a runnable deck on its own — include it under your own testbench:
**   .include _dut.spice
**   XDUT vinp vinn voutp voutn vref clk_chin clk_chin_not clk_chfb clk_chfb_not clk_chout clk_chout_not clk_chpf clk_chpf_not vdd vss ia_003_fan_chopper_pf
** Source: pdk/ihp-sg13g2/netlist.spice (run `analog-db generate` to refresh).
*----------------------------------------------------------*
** params: 35 free + 14 frozen knobs (sizing.yaml) · 106 tied · 0 ratio-derived (abstract/params.yaml)
.param x_dut_xm1_w=20u
.param x_dut_xm1_l=1u
.param x_dut_xm2_w=20u
.param x_dut_xm2_l=0.5u
.param x_dut_xm4_w=4.7u
.param x_dut_xm4_l=1u
.param x_dut_xm6_w=10u
.param x_dut_xm8_w=6.2u
.param x_dut_xm10_w=10u
.param x_dut_xm10_l=0.3u
.param x_dut_xm12_w=5u
.param x_dut_xm12_l=0.3u
.param x_dut_xm14_w=6u
.param x_dut_xm14_l=0.5u
.param x_dut_xm16_w=2u
.param x_dut_xm16_l=0.13u
.param x_dut_xm17_w=2u
.param x_dut_xm17_l=0.13u
.param x_dut_xm20_w=2u
.param x_dut_xm20_l=0.13u
.param x_dut_xm21_w=2u
.param x_dut_xm21_l=0.13u
.param x_dut_xm24_w=2u
.param x_dut_xm24_l=0.13u
.param x_dut_xm25_w=2u
.param x_dut_xm25_l=0.13u
.param x_dut_cin1_value=16p
.param x_dut_cfb1_value=0.8p
.param x_dut_cpf1_value=0.8p
.param x_dut_cm1_value=1p
.param x_dut_rb1_value=10Meg
.param vb1=0.5
.param vb2=0.75
.param vb3=0.45
.param vb4=0.55
.param x_dut_xm1_m=1
.param x_dut_xm2_m=1
.param x_dut_xm4_m=1
.param x_dut_xm6_m=1
.param x_dut_xm8_m=1
.param x_dut_xm10_m=1
.param x_dut_xm12_m=1
.param x_dut_xm14_m=1
.param x_dut_xm16_m=1
.param x_dut_xm17_m=1
.param x_dut_xm20_m=1
.param x_dut_xm21_m=1
.param x_dut_xm24_m=1
.param x_dut_xm25_m=1
* ---- GENERATED parameter ties (abstract/params.yaml groups/ratios) ----
* Each tied symbol is defined exactly once, by its line below; rewrite that
* .param to untie just that symbol (untying = shadowing, plan D-3).
.param x_dut_xm3_w = {x_dut_xm2_w}
.param x_dut_xm3_l = {x_dut_xm2_l}
.param x_dut_xm3_m = {x_dut_xm2_m}
.param x_dut_xm5_w = {x_dut_xm4_w}
.param x_dut_xm5_l = {x_dut_xm4_l}
.param x_dut_xm5_m = {x_dut_xm4_m}
.param x_dut_xm13_w = {x_dut_xm12_w}
.param x_dut_xm13_l = {x_dut_xm12_l}
.param x_dut_xm13_m = {x_dut_xm12_m}
.param x_dut_xm11_w = {x_dut_xm10_w}
.param x_dut_xm11_l = {x_dut_xm10_l}
.param x_dut_xm11_m = {x_dut_xm10_m}
.param x_dut_xm7_w = {x_dut_xm6_w}
.param x_dut_xm7_m = {x_dut_xm6_m}
.param x_dut_xm9_w = {x_dut_xm8_w}
.param x_dut_xm9_m = {x_dut_xm8_m}
.param x_dut_xm6_l = {x_dut_xm1_l}
.param x_dut_xm7_l = {x_dut_xm1_l}
.param x_dut_xm8_l = {x_dut_xm1_l}
.param x_dut_xm9_l = {x_dut_xm1_l}
.param x_dut_xm15_w = {x_dut_xm14_w}
.param x_dut_xm15_l = {x_dut_xm14_l}
.param x_dut_xm15_m = {x_dut_xm14_m}
.param x_dut_xm18_w = {x_dut_xm16_w}
.param x_dut_xm32_w = {x_dut_xm16_w}
.param x_dut_xm34_w = {x_dut_xm16_w}
.param x_dut_xm18_l = {x_dut_xm16_l}
.param x_dut_xm32_l = {x_dut_xm16_l}
.param x_dut_xm34_l = {x_dut_xm16_l}
.param x_dut_xm18_m = {x_dut_xm16_m}
.param x_dut_xm32_m = {x_dut_xm16_m}
.param x_dut_xm34_m = {x_dut_xm16_m}
.param x_dut_xm19_w = {x_dut_xm17_w}
.param x_dut_xm33_w = {x_dut_xm17_w}
.param x_dut_xm35_w = {x_dut_xm17_w}
.param x_dut_xm19_l = {x_dut_xm17_l}
.param x_dut_xm33_l = {x_dut_xm17_l}
.param x_dut_xm35_l = {x_dut_xm17_l}
.param x_dut_xm19_m = {x_dut_xm17_m}
.param x_dut_xm33_m = {x_dut_xm17_m}
.param x_dut_xm35_m = {x_dut_xm17_m}
.param x_dut_xm26_w = {x_dut_xm24_w}
.param x_dut_xm36_w = {x_dut_xm24_w}
.param x_dut_xm38_w = {x_dut_xm24_w}
.param x_dut_xm26_l = {x_dut_xm24_l}
.param x_dut_xm36_l = {x_dut_xm24_l}
.param x_dut_xm38_l = {x_dut_xm24_l}
.param x_dut_xm26_m = {x_dut_xm24_m}
.param x_dut_xm36_m = {x_dut_xm24_m}
.param x_dut_xm38_m = {x_dut_xm24_m}
.param x_dut_xm27_w = {x_dut_xm25_w}
.param x_dut_xm37_w = {x_dut_xm25_w}
.param x_dut_xm39_w = {x_dut_xm25_w}
.param x_dut_xm27_l = {x_dut_xm25_l}
.param x_dut_xm37_l = {x_dut_xm25_l}
.param x_dut_xm39_l = {x_dut_xm25_l}
.param x_dut_xm27_m = {x_dut_xm25_m}
.param x_dut_xm37_m = {x_dut_xm25_m}
.param x_dut_xm39_m = {x_dut_xm25_m}
.param x_dut_xm22_w = {x_dut_xm20_w}
.param x_dut_xm28_w = {x_dut_xm20_w}
.param x_dut_xm30_w = {x_dut_xm20_w}
.param x_dut_xm40_w = {x_dut_xm20_w}
.param x_dut_xm42_w = {x_dut_xm20_w}
.param x_dut_xm44_w = {x_dut_xm20_w}
.param x_dut_xm46_w = {x_dut_xm20_w}
.param x_dut_xm22_l = {x_dut_xm20_l}
.param x_dut_xm28_l = {x_dut_xm20_l}
.param x_dut_xm30_l = {x_dut_xm20_l}
.param x_dut_xm40_l = {x_dut_xm20_l}
.param x_dut_xm42_l = {x_dut_xm20_l}
.param x_dut_xm44_l = {x_dut_xm20_l}
.param x_dut_xm46_l = {x_dut_xm20_l}
.param x_dut_xm22_m = {x_dut_xm20_m}
.param x_dut_xm28_m = {x_dut_xm20_m}
.param x_dut_xm30_m = {x_dut_xm20_m}
.param x_dut_xm40_m = {x_dut_xm20_m}
.param x_dut_xm42_m = {x_dut_xm20_m}
.param x_dut_xm44_m = {x_dut_xm20_m}
.param x_dut_xm46_m = {x_dut_xm20_m}
.param x_dut_xm23_w = {x_dut_xm21_w}
.param x_dut_xm29_w = {x_dut_xm21_w}
.param x_dut_xm31_w = {x_dut_xm21_w}
.param x_dut_xm41_w = {x_dut_xm21_w}
.param x_dut_xm43_w = {x_dut_xm21_w}
.param x_dut_xm45_w = {x_dut_xm21_w}
.param x_dut_xm47_w = {x_dut_xm21_w}
.param x_dut_xm23_l = {x_dut_xm21_l}
.param x_dut_xm29_l = {x_dut_xm21_l}
.param x_dut_xm31_l = {x_dut_xm21_l}
.param x_dut_xm41_l = {x_dut_xm21_l}
.param x_dut_xm43_l = {x_dut_xm21_l}
.param x_dut_xm45_l = {x_dut_xm21_l}
.param x_dut_xm47_l = {x_dut_xm21_l}
.param x_dut_xm23_m = {x_dut_xm21_m}
.param x_dut_xm29_m = {x_dut_xm21_m}
.param x_dut_xm31_m = {x_dut_xm21_m}
.param x_dut_xm41_m = {x_dut_xm21_m}
.param x_dut_xm43_m = {x_dut_xm21_m}
.param x_dut_xm45_m = {x_dut_xm21_m}
.param x_dut_xm47_m = {x_dut_xm21_m}
.param x_dut_cin2_value = {x_dut_cin1_value}
.param x_dut_cfb2_value = {x_dut_cfb1_value}
.param x_dut_cpf2_value = {x_dut_cpf1_value}
.param x_dut_cm2_value = {x_dut_cm1_value}
.param x_dut_rb2_value = {x_dut_rb1_value}
.subckt ia_003_fan_chopper_pf vinp vinn voutp voutn vref clk_chin clk_chin_not clk_chfb clk_chfb_not clk_chout clk_chout_not clk_chpf clk_chpf_not vdd vss
CFB1 fbch_p vsum_n 'x_dut_cfb1_value'
CFB2 fbch_n vsum_p 'x_dut_cfb2_value'
CIN1 vsum_n inch_n 'x_dut_cin1_value'
CIN2 vsum_p inch_p 'x_dut_cin2_value'
CM1 g2_p voutp 'x_dut_cm1_value'
CM2 g2_n voutn 'x_dut_cm2_value'
CPF1 pfch_p inch_p 'x_dut_cpf1_value'
CPF2 pfch_n inch_n 'x_dut_cpf2_value'
RB1 vsum_n vref 'x_dut_rb1_value'
RB2 vsum_p vref 'x_dut_rb2_value'
VB1 vb1 vss dc {vb1}
VB2 vb2 vss dc {vb2}
VB3 vb3 vss dc {vb3}
VB4 vb4 vss dc {vb4}
XM1 tail vb4 vdd vdd sg13_lv_pmos l=x_dut_xm1_l m=x_dut_xm1_m w=x_dut_xm1_w
XM10 out1_n vb3 casc_src_n vdd sg13_lv_pmos l=x_dut_xm10_l m=x_dut_xm10_m w=x_dut_xm10_w
XM11 out1_p vb3 casc_src_p vdd sg13_lv_pmos l=x_dut_xm11_l m=x_dut_xm11_m w=x_dut_xm11_w
XM12 out1_p vb2 fold_p vss sg13_lv_nmos l=x_dut_xm12_l m=x_dut_xm12_m w=x_dut_xm12_w
XM13 out1_n vb2 fold_n vss sg13_lv_nmos l=x_dut_xm13_l m=x_dut_xm13_m w=x_dut_xm13_w
XM14 voutp g2_p vss vss sg13_lv_nmos l=x_dut_xm14_l m=x_dut_xm14_m w=x_dut_xm14_w
XM15 voutn g2_n vss vss sg13_lv_nmos l=x_dut_xm15_l m=x_dut_xm15_m w=x_dut_xm15_w
XM16 out1_n clk_chout g2_n vss sg13_lv_nmos l=x_dut_xm16_l m=x_dut_xm16_m w=x_dut_xm16_w
XM17 g2_n clk_chout_not out1_n vdd sg13_lv_pmos l=x_dut_xm17_l m=x_dut_xm17_m w=x_dut_xm17_w
XM18 out1_p clk_chout g2_p vss sg13_lv_nmos l=x_dut_xm18_l m=x_dut_xm18_m w=x_dut_xm18_w
XM19 g2_p clk_chout_not out1_p vdd sg13_lv_pmos l=x_dut_xm19_l m=x_dut_xm19_m w=x_dut_xm19_w
XM2 fold_p vsum_p tail vdd sg13_lv_pmos l=x_dut_xm2_l m=x_dut_xm2_m w=x_dut_xm2_w
XM20 fbch_p clk_chfb voutp vss sg13_lv_nmos l=x_dut_xm20_l m=x_dut_xm20_m w=x_dut_xm20_w
XM21 voutp clk_chfb_not fbch_p vdd sg13_lv_pmos l=x_dut_xm21_l m=x_dut_xm21_m w=x_dut_xm21_w
XM22 fbch_n clk_chfb voutn vss sg13_lv_nmos l=x_dut_xm22_l m=x_dut_xm22_m w=x_dut_xm22_w
XM23 voutn clk_chfb_not fbch_n vdd sg13_lv_pmos l=x_dut_xm23_l m=x_dut_xm23_m w=x_dut_xm23_w
XM24 vinn clk_chin inch_n vss sg13_lv_nmos l=x_dut_xm24_l m=x_dut_xm24_m w=x_dut_xm24_w
XM25 inch_n clk_chin_not vinn vdd sg13_lv_pmos l=x_dut_xm25_l m=x_dut_xm25_m w=x_dut_xm25_w
XM26 vinp clk_chin inch_p vss sg13_lv_nmos l=x_dut_xm26_l m=x_dut_xm26_m w=x_dut_xm26_w
XM27 inch_p clk_chin_not vinp vdd sg13_lv_pmos l=x_dut_xm27_l m=x_dut_xm27_m w=x_dut_xm27_w
XM28 pfch_p clk_chpf voutp vss sg13_lv_nmos l=x_dut_xm28_l m=x_dut_xm28_m w=x_dut_xm28_w
XM29 voutp clk_chpf_not pfch_p vdd sg13_lv_pmos l=x_dut_xm29_l m=x_dut_xm29_m w=x_dut_xm29_w
XM3 fold_n vsum_n tail vdd sg13_lv_pmos l=x_dut_xm3_l m=x_dut_xm3_m w=x_dut_xm3_w
XM30 pfch_n clk_chpf voutn vss sg13_lv_nmos l=x_dut_xm30_l m=x_dut_xm30_m w=x_dut_xm30_w
XM31 voutn clk_chpf_not pfch_n vdd sg13_lv_pmos l=x_dut_xm31_l m=x_dut_xm31_m w=x_dut_xm31_w
XM32 out1_n clk_chout_not g2_p vss sg13_lv_nmos l=x_dut_xm32_l m=x_dut_xm32_m w=x_dut_xm32_w
XM33 g2_p clk_chout out1_n vdd sg13_lv_pmos l=x_dut_xm33_l m=x_dut_xm33_m w=x_dut_xm33_w
XM34 out1_p clk_chout_not g2_n vss sg13_lv_nmos l=x_dut_xm34_l m=x_dut_xm34_m w=x_dut_xm34_w
XM35 g2_n clk_chout out1_p vdd sg13_lv_pmos l=x_dut_xm35_l m=x_dut_xm35_m w=x_dut_xm35_w
XM36 vinn clk_chin_not inch_p vss sg13_lv_nmos l=x_dut_xm36_l m=x_dut_xm36_m w=x_dut_xm36_w
XM37 inch_p clk_chin vinn vdd sg13_lv_pmos l=x_dut_xm37_l m=x_dut_xm37_m w=x_dut_xm37_w
XM38 vinp clk_chin_not inch_n vss sg13_lv_nmos l=x_dut_xm38_l m=x_dut_xm38_m w=x_dut_xm38_w
XM39 inch_n clk_chin vinp vdd sg13_lv_pmos l=x_dut_xm39_l m=x_dut_xm39_m w=x_dut_xm39_w
XM4 fold_p vb1 vss vss sg13_lv_nmos l=x_dut_xm4_l m=x_dut_xm4_m w=x_dut_xm4_w
XM40 fbch_p clk_chfb_not voutn vss sg13_lv_nmos l=x_dut_xm40_l m=x_dut_xm40_m w=x_dut_xm40_w
XM41 voutn clk_chfb fbch_p vdd sg13_lv_pmos l=x_dut_xm41_l m=x_dut_xm41_m w=x_dut_xm41_w
XM42 fbch_n clk_chfb_not voutp vss sg13_lv_nmos l=x_dut_xm42_l m=x_dut_xm42_m w=x_dut_xm42_w
XM43 voutp clk_chfb fbch_n vdd sg13_lv_pmos l=x_dut_xm43_l m=x_dut_xm43_m w=x_dut_xm43_w
XM44 pfch_p clk_chpf_not voutn vss sg13_lv_nmos l=x_dut_xm44_l m=x_dut_xm44_m w=x_dut_xm44_w
XM45 voutn clk_chpf pfch_p vdd sg13_lv_pmos l=x_dut_xm45_l m=x_dut_xm45_m w=x_dut_xm45_w
XM46 pfch_n clk_chpf_not voutp vss sg13_lv_nmos l=x_dut_xm46_l m=x_dut_xm46_m w=x_dut_xm46_w
XM47 voutp clk_chpf pfch_n vdd sg13_lv_pmos l=x_dut_xm47_l m=x_dut_xm47_m w=x_dut_xm47_w
XM5 fold_n vb1 vss vss sg13_lv_nmos l=x_dut_xm5_l m=x_dut_xm5_m w=x_dut_xm5_w
XM6 casc_src_n vb4 vdd vdd sg13_lv_pmos l=x_dut_xm6_l m=x_dut_xm6_m w=x_dut_xm6_w
XM7 casc_src_p vb4 vdd vdd sg13_lv_pmos l=x_dut_xm7_l m=x_dut_xm7_m w=x_dut_xm7_w
XM8 voutp vb4 vdd vdd sg13_lv_pmos l=x_dut_xm8_l m=x_dut_xm8_m w=x_dut_xm8_w
XM9 voutn vb4 vdd vdd sg13_lv_pmos l=x_dut_xm9_l m=x_dut_xm9_m w=x_dut_xm9_w
.ends
