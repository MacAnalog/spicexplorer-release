** GENERATED by `analog-db export-raw` — DO NOT EDIT.
** circuit=amp_021_yan_az  class=amplifier  pdk=tsmc-n65  testbench=dc_op  corner=tt
** Self-contained deck: testbench + bound params + lowered DUT (.subckt amp_021_yan_az).
** PDK corner libs resolve by BARE NAME on the image's ngspice sourcepath — run in a
** PDK-enabled env (the base image / api container), NOT a bare host:
**   docker run --rm -i spicexplorer-spice-base:local \
**     bash -lc 'd=$(mktemp -d) && cat > $d/c.spice && cd $d && ngspice -b c.spice' < raw/amp_021_yan_az/tsmc-n65/dc_op.spice
*----------------------------------------------------------*
** params: 36 free + 0 frozen knobs (sizing.yaml) · 27 tied · 6 ratio-derived (abstract/params.yaml) · 2 testbench params
** AUTHORED TEMPLATE — amplifier/dc_op_biaswrap: DC operating point + supply current for DUTs on
** the AnalogGym self-bias convention (ports vss vdd vinn vinp vout; NO ibias port). Self-bias
** companion of the universal dc_op (M4 follow-up): a high-gain multistage OTA has no stable
** open-loop DC op point (it rails), so i_supply read open-loop is non-representative. Close the DC
** feedback exactly as ac_open_loop_biaswrap does — Lfb DC-shorts vout back to the inverting input
** (unity DC feedback), pinning the real quiescent operating point (vout ≈ VCM) — then read the
** supply current there. No Cin/Vac: this is a pure DC .op (an inductor is a DC short, so the loop
** is closed at DC).
**
** Assumes the AnalogGym canonical DUT port order (self-biased; NO ibias port):
**   .subckt <id> vss vdd vinn vinp vout
** Bindings: DUT VDD VCM PDK_INCLUDE.
** FIXED 2026-07-20: this template used to hardcode `X1 0 vdd opout_dc opin opout amp_021_yan_az`,
** which silently assumed the AnalogGym port order [vss vdd vinn vinp vout] and MIS-WIRED any
** DUT declaring a different order (e.g. the amplifier-class [vdd vout vinp vinn vss] swaps
** vdd<->vss). It now uses XDUT vss vdd vinn vinp vout with canonical node names, exactly like the
** *_biaswrap_ibias sibling. For the AnalogGym DUTs this is a no-op: their vss port binds to
** node `vss`, which `Vss vss 0 dc 0` ties to ground just as the old direct-to-0 wiring did.
.lib tsmc_n65_models.scs tt
.temp 27

.param VDD=1.8
.param VCM=300m

Vdd  vdd 0 dc {VDD}
Vss  vss 0 dc 0
Vcm  vinp 0 dc {VCM}          ; common-mode bias on the non-inverting input
Lfb  vout vinn 1T        ; 1 TH: DC short → unity feedback sets the quiescent op point

XDUT vss vdd vinn vinp vout amp_021_yan_az
.control
  set filetype=ascii
  op
  let i_supply = abs(i(Vdd))
  * Input-referred systematic offset: the Lfb DC short makes this a unity-gain follower, so the
  * settled (vout - vinp) IS the input offset. Additive metric (2026-07-20) — existing measures
  * are untouched; a topology with a deliberately ratioed sink (e.g. the TI LDO error amp's
  * mirror_e) shows a large vos here, which also caps its ICMR tracking band.
  let vos = v(vout) - v(vinp)
  print i_supply vos
  write
  quit
.endc
.param CAPACITOR_0=1.4p
.param CAPACITOR_1=1.3p
.param CURRENT_1_BIAS=5u
.param x_dut_xm67_l=1u
.param x_dut_xm67_m=4
.param x_dut_xm67_w=1u
.param x_dut_xm11_l=1u
.param x_dut_xm11_m=4
.param x_dut_xm11_w=1u
.param x_dut_xm13_l=1u
.param x_dut_xm13_m=4
.param x_dut_xm13_w=1u
.param x_dut_xm14_l=1u
.param x_dut_xm14_m=4
.param x_dut_xm14_w=1u
.param x_dut_xm16_l=1u
.param x_dut_xm16_m=4
.param x_dut_xm16_w=1u
.param x_dut_xm18_l=1u
.param x_dut_xm18_m=4
.param x_dut_xm18_w=1u
.param x_dut_xm19_l=1u
.param x_dut_xm19_m=4
.param x_dut_xm19_w=1u
.param x_dut_xm22_l=1u
.param x_dut_xm22_m=4
.param x_dut_xm22_w=1u
.param x_dut_xm23_l=1u
.param x_dut_xm23_m=4
.param x_dut_xm23_w=1u
.param x_dut_xm10_l=1u
.param x_dut_xm10_m=4
.param x_dut_xm10_w=1u
.param RESISTOR_0=240k
.param RESISTOR_1=85.7k
.param RESISTOR_2=85.7K
* ---- GENERATED parameter ties (abstract/params.yaml groups/ratios) ----
* Each tied symbol is defined exactly once, by its line below; rewrite that
* .param to untie just that symbol (untying = shadowing, plan D-3).
.param x_dut_xm3_w = {x_dut_xm67_w}
.param x_dut_xm5_w = {x_dut_xm67_w}
.param x_dut_xm4_w = {x_dut_xm67_w}
.param x_dut_xm2_w = {x_dut_xm67_w}
.param x_dut_xm1_w = {x_dut_xm67_w}
.param x_dut_xm0_w = {x_dut_xm67_w}
.param x_dut_xm3_l = {x_dut_xm67_l}
.param x_dut_xm5_l = {x_dut_xm67_l}
.param x_dut_xm4_l = {x_dut_xm67_l}
.param x_dut_xm2_l = {x_dut_xm67_l}
.param x_dut_xm1_l = {x_dut_xm67_l}
.param x_dut_xm0_l = {x_dut_xm67_l}
.param x_dut_xm9_w = {x_dut_xm10_w}
.param x_dut_xm9_l = {x_dut_xm10_l}
.param x_dut_xm9_m = {x_dut_xm10_m}
.param x_dut_xm17_w = {x_dut_xm16_w}
.param x_dut_xm17_l = {x_dut_xm16_l}
.param x_dut_xm17_m = {x_dut_xm16_m}
.param x_dut_xm20_w = {x_dut_xm19_w}
.param x_dut_xm21_w = {x_dut_xm19_w}
.param x_dut_xm20_l = {x_dut_xm19_l}
.param x_dut_xm21_l = {x_dut_xm19_l}
.param x_dut_xm20_m = {x_dut_xm19_m}
.param x_dut_xm21_m = {x_dut_xm19_m}
.param x_dut_xm15_w = {x_dut_xm14_w}
.param x_dut_xm15_l = {x_dut_xm14_l}
.param x_dut_xm15_m = {x_dut_xm14_m}
.param x_dut_xm3_m = {x_dut_xm67_m*4}
.param x_dut_xm5_m = {x_dut_xm67_m*1}
.param x_dut_xm4_m = {x_dut_xm67_m*1}
.param x_dut_xm2_m = {x_dut_xm67_m*2}
.param x_dut_xm1_m = {x_dut_xm67_m*1}
.param x_dut_xm0_m = {x_dut_xm67_m*1}
.subckt amp_021_yan_az vss vdd vinn vinp vout
C0 net063 VOUT 'CAPACITOR_1'
C1 net051 vss 'CAPACITOR_0'
I0 VB1 vss 'CURRENT_1_BIAS'
R0 net078 net077 'RESISTOR_1'
R1 net078 net082 'RESISTOR_2'
R2 net094 net051 'RESISTOR_0'
XM0 VB1 VB1 vdd vdd pch_lvt l=x_dut_xm0_l m=x_dut_xm0_m w=x_dut_xm0_w
XM1 VB4 VB1 vdd vdd pch_lvt l=x_dut_xm1_l m=x_dut_xm1_m w=x_dut_xm1_w
XM10 net063 VINP net019 net019 pch_lvt l=x_dut_xm10_l m=x_dut_xm10_m w=x_dut_xm10_w
XM11 net094 net050 vdd vdd pch_lvt l=x_dut_xm11_l m=x_dut_xm11_m w=x_dut_xm11_w
XM13 VOUT net050 vdd vdd pch_lvt l=x_dut_xm13_l m=x_dut_xm13_m w=x_dut_xm13_w
XM14 VOUTN net077 DM_2 vss nch_lvt l=x_dut_xm14_l m=x_dut_xm14_m w=x_dut_xm14_w
XM15 net050 net082 net063 vss nch_lvt l=x_dut_xm15_l m=x_dut_xm15_m w=x_dut_xm15_w
XM16 net077 DM_2 vss vss nch_lvt l=x_dut_xm16_l m=x_dut_xm16_m w=x_dut_xm16_w
XM17 net082 net063 vss vss nch_lvt l=x_dut_xm17_l m=x_dut_xm17_m w=x_dut_xm17_w
XM18 VOUT net057 vss vss nch_lvt l=x_dut_xm18_l m=x_dut_xm18_m w=x_dut_xm18_w
XM19 VB4 VB4 vss vss nch_lvt l=x_dut_xm19_l m=x_dut_xm19_m w=x_dut_xm19_w
XM2 net019 VB1 vdd vdd pch_lvt l=x_dut_xm2_l m=x_dut_xm2_m w=x_dut_xm2_w
XM20 DM_2 VB4 vss vss nch_lvt l=x_dut_xm20_l m=x_dut_xm20_m w=x_dut_xm20_w
XM21 net063 VB4 vss vss nch_lvt l=x_dut_xm21_l m=x_dut_xm21_m w=x_dut_xm21_w
XM22 net094 net051 vss vss nch_lvt l=x_dut_xm22_l m=x_dut_xm22_m w=x_dut_xm22_w
XM23 net057 net094 vss vss nch_lvt l=x_dut_xm23_l m=x_dut_xm23_m w=x_dut_xm23_w
XM3 net078 VB1 vdd vdd pch_lvt l=x_dut_xm3_l m=x_dut_xm3_m w=x_dut_xm3_w
XM4 VOUTN VOUTN vdd vdd pch_lvt l=x_dut_xm4_l m=x_dut_xm4_m w=x_dut_xm4_w
XM5 net050 VOUTN vdd vdd pch_lvt l=x_dut_xm5_l m=x_dut_xm5_m w=x_dut_xm5_w
XM67 net057 VOUTN vdd vdd pch_lvt l=x_dut_xm67_l m=x_dut_xm67_m w=x_dut_xm67_w
XM9 DM_2 VINN net019 net019 pch_lvt l=x_dut_xm9_l m=x_dut_xm9_m w=x_dut_xm9_w
.ends
.end
