** GENERATED by `analog-db generate` — DO NOT EDIT. Source: abstract/netlist.spice → tsmc-n65
* amp_032_ti_ldo_error_selfbias (emitted by spicexplorer-circuitgraph)
CC ncz vout 'c_comp'
RND na nd 'r_nd'
RZ nb ncz 'r_z'
XM1 na vinn tail vss nch_lvt l=x_dut_xm1_l w=x_dut_xm1_w
XM2 nb vinp tail vss nch_lvt l=x_dut_xm2_l w=x_dut_xm2_w
XM3 na nd vdd vdd pch_lvt l=x_dut_xm3_l w=x_dut_xm3_w
XM4 nlev na nd vdd pch_lvt l=x_dut_xm4_l w=x_dut_xm4_w
XM5 nb nd vdd vdd pch_lvt l=x_dut_xm5_l w=x_dut_xm5_w
XM6 vout nb vdd vdd pch_lvt l=x_dut_xm6_l w=x_dut_xm6_w
XMB0 ibias ibias vss vss nch_lvt l=x_dut_xmb0_l w=x_dut_xmb0_w
XMBC tail ibias vss vss nch_lvt l=x_dut_xmbc_l m=x_dut_xmbc_m w=x_dut_xmbc_w
XMBF nlev ibias vss vss nch_lvt l=x_dut_xmbf_l w=x_dut_xmbf_w
XMBO vout ibias vss vss nch_lvt l=x_dut_xmbo_l m=x_dut_xmbo_m w=x_dut_xmbo_w
XMBP ibias ibias vdd vdd pch_lvt l=x_dut_xmbp_l w=x_dut_xmbp_w
.end
