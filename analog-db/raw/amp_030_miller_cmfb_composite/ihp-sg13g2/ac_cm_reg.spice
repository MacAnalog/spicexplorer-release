** GENERATED by `analog-db export-raw` — DO NOT EDIT.
** circuit=amp_030_miller_cmfb_composite  class=amplifier  pdk=ihp-sg13g2  testbench=ac_cm_reg  corner=tt
** Self-contained deck: testbench + bound params + lowered DUT (.subckt amp_030_miller_cmfb_composite).
** PDK corner libs resolve by BARE NAME on the image's ngspice sourcepath — run in a
** PDK-enabled env (the base image / api container), NOT a bare host:
**   docker run --rm -i spicexplorer-spice-base:local \
**     bash -lc 'd=$(mktemp -d) && cat > $d/c.spice && cd $d && ngspice -b c.spice' < raw/amp_030_miller_cmfb_composite/ihp-sg13g2/ac_cm_reg.spice
*----------------------------------------------------------*
** params: 21 free + 6 frozen knobs (sizing.yaml) · 17 tied · 0 ratio-derived (abstract/params.yaml) · 3 testbench params
** AUTHORED TEMPLATE — amplifier/ac_cm_reg (CM-loop health, frequency domain).
** Closed-loop COMMON-MODE output impedance: a unit AC common-mode current (0.5 A per
** side) is injected into both outputs; vocm/(1 A) = |Zcm(f)|. The CM feedback loop
** suppresses Zcm in-band, so:
**   zcm_lf_ohm     low-frequency Zcm — the CM stiffness the servo achieves
**   zcm_peak_ohm   the sweep maximum
**   cm_peaking_db  20*log10(peak/lf) — impedance peaking; a large value flags an
**                  underdamped CM loop (the external signature of poor CM phase margin)
** HONESTY NOTE: the internal CM loop gain/phase (T_cm, PM_cm) cannot be probed from a
** bench without breaking the loop inside the DUT — that is a composition-time
** measurement (insert a VIPRB/stb probe in the CMFB path of a composed variant). This
** bench measures the closed-loop observables that T_cm determines.
**
** Assumes a self-biased, differential-output DUT with a CM control loop:
**   .subckt <id> vinp vinn voutp voutn vdd vss
** Required bindings: DUT PORT_LINE VDD VCM CL FSTART FSTOP PPD PDK_INCLUDE.
.lib cornerMOSlv.lib mos_tt
.lib cornerRES.lib res_typ
.temp 27

.param VDD=1.2
.param VCM=0.6
.param CL=50f

Vdd  vdd 0 dc {VDD}
Vss  vss 0 dc 0
CLoadp voutp 0 {CL}
CLoadn voutn 0 {CL}
Vcm  vcm 0 dc {VCM}
Vinp vinp vcm dc 0
Vinn vinn vcm dc 0
* unit common-mode current injection (0.5 A AC per side -> 1 A total CM)
Icmp 0 voutp dc 0 ac 0.5
Icmn 0 voutn dc 0 ac 0.5

XDUT vinp vinn voutp voutn vdd vss amp_030_miller_cmfb_composite

.control
  set filetype=ascii
  ac dec 41 100 1G
  let zcm = mag((v(voutp)+v(voutn))/2)
  meas ac zcm_lf_ohm FIND zcm AT=100
  meas ac zcm_pk MAX zcm
  * MAX meas lines carry an `at=` suffix the result parser skips - re-print clean
  let zcm_peak_ohm = zcm_pk
  let cm_peaking_db = 20*log10(zcm_pk/zcm_lf_ohm)
  print zcm_peak_ohm cm_peaking_db
  write
  quit
.endc
.param x_dut_xm1_core_w=10u
.param x_dut_xm1_core_l=0.5u
.param x_dut_xm3_core_w=10u
.param x_dut_xm3_core_l=1u
.param x_dut_xm5_core_w=12u
.param x_dut_xm5_core_l=0.5u
.param x_dut_xm6_core_w=2u
.param x_dut_xm6_core_l=1u
.param x_dut_xm7_core_w=6u
.param x_dut_xm8_core_w=2u
.param x_dut_r1_core_value=2k
.param x_dut_c1_core_value=1p
.param i_bias_core=20u
.param x_dut_xm1_core_m=1
.param x_dut_xm3_core_m=1
.param x_dut_xm5_core_m=1
.param x_dut_xm6_core_m=1
.param x_dut_xm7_core_m=1
.param x_dut_xm8_core_m=1
.param gm_val_servo=100u
.param rout_val_servo=10k
.param cout_val_servo=100f
.param rin_val_servo=1e12
.param cin_val_servo=10f
.param x_dut_rmp_servo_value=1Meg
.param vcm_ref=0.6
.param vbl0=0.71
* ---- GENERATED parameter ties (abstract/params.yaml groups/ratios) ----
* Each tied symbol is defined exactly once, by its line below; rewrite that
* .param to untie just that symbol (untying = shadowing, plan D-3).
.param x_dut_xm10_core_l = {x_dut_xm6_core_l}
.param x_dut_xm7_core_l = {x_dut_xm6_core_l}
.param x_dut_xm8_core_l = {x_dut_xm6_core_l}
.param x_dut_xm2_core_w = {x_dut_xm1_core_w}
.param x_dut_xm2_core_l = {x_dut_xm1_core_l}
.param x_dut_xm2_core_m = {x_dut_xm1_core_m}
.param x_dut_xm4_core_w = {x_dut_xm3_core_w}
.param x_dut_xm4_core_l = {x_dut_xm3_core_l}
.param x_dut_xm4_core_m = {x_dut_xm3_core_m}
.param x_dut_xm9_core_w = {x_dut_xm5_core_w}
.param x_dut_xm9_core_l = {x_dut_xm5_core_l}
.param x_dut_xm9_core_m = {x_dut_xm5_core_m}
.param x_dut_xm10_core_w = {x_dut_xm7_core_w}
.param x_dut_xm10_core_m = {x_dut_xm7_core_m}
.param x_dut_r2_core_value = {x_dut_r1_core_value}
.param x_dut_c2_core_value = {x_dut_c1_core_value}
.param x_dut_rmn_servo_value = {x_dut_rmp_servo_value}
.subckt amp_030_miller_cmfb_composite vinp vinn voutp voutn vdd vss
C1_CORE core__mill_p voutp 'x_dut_c1_core_value'
C2_CORE core__mill_n voutn 'x_dut_c2_core_value'
CIN_SERVO_SERVO servo__cm_sense vref_cm 'cin_val_servo'
COUT_SERVO_SERVO vss vcmfb_raw 'cout_val_servo'
GM_SERVO_SERVO vss vcmfb_raw vref_cm servo__cm_sense {gm_val_servo}
IBIAS_CORE vdd core__ref dc {i_bias_core}
R1_CORE core__stg1p core__mill_p 'x_dut_r1_core_value'
R2_CORE core__stg1n core__mill_n 'x_dut_r2_core_value'
RIN_SERVO_SERVO servo__cm_sense vref_cm 'rin_val_servo'
RMN_SERVO voutn servo__cm_sense 'x_dut_rmn_servo_value'
RMP_SERVO servo__cm_sense voutp 'x_dut_rmp_servo_value'
ROUT_SERVO_SERVO vss vcmfb_raw 'rout_val_servo'
VBL0 vbl_ctl vcmfb_raw dc {vbl0}
VREFCM vref_cm vss dc {vcm_ref}
XM10_CORE voutn core__ref vss vss sg13_lv_nmos l=x_dut_xm10_core_l m=x_dut_xm10_core_m w=x_dut_xm10_core_w
XM1_CORE core__stg1p vinp core__tail vss sg13_lv_nmos l=x_dut_xm1_core_l m=x_dut_xm1_core_m w=x_dut_xm1_core_w
XM2_CORE core__stg1n vinn core__tail vss sg13_lv_nmos l=x_dut_xm2_core_l m=x_dut_xm2_core_m w=x_dut_xm2_core_w
XM3_CORE core__stg1p vbl_ctl vdd vdd sg13_lv_pmos l=x_dut_xm3_core_l m=x_dut_xm3_core_m w=x_dut_xm3_core_w
XM4_CORE core__stg1n vbl_ctl vdd vdd sg13_lv_pmos l=x_dut_xm4_core_l m=x_dut_xm4_core_m w=x_dut_xm4_core_w
XM5_CORE voutp core__stg1p vdd vdd sg13_lv_pmos l=x_dut_xm5_core_l m=x_dut_xm5_core_m w=x_dut_xm5_core_w
XM6_CORE core__ref core__ref vss vss sg13_lv_nmos l=x_dut_xm6_core_l m=x_dut_xm6_core_m w=x_dut_xm6_core_w
XM7_CORE voutp core__ref vss vss sg13_lv_nmos l=x_dut_xm7_core_l m=x_dut_xm7_core_m w=x_dut_xm7_core_w
XM8_CORE core__tail core__ref vss vss sg13_lv_nmos l=x_dut_xm8_core_l m=x_dut_xm8_core_m w=x_dut_xm8_core_w
XM9_CORE voutn core__stg1n vdd vdd sg13_lv_pmos l=x_dut_xm9_core_l m=x_dut_xm9_core_m w=x_dut_xm9_core_w
.ends
.end
