** Abstract two-stage, Miller-compensated, fully-differential OTA with a passive resistive
** common-mode servo on the first-stage PMOS load gate. AUTHORED source of truth (plan D-2).
** PDK-neutral model tokens (nmos/pmos); per-PDK device names + geometry come from
** circuitgraph lowering + pdk/<pdk>/{devices.map,sizing}.yaml.
** Subckt port order (= circuit.yaml ports): vinp vinn voutp voutn vdd vss
**
** Topology (from templates/OTA-Two-Stage/two-stage-miller-comp-common-mode-control.sch,
** parameterized here after headless-xschem netlisting against the vendored IHP PDK symbol
** library — see pdk/ihp-sg13g2/schematic/):
**   stage 1 — NMOS diff pair (M1/M2) with PMOS current-source loads (M3/M4). The load gate
**     (node cmfb) is NOT diode-connected; instead it is servoed by a passive RC common-mode
**     averager off the stage-1 outputs (stg1p/stg1n): a direct resistor leg (r_cmfb) in
**     parallel with a series R-C leg (r_cmfb_hf + c_cmfb_hf) per side, adding HF shaping to
**     the CM-servo loop. This is the "common mode control" the source schematic is named for
**     — it fixes stage 1's internal common-mode point without a diode-connected load.
**   stage 2 — two independent common-source amplifiers (M5+M7 -> voutp, M9+M10 -> voutn)
**     sharing one diode-connected NMOS bias reference (M6). The reference current is set by
**     an INTERNAL current source (i_bias) — self-biased, no external ibias port (unlike
**     amp_001_5t, whose tail mirror reference is externally driven).
**   compensation — per-side Miller R-C (r_miller/c_miller) from each stage-1 output to its
**     own stage-2 output.
**.subckt amp_020_two_stage_miller_cmfb vinp vinn voutp voutn vdd vss
* --- stage 1: NMOS input pair ---
XM1 stg1p vinp tail vss nmos w=x_dut_xm1_w l=x_dut_xm1_l m=x_dut_xm1_m
XM2 stg1n vinn tail vss nmos w=x_dut_xm2_w l=x_dut_xm2_l m=x_dut_xm2_m
* --- stage 1: PMOS current-source loads, gate servoed by the CM-servo network (node cmfb) ---
XM3 stg1p cmfb vdd vdd pmos w=x_dut_xm3_w l=x_dut_xm3_l m=x_dut_xm3_m
XM4 stg1n cmfb vdd vdd pmos w=x_dut_xm4_w l=x_dut_xm4_l m=x_dut_xm4_m
* --- stage 2: common-source amplifiers (one per side) ---
XM5 voutp stg1p vdd vdd pmos w=x_dut_xm5_w l=x_dut_xm5_l m=x_dut_xm5_m
XM9 voutn stg1n vdd vdd pmos w=x_dut_xm9_w l=x_dut_xm9_l m=x_dut_xm9_m
XM7 voutp ref vss vss nmos w=x_dut_xm7_w l=x_dut_xm7_l m=x_dut_xm7_m
XM10 voutn ref vss vss nmos w=x_dut_xm10_w l=x_dut_xm10_l m=x_dut_xm10_m
* --- bias: diode-connected reference + input-pair tail sink, both mirrored from ref ---
XM6 ref ref vss vss nmos w=x_dut_xm6_w l=x_dut_xm6_l m=x_dut_xm6_m
XM8 tail ref vss vss nmos w=x_dut_xm8_w l=x_dut_xm8_l m=x_dut_xm8_m
Ibias vdd ref dc {i_bias}
* --- per-side Miller compensation (stage-1 output -> stage-2 output) ---
R1 stg1p mill_p 'x_dut_r1_value'
C1 mill_p voutp 'x_dut_c1_value'
R2 stg1n mill_n 'x_dut_r2_value'
C2 mill_n voutn 'x_dut_c2_value'
* --- common-mode servo: resistive averager (r_cmfb) + a parallel HF-shaping R-C leg ---
R3 cmfb stg1p 'x_dut_r3_value'
R4 stg1n cmfb 'x_dut_r4_value'
C3 cmz_p stg1p 'x_dut_c3_value'
C4 stg1n cmz_n 'x_dut_c4_value'
R5 cmfb cmz_p 'x_dut_r5_value'
R6 cmz_n cmfb 'x_dut_r6_value'
**.ends
.end
