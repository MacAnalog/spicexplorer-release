// Runnable NMOS ULVT Vgs sweep for gm/Id-style characterization.

simulator lang=spectre
global 0

parameters Vgs=0.5 Vds=0.45

include "${PDK_ROOT}/models/spectre/crn28ull_model.scs" section=pre_simu
include "${PDK_ROOT}/models/spectre/crn28ull_model.scs" section=ttmacro_mos_moscap

V_g (G 0) vsource dc=Vgs type=dc
V_d (D 0) vsource dc=Vds type=dc
M_DUT (D G 0 0) nch_ulvt_mac l=30n w=300n multi=1 nf=1

simulatorOptions options psfversion="1.4.0" reltol=1e-4 vabstol=1e-6 \
    iabstol=1e-12 temp=27 tnom=27 scalem=1.0 scale=1.0 \
    gmin=1e-12 rforce=1 maxnotes=5 maxwarns=5 digits=5 cols=80 \
    pivrel=1e-3 sensfile="../psf/sens.output" checklimitdest=psf

dc dc param=Vgs start=0 stop=0.9 step=0.01 annotate=status
element info what=inst where=rawfile

save M_DUT:gm M_DUT:gds M_DUT:id M_DUT:vth M_DUT:cgg
saveOptions options save=selected
