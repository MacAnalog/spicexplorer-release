** GENERATED by `analog-db export-raw` — DO NOT EDIT.
** circuit=amp_025_hsu_classab_ota  class=amplifier  pdk=sky130  testbench=tran_cm_kick  corner=tt
** Self-contained deck: testbench + bound params + lowered DUT (.subckt amp_025_hsu_classab_ota).
** PDK corner libs resolve by BARE NAME on the image's ngspice sourcepath — run in a
** PDK-enabled env (the base image / api container), NOT a bare host:
**   docker run --rm -i spicexplorer-spice-base:local \
**     bash -lc 'd=$(mktemp -d) && cat > $d/c.spice && cd $d && ngspice -b c.spice' < raw/amp_025_hsu_classab_ota/sky130/tran_cm_kick.spice
*----------------------------------------------------------*
** params: 37 free + 13 frozen knobs (sizing.yaml) · 40 tied · 0 ratio-derived (abstract/params.yaml) · 4 testbench params
** AUTHORED TEMPLATE — amplifier/tran_cm_kick (CM-loop health, time domain).
** Common-mode disturbance recovery: a CM current step ICM (0.5*ICM per side) kicks both
** outputs from TKICK to TREL; the CM feedback loop must absorb it and re-settle vocm.
**   cm_kick_v    settled vocm displacement while the kick is applied (at TMID) —
**                = ICM * Zcm(0); small = stiff servo
**   cm_resid_v   vocm at TEND minus the pre-kick level — residual after release (~0
**                for a healthy loop; nonzero flags CM bistability/latch-up: the kick
**                pushed the amp to another operating point)
**   t_cm_settle  recovery time from the release edge to |vocm - vocm(TEND)| < VTOL
** Ringing shows up as a long t_cm_settle relative to the loop bandwidth. See
** ac_cm_reg.spice's honesty note: internal T_cm/PM_cm need a composed loop probe.
**
** Assumes a self-biased, differential-output DUT with a CM control loop:
**   .subckt <id> vinp vinn voutp voutn vdd vss
** Required bindings: DUT PORT_LINE VDD VCM CL ICM TKICK TMID TREL TEND VTOL TSTEP
**                    TSTOP PDK_INCLUDE.  (TB0 sample of the pre-kick level is taken at
**                    TKICK/2; choose TKICK late enough for startup to settle.)
.lib sky130.lib.spice tt
.temp 27

.param VDD=1.8
.param VCM=0.9
.param CL=10p
.param ICM=5u

Vdd  vdd 0 dc {VDD}
Vss  vss 0 dc 0
CLoadp voutp 0 {CL}
CLoadn voutn 0 {CL}
Vcm  vcm 0 dc {VCM}
Vinp vinp vcm dc 0
Vinn vinn vcm dc 0
* common-mode current kick, applied TKICK..TREL (one-shot: width TREL-TKICK, per >> pw)
Icmp 0 voutp pulse(0 {ICM/2} 2u 10n 10n {6u-2u} 1)
Icmn 0 voutn pulse(0 {ICM/2} 2u 10n 10n {6u-2u} 1)

XDUT vinp vinn voutp voutn vdd vss amp_025_hsu_classab_ota

.control
  set filetype=ascii
  tran 2n 20u
  let vocm = (v(voutp)+v(voutn))/2
  meas tran vocm0 FIND vocm AT={2u/2}
  meas tran vocm_mid FIND vocm AT=5u
  meas tran vocm_end FIND vocm AT=19u
  let cm_kick_v = vocm_mid - vocm0
  let cm_resid_v = vocm_end - vocm0
  let verr = abs(vocm - vocm_end)
  meas tran tcross WHEN verr=2m FALL=LAST
  let t_cm_settle = tcross - 6u
  print cm_kick_v cm_resid_v t_cm_settle
  write
  quit
.endc
.param x_dut_xm1_w=20
.param x_dut_xm1_l=1
.param x_dut_xm2_w=20
.param x_dut_xm2_l=0.5
.param x_dut_xm4_w=4
.param x_dut_xm4_l=0.5
.param x_dut_xm6_w=8
.param x_dut_xm7_w=5
.param x_dut_xm7_l=0.3
.param x_dut_xm10_w=10
.param x_dut_xm10_l=0.3
.param x_dut_xm12_w=10
.param x_dut_xm12_l=0.5
.param x_dut_xm14_w=3
.param x_dut_xm14_l=0.5
.param x_dut_xm15_w=16
.param x_dut_xm15_l=0.5
.param x_dut_xm16_w=5
.param x_dut_xm16_l=0.3
.param x_dut_xm17_w=16
.param x_dut_xm17_l=0.5
.param x_dut_xm18_w=20
.param x_dut_xm18_l=0.3
.param x_dut_xm19_w=2
.param x_dut_xm19_l=0.5
.param x_dut_c1_value=1p
.param x_dut_r1_value=10k
.param x_dut_rmp_value=1Meg
.param gm_val=100u
.param rout_val=10Meg
.param rin_val=1.0e12
.param cout_val=10p
.param cin_val=10f
.param vb1=0.8
.param vb2=0.7
.param vb3=1.0
.param vcmfb_ref=1.0
.param x_dut_xm1_m=1
.param x_dut_xm2_m=1
.param x_dut_xm4_m=1
.param x_dut_xm6_m=1
.param x_dut_xm7_m=1
.param x_dut_xm10_m=1
.param x_dut_xm12_m=1
.param x_dut_xm14_m=1
.param x_dut_xm15_m=1
.param x_dut_xm16_m=1
.param x_dut_xm17_m=1
.param x_dut_xm18_m=1
.param x_dut_xm19_m=1
* ---- GENERATED parameter ties (abstract/params.yaml groups/ratios) ----
* Each tied symbol is defined exactly once, by its line below; rewrite that
* .param to untie just that symbol (untying = shadowing, plan D-3).
.param x_dut_xm3_w = {x_dut_xm2_w}
.param x_dut_xm3_l = {x_dut_xm2_l}
.param x_dut_xm3_m = {x_dut_xm2_m}
.param x_dut_xm5_w = {x_dut_xm4_w}
.param x_dut_xm5_l = {x_dut_xm4_l}
.param x_dut_xm5_m = {x_dut_xm4_m}
.param x_dut_xm8_l = {x_dut_xm4_l}
.param x_dut_xm6_l = {x_dut_xm5_l}
.param x_dut_xm8_w = {x_dut_xm6_w}
.param x_dut_xm8_m = {x_dut_xm6_m}
.param x_dut_xm9_w = {x_dut_xm7_w}
.param x_dut_xm9_l = {x_dut_xm7_l}
.param x_dut_xm9_m = {x_dut_xm7_m}
.param x_dut_xm11_w = {x_dut_xm10_w}
.param x_dut_xm11_l = {x_dut_xm10_l}
.param x_dut_xm11_m = {x_dut_xm10_m}
.param x_dut_xm13_w = {x_dut_xm12_w}
.param x_dut_xm13_l = {x_dut_xm12_l}
.param x_dut_xm13_m = {x_dut_xm12_m}
.param x_dut_xm20_w = {x_dut_xm14_w}
.param x_dut_xm20_l = {x_dut_xm14_l}
.param x_dut_xm20_m = {x_dut_xm14_m}
.param x_dut_xm21_w = {x_dut_xm15_w}
.param x_dut_xm21_l = {x_dut_xm15_l}
.param x_dut_xm21_m = {x_dut_xm15_m}
.param x_dut_xm22_w = {x_dut_xm16_w}
.param x_dut_xm22_l = {x_dut_xm16_l}
.param x_dut_xm22_m = {x_dut_xm16_m}
.param x_dut_xm23_w = {x_dut_xm17_w}
.param x_dut_xm23_l = {x_dut_xm17_l}
.param x_dut_xm23_m = {x_dut_xm17_m}
.param x_dut_xm24_w = {x_dut_xm18_w}
.param x_dut_xm24_l = {x_dut_xm18_l}
.param x_dut_xm24_m = {x_dut_xm18_m}
.param x_dut_xm25_w = {x_dut_xm19_w}
.param x_dut_xm25_l = {x_dut_xm19_l}
.param x_dut_xm25_m = {x_dut_xm19_m}
.param x_dut_c2_value = {x_dut_c1_value}
.param x_dut_r2_value = {x_dut_r1_value}
.param x_dut_rmn_value = {x_dut_rmp_value}
.subckt amp_025_hsu_classab_ota vinp vinn voutp voutn vdd vss
C1 abm_p zc_p 'x_dut_c1_value'
C2 abm_n zc_n 'x_dut_c2_value'
CIN cm_det vcmfb_ref 'cin_val'
COUT vss vcmfb 'cout_val'
GM vss vcmfb vcmfb_ref cm_det {gm_val}
R1 zc_p drv_p 'x_dut_r1_value'
R2 drv_n zc_n 'x_dut_r2_value'
RIN cm_det vcmfb_ref 'rin_val'
RMN voutn cm_det 'x_dut_rmn_value'
RMP cm_det voutp 'x_dut_rmp_value'
ROUT vss vcmfb 'rout_val'
VB1 vb1 vss dc {vb1}
VB2 vb2 vss dc {vb2}
VB3 vb3 vss dc {vb3}
VCMFB_REF vcmfb_ref vss dc {vcmfb_ref}
XM1 tail vb1 vdd vdd sky130_fd_pr__pfet_01v8 l=x_dut_xm1_l m=x_dut_xm1_m w=x_dut_xm1_w
XM10 drv_n vb2 psrc_n vdd sky130_fd_pr__pfet_01v8 l=x_dut_xm10_l m=x_dut_xm10_m w=x_dut_xm10_w
XM11 drv_p vb2 psrc_p vdd sky130_fd_pr__pfet_01v8 l=x_dut_xm11_l m=x_dut_xm11_m w=x_dut_xm11_w
XM12 psrc_n vcmfb vdd vdd sky130_fd_pr__pfet_01v8 l=x_dut_xm12_l m=x_dut_xm12_m w=x_dut_xm12_w
XM13 psrc_p vcmfb vdd vdd sky130_fd_pr__pfet_01v8 l=x_dut_xm13_l m=x_dut_xm13_m w=x_dut_xm13_w
XM14 gnf_p vb1 vdd vdd sky130_fd_pr__pfet_01v8 l=x_dut_xm14_l m=x_dut_xm14_m w=x_dut_xm14_w
XM15 gnf_p gnf_p abm_p vss sky130_fd_pr__nfet_01v8 l=x_dut_xm15_l m=x_dut_xm15_m w=x_dut_xm15_w
XM16 vdd gnf_p voutp vss sky130_fd_pr__nfet_01v8 l=x_dut_xm16_l m=x_dut_xm16_m w=x_dut_xm16_w
XM17 gpf_p gpf_p abm_p vdd sky130_fd_pr__pfet_01v8 l=x_dut_xm17_l m=x_dut_xm17_m w=x_dut_xm17_w
XM18 vss gpf_p voutp vdd sky130_fd_pr__pfet_01v8 l=x_dut_xm18_l m=x_dut_xm18_m w=x_dut_xm18_w
XM19 gpf_p drv_p vss vss sky130_fd_pr__nfet_01v8 l=x_dut_xm19_l m=x_dut_xm19_m w=x_dut_xm19_w
XM2 mir_p vinn tail vdd sky130_fd_pr__pfet_01v8 l=x_dut_xm2_l m=x_dut_xm2_m w=x_dut_xm2_w
XM20 gnf_n vb1 vdd vdd sky130_fd_pr__pfet_01v8 l=x_dut_xm20_l m=x_dut_xm20_m w=x_dut_xm20_w
XM21 gnf_n gnf_n abm_n vss sky130_fd_pr__nfet_01v8 l=x_dut_xm21_l m=x_dut_xm21_m w=x_dut_xm21_w
XM22 vdd gnf_n voutn vss sky130_fd_pr__nfet_01v8 l=x_dut_xm22_l m=x_dut_xm22_m w=x_dut_xm22_w
XM23 gpf_n gpf_n abm_n vdd sky130_fd_pr__pfet_01v8 l=x_dut_xm23_l m=x_dut_xm23_m w=x_dut_xm23_w
XM24 vss gpf_n voutn vdd sky130_fd_pr__pfet_01v8 l=x_dut_xm24_l m=x_dut_xm24_m w=x_dut_xm24_w
XM25 gpf_n drv_n vss vss sky130_fd_pr__nfet_01v8 l=x_dut_xm25_l m=x_dut_xm25_m w=x_dut_xm25_w
XM3 mir_n vinp tail vdd sky130_fd_pr__pfet_01v8 l=x_dut_xm3_l m=x_dut_xm3_m w=x_dut_xm3_w
XM4 mir_p mir_p vss vss sky130_fd_pr__nfet_01v8 l=x_dut_xm4_l m=x_dut_xm4_m w=x_dut_xm4_w
XM5 mir_n mir_n vss vss sky130_fd_pr__nfet_01v8 l=x_dut_xm5_l m=x_dut_xm5_m w=x_dut_xm5_w
XM6 csrc_n mir_n vss vss sky130_fd_pr__nfet_01v8 l=x_dut_xm6_l m=x_dut_xm6_m w=x_dut_xm6_w
XM7 drv_n vb3 csrc_n vss sky130_fd_pr__nfet_01v8 l=x_dut_xm7_l m=x_dut_xm7_m w=x_dut_xm7_w
XM8 csrc_p mir_p vss vss sky130_fd_pr__nfet_01v8 l=x_dut_xm8_l m=x_dut_xm8_m w=x_dut_xm8_w
XM9 drv_p vb3 csrc_p vss sky130_fd_pr__nfet_01v8 l=x_dut_xm9_l m=x_dut_xm9_m w=x_dut_xm9_w
.ends
.end
