** GENERATED by `analog-db export-raw` — DO NOT EDIT.
** circuit=ldo_010_capless_lowiq  class=ldo  pdk=ihp-sg13g2  testbench=ac_loopgain  corner=tt
** Self-contained deck: testbench + bound params + lowered DUT (.subckt ldo_010_capless_lowiq).
** PDK corner libs resolve by BARE NAME on the image's ngspice sourcepath — run in a
** PDK-enabled env (the base image / api container), NOT a bare host:
**   docker run --rm -i spicexplorer-spice-base:local \
**     bash -lc 'd=$(mktemp -d) && cat > $d/c.spice && cd $d && ngspice -b c.spice' < raw/ldo_010_capless_lowiq/ihp-sg13g2/ac_loopgain.spice
*----------------------------------------------------------*
** params: 33 free + 0 frozen knobs (sizing.yaml) · 0 tied · 0 ratio-derived (abstract/params.yaml) · 1 testbench params
** AUTHORED TEMPLATE — ldo/ac_loopgain: TRUE regulation-loop gain, phase margin and gain margin
** by Middlebrook voltage injection at an in-DUT loop-break marker.
**
** Why this exists: an LDO's regulation loop is entirely INSIDE the subckt (vout -> error amp ->
** pass gate -> vout), so it cannot be broken from the [vdd, vout, vss] ports. The class's
** `loop_stability` bench measures closed-loop output-impedance peaking (zout_peak_db) as an
** honest proxy, but peaking is a symptom, not a margin — it cannot tell you HOW MUCH phase you
** have, and a critically-damped loop and a 30-degree loop can show similar peaks under different
** loads. This bench gives the real number.
**
** CONTRACT — the DUT must carry a loop-break marker. Put a 0 V source in the feedback path of the
** abstract netlist, between the driving node and the sensing input:
**     Vlp lp_brk vout dc 0        ; and feed the error amp's sense input from lp_brk, not vout
** A 0 V source with no AC spec is an ideal short, so it is INVISIBLE to every other analysis —
** dc_op / load_regulation / psrr / the transients all see the loop closed exactly as before. Only
** this bench turns it into a generator, via `alter`. This mirrors the amplifier class's `stb`
** bench, which uses the same 0 V VIPRB marker convention (there it becomes a Spectre iprobe).
**
** INJECTION POINT: it must sit where the source-side impedance is LOW and the load-side impedance
** is HIGH — vout (driven hard by the pass device and the output cap) into a MOSFET gate satisfies
** that by a wide margin, which is what makes the Middlebrook approximation valid here.
**
** MATH: the marker forces V(lp_brk) - V(vout) = 1 V AC. With G the transfer once around the rest
** of the loop (lp_brk -> error amp -> pass device -> vout):
**     V(vout) = G * V(lp_brk)  and  V(lp_brk) = V(vout) + 1
**  => V(lp_brk) = 1/(1-G),  V(vout) = G/(1-G),  so  T = v(vout)/v(lp_brk) = G  exactly.
** No small-signal approximation is involved in that algebra; the only assumption is the impedance
** condition above.
**
** VALIDATED 2026-07-20 against a known answer: applied to amp_033_ti_ldo_ref_selfbias closed as a
** unity buffer, this method returns 74.9178 dB / 12.083 MHz / 21.05 deg where the independent
** amplifier `ac_open_loop_biaswrap` bench returns 74.9177 dB / 12.112 MHz / 20.997 deg — agreement
** to the frequency-grid resolution. The phase normalisation (180 + phc - phc[0]) is the same
** sign-convention-agnostic form the amplifier open-loop templates use, so an inverting loop
** (phc[0] ~ 180 deg) and a non-inverting one both report the same physical margin.
**
** Bindings: DUT PORT_LINE VDD ILOAD COUT PPD FSTART FSTOP LP_PROBE PDK_INCLUDE.
** LP_PROBE is the marker's instance name inside the DUT (default `vlp`, see assemble.py).
.lib cornerMOSlv.lib mos_tt
.lib cornerRES.lib res_typ
.lib cornerCAP.lib cap_typ
.temp 27

.param VDD=1.5

Vdd  vdd 0 dc {VDD}
Vss  vss 0 dc 0
Iload vout 0 dc 1m
CLoad vout 0 1p

XDUT vdd vout vss ldo_010_capless_lowiq

.control
  set filetype=ascii
  * turn the in-loop 0 V marker into a 1 V AC generator (it stays a plain short at DC, so the
  * operating point this measurement rides on is the regulated one)
  alter @v.xdut.vlp[acmag] = 1
  ac dec 20 1 1G
  let tloop = v(vout) / v(xdut.lp_brk)
  let tdb  = db(tloop)
  let tphc = cph(tloop)*180/3.14159265
  let tph  = 180 + tphc - tphc[0]
  meas ac loopgain_db FIND tdb AT=1
  meas ac ugf_loop    WHEN tdb=0 FALL=1
  meas ac pm_loop     FIND tph WHEN tdb=0 FALL=1
  * gain margin: attenuation still in hand where the loop phase reaches 0 (i.e. 180 deg of shift
  * from the DC value). NaN when the phase never gets there — an honest "unconditionally stable"
  * rather than a fabricated number.
  meas ac gm_at_180 FIND tdb WHEN tph=0 FALL=1
  let gm_loop_db = 0 - gm_at_180
  * SENSITIVITY-FUNCTION PEAK. For a regulator, Zout_cl = Zout_ol/(1+T_rr), so
  * |Zout_cl|/|Zout_ol| = |1/(1+T_rr)| = |S| exactly, and its peak Ms is the damping
  * figure the zout_peak_db proxy was standing in for. Ms comes free from THIS sweep:
  * no open-loop Zout run is needed.
  * SIGN: tloop is the raw around-the-loop transfer measured at the marker, and it is
  * NEGATIVE at DC for a negative-feedback loop (vout up -> pass current down -> vout
  * down), i.e. tphc[0] ~ +/-180 deg. The return ratio is therefore T_rr = -tloop, and
  * S = 1/(1 - tloop). This was ADJUDICATED by measurement, not assumed: on
  * ldo_005/ihp-sg13g2 the two candidate conventions give 4.3447 dB and 4.2e-06 dB,
  * and only the first is admissible, because Ms >= 1/(2 sin(PM/2)) forces Ms >= 1.270
  * (2.07 dB) at that run's 46.39 deg phase margin. The 1/(1+tloop) form collapses to
  * 0 dB exactly as expected for the wrong sign: |1+T| is huge in band, so its peak is
  * just the high-frequency limit where the loop gain dies and |S| -> 1.
  * tloop_ph_dc is recorded on every run as the standing guard: a circuit whose DC loop
  * phase is NOT near +/-180 does not satisfy this convention and its ms_peak must not
  * be trusted.
  let s_db = db(1/(1-tloop))
  meas ac ms_peak     MAX s_db
  meas ac tloop_ph_dc FIND tphc AT=1
  print loopgain_db ugf_loop pm_loop gm_loop_db ms_peak tloop_ph_dc
  write
  quit
.endc
.param vref_val=0.6
.param r_w=0.5u
.param r_fb_l=340u
.param c_ff_w=8u
.param r_bias_l=138.5u
.param x_dut_xmb0_w=1u
.param x_dut_xmb0_l=1u
.param x_dut_xmb1_w=1.39u
.param x_dut_xmbp_w=10u
.param x_dut_xmbp_l=1u
.param x_dut_xmt_w=10u
.param x_dut_xm1_w=9.53u
.param x_dut_xm1_l=0.5u
.param x_dut_xm3_w=2.95u
.param x_dut_xm3_l=1u
.param x_dut_xm5_w=2.42u
.param x_dut_xm5_l=0.5u
.param x_dut_xm6_w=5.53u
.param c_comp_w=54u
.param x_dut_xmc_w=15.76u
.param x_dut_xmc_l=0.36u
.param x_dut_xma_w=5.79u
.param x_dut_xma_l=0.5u
.param x_dut_xmcp_w=9.02u
.param x_dut_xmcp_l=0.5u
.param x_dut_xms_w=2.2u
.param x_dut_xms_l=0.95u
.param x_dut_xmp_w=10u
.param x_dut_xmp_l=0.13u
.param x_dut_xmp_m=19
.param x_dut_xmp_nf_mult=4
.param c_out_w=58u
.param c_out_m=4
.subckt ldo_010_capless_lowiq vdd vout vss
VLP lp_brk vout dc 0
VREF vref vss dc {vref_val}
XCC ea_out ea_o1 cap_cmim l=c_comp_w w=c_comp_w
XCFF lp_brk fb cap_cmim l=c_ff_w w=c_ff_w
XCOUT vout vss cap_cmim l=c_out_w m=c_out_m w=c_out_w
XM1A ea_n fb ea_tail vdd sg13_lv_pmos l=x_dut_xm1_l w={x_dut_xm1_w/2}
XM1B ea_n fb ea_tail vdd sg13_lv_pmos l=x_dut_xm1_l w={x_dut_xm1_w/2}
XM2A ea_o1 vref ea_tail vdd sg13_lv_pmos l=x_dut_xm1_l w={x_dut_xm1_w/2}
XM2B ea_o1 vref ea_tail vdd sg13_lv_pmos l=x_dut_xm1_l w={x_dut_xm1_w/2}
XM3A ea_n ea_n vss vss sg13_lv_nmos l=x_dut_xm3_l w={x_dut_xm3_w/2}
XM3B ea_n ea_n vss vss sg13_lv_nmos l=x_dut_xm3_l w={x_dut_xm3_w/2}
XM4A ea_o1 ea_n vss vss sg13_lv_nmos l=x_dut_xm3_l w={x_dut_xm3_w/2}
XM4B ea_o1 ea_n vss vss sg13_lv_nmos l=x_dut_xm3_l w={x_dut_xm3_w/2}
XM5 ea_out ea_o1 vss vss sg13_lv_nmos l=x_dut_xm5_l w=x_dut_xm5_w
XM6 ea_out pbias vdd vdd sg13_lv_pmos l=x_dut_xmbp_l w=x_dut_xm6_w
XMA x1 x1 vss vss sg13_lv_nmos l=x_dut_xma_l w=x_dut_xma_w
XMB y x1 vss vss sg13_lv_nmos l=x_dut_xma_l w=x_dut_xma_w
XMB0A nbias nbias vss vss sg13_lv_nmos l=x_dut_xmb0_l w={x_dut_xmb0_w/2}
XMB0B nbias nbias vss vss sg13_lv_nmos l=x_dut_xmb0_l w={x_dut_xmb0_w/2}
XMB1A pbias nbias vss vss sg13_lv_nmos l=x_dut_xmb0_l w={x_dut_xmb1_w/2}
XMB1B pbias nbias vss vss sg13_lv_nmos l=x_dut_xmb0_l w={x_dut_xmb1_w/2}
XMBP pbias pbias vdd vdd sg13_lv_pmos l=x_dut_xmbp_l w=x_dut_xmbp_w
XMC x1 ea_out vout vdd sg13_lv_pmos l=x_dut_xmc_l w=x_dut_xmc_w
XMCP y y vdd vdd sg13_lv_pmos l=x_dut_xmcp_l w=x_dut_xmcp_w
XMD gate y vdd vdd sg13_lv_pmos l=x_dut_xmcp_l w=x_dut_xmcp_w
XMP vout gate vdd vdd sg13_lv_pmos l=x_dut_xmp_l m={x_dut_xmp_m*x_dut_xmp_nf_mult} w={x_dut_xmp_w/x_dut_xmp_nf_mult}
XMSA gate nbias vss vss sg13_lv_nmos l=x_dut_xms_l w={x_dut_xms_w/2}
XMSB gate nbias vss vss sg13_lv_nmos l=x_dut_xms_l w={x_dut_xms_w/2}
XMT ea_tail pbias vdd vdd sg13_lv_pmos l=x_dut_xmbp_l w=x_dut_xmt_w
XR1_1 lp_brk n_r1_1 vss rhigh l={r_fb_l/8} w=r_w
XR1_2 n_r1_1 n_r1_2 vss rhigh l={r_fb_l/8} w=r_w
XR1_3 n_r1_2 n_r1_3 vss rhigh l={r_fb_l/8} w=r_w
XR1_4 n_r1_3 n_r1_4 vss rhigh l={r_fb_l/8} w=r_w
XR1_5 n_r1_4 n_r1_5 vss rhigh l={r_fb_l/8} w=r_w
XR1_6 n_r1_5 n_r1_6 vss rhigh l={r_fb_l/8} w=r_w
XR1_7 n_r1_6 n_r1_7 vss rhigh l={r_fb_l/8} w=r_w
XR1_8 n_r1_7 fb vss rhigh l={r_fb_l/8} w=r_w
XR2_1 fb n_r2_1 vss rhigh l={r_fb_l/8} w=r_w
XR2_2 n_r2_1 n_r2_2 vss rhigh l={r_fb_l/8} w=r_w
XR2_3 n_r2_2 n_r2_3 vss rhigh l={r_fb_l/8} w=r_w
XR2_4 n_r2_3 n_r2_4 vss rhigh l={r_fb_l/8} w=r_w
XR2_5 n_r2_4 n_r2_5 vss rhigh l={r_fb_l/8} w=r_w
XR2_6 n_r2_5 n_r2_6 vss rhigh l={r_fb_l/8} w=r_w
XR2_7 n_r2_6 n_r2_7 vss rhigh l={r_fb_l/8} w=r_w
XR2_8 n_r2_7 vss vss rhigh l={r_fb_l/8} w=r_w
XRB_1 vdd n_rb_1 vss rhigh l={r_bias_l/5} w=r_w
XRB_2 n_rb_1 n_rb_2 vss rhigh l={r_bias_l/5} w=r_w
XRB_3 n_rb_2 n_rb_3 vss rhigh l={r_bias_l/5} w=r_w
XRB_4 n_rb_3 n_rb_4 vss rhigh l={r_bias_l/5} w=r_w
XRB_5 n_rb_4 nbias vss rhigh l={r_bias_l/5} w=r_w
.ends
.end
