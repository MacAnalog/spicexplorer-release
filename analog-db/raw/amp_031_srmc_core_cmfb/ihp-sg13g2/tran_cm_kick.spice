** GENERATED by `analog-db export-raw` — DO NOT EDIT.
** circuit=amp_031_srmc_core_cmfb  class=amplifier  pdk=ihp-sg13g2  testbench=tran_cm_kick  corner=tt
** Self-contained deck: testbench + bound params + lowered DUT (.subckt amp_031_srmc_core_cmfb).
** PDK corner libs resolve by BARE NAME on the image's ngspice sourcepath — run in a
** PDK-enabled env (the base image / api container), NOT a bare host:
**   docker run --rm -i spicexplorer-spice-base:local \
**     bash -lc 'd=$(mktemp -d) && cat > $d/c.spice && cd $d && ngspice -b c.spice' < raw/amp_031_srmc_core_cmfb/ihp-sg13g2/tran_cm_kick.spice
*----------------------------------------------------------*
** params: 22 free + 6 frozen knobs (sizing.yaml) · 17 tied · 0 ratio-derived (abstract/params.yaml) · 4 testbench params
** AUTHORED TEMPLATE — amplifier/tran_cm_kick (CM-loop health, time domain).
** Common-mode disturbance recovery: a CM current step ICM (0.5*ICM per side) kicks both
** outputs from TKICK to TREL; the CM feedback loop must absorb it and re-settle vocm.
**   cm_kick_v    settled vocm displacement while the kick is applied (at TMID) —
**                = ICM * Zcm(0); small = stiff servo
**   cm_resid_v   vocm at TEND minus the pre-kick level — residual after release (~0
**                for a healthy loop; nonzero flags CM bistability/latch-up: the kick
**                pushed the amp to another operating point)
**   t_cm_settle  recovery time from the release edge to |vocm - vocm(TEND)| < VTOL
** Ringing shows up as a long t_cm_settle relative to the loop bandwidth. See
** ac_cm_reg.spice's honesty note: internal T_cm/PM_cm need a composed loop probe.
**
** Assumes a self-biased, differential-output DUT with a CM control loop:
**   .subckt <id> vinp vinn voutp voutn vdd vss
** Required bindings: DUT PORT_LINE VDD VCM CL ICM TKICK TMID TREL TEND VTOL TSTEP
**                    TSTOP PDK_INCLUDE.  (TB0 sample of the pre-kick level is taken at
**                    TKICK/2; choose TKICK late enough for startup to settle.)
.lib cornerMOSlv.lib mos_tt
.temp 27

.param VDD=1.2
.param VCM=0.5
.param CL=50f
.param ICM=200n

Vdd  vdd 0 dc {VDD}
Vss  vss 0 dc 0
CLoadp voutp 0 {CL}
CLoadn voutn 0 {CL}
Vcm  vcm 0 dc {VCM}
Vinp vinp vcm dc 0
Vinn vinn vcm dc 0
* common-mode current kick, applied TKICK..TREL (one-shot: width TREL-TKICK, per >> pw)
Icmp 0 voutp pulse(0 {ICM/2} 50u 10n 10n {54u-50u} 1)
Icmn 0 voutn pulse(0 {ICM/2} 50u 10n 10n {54u-50u} 1)

XDUT vinp vinn voutp voutn vdd vss amp_031_srmc_core_cmfb

.control
  set filetype=ascii
  tran 200n 400u
  let vocm = (v(voutp)+v(voutn))/2
  meas tran vocm0 FIND vocm AT={50u/2}
  meas tran vocm_mid FIND vocm AT=52u
  meas tran vocm_end FIND vocm AT=380u
  let cm_kick_v = vocm_mid - vocm0
  let cm_resid_v = vocm_end - vocm0
  let verr = abs(vocm - vocm_end)
  meas tran tcross WHEN verr=2m FALL=LAST
  let t_cm_settle = tcross - 54u
  print cm_kick_v cm_resid_v t_cm_settle
  write
  quit
.endc
.param x_dut_xm3_w=1.929899553930193e-06
.param x_dut_xm3_l=7.17160573582043e-07
.param x_dut_xm6_w=4.333517676791642e-06
.param x_dut_xm6_l=5.543754544025163e-07
.param x_dut_xm5_w=2.65342774731541e-06
.param x_dut_xm5_l=4.862864381993593e-07
.param x_dut_xm8_w=2.8635900612133323e-06
.param x_dut_xm8_l=4.4416626216939937e-07
.param x_dut_xm1_w=2.0223959132588594e-06
.param x_dut_xm1_l=4.2775106088068857e-07
.param x_dut_xm2_w=1.5914426355899998e-06
.param x_dut_xm2_l=5.757246674262767e-07
.param x_dut_c1_value=5.825188706426775e-13
.param x_dut_r1_value=2102.5223381221017
.param x_dut_rm1p_value=1Meg
.param gm_val=100u
.param rout_val=10Meg
.param rin_val=1.0e12
.param cout_val=100f
.param cin_val=10f
.param vb2=0.7002027602191484
.param vref_cm=0.5
.param x_dut_xm1_m=1
.param x_dut_xm2_m=1
.param x_dut_xm3_m=1
.param x_dut_xm5_m=1
.param x_dut_xm6_m=1
.param x_dut_xm8_m=1
* ---- GENERATED parameter ties (abstract/params.yaml groups/ratios) ----
* Each tied symbol is defined exactly once, by its line below; rewrite that
* .param to untie just that symbol (untying = shadowing, plan D-3).
.param x_dut_xm4_w = {x_dut_xm3_w}
.param x_dut_xm4_l = {x_dut_xm3_l}
.param x_dut_xm4_m = {x_dut_xm3_m}
.param x_dut_xm7_w = {x_dut_xm6_w}
.param x_dut_xm7_l = {x_dut_xm6_l}
.param x_dut_xm7_m = {x_dut_xm6_m}
.param x_dut_xm9_w = {x_dut_xm1_w}
.param x_dut_xm9_l = {x_dut_xm1_l}
.param x_dut_xm9_m = {x_dut_xm1_m}
.param x_dut_xm10_w = {x_dut_xm2_w}
.param x_dut_xm10_l = {x_dut_xm2_l}
.param x_dut_xm10_m = {x_dut_xm2_m}
.param x_dut_c2_value = {x_dut_c1_value}
.param x_dut_r2_value = {x_dut_r1_value}
.param x_dut_rm1n_value = {x_dut_rm1p_value}
.param x_dut_rm2p_value = {x_dut_rm1p_value}
.param x_dut_rm2n_value = {x_dut_rm1p_value}
.subckt amp_031_srmc_core_cmfb vinp vinn voutp voutn vdd vss
C1 vo1n zc_p 'x_dut_c1_value'
C2 vo1p zc_n 'x_dut_c2_value'
CIN1 cm1_det vref_cm1 'cin_val'
CIN2 cm2_det vref_cm2 'cin_val'
COUT1 vss vcmfb1 'cout_val'
COUT2 vss vcmfb2 'cout_val'
GM1 vss vcmfb1 cm1_det vref_cm1 {gm_val}
GM2 vss vcmfb2 cm2_det vref_cm2 {gm_val}
R1 zc_p voutp 'x_dut_r1_value'
R2 zc_n voutn 'x_dut_r2_value'
RIN1 cm1_det vref_cm1 'rin_val'
RIN2 cm2_det vref_cm2 'rin_val'
RM1N vo1n cm1_det 'x_dut_rm1n_value'
RM1P cm1_det vo1p 'x_dut_rm1p_value'
RM2N voutn cm2_det 'x_dut_rm2n_value'
RM2P cm2_det voutp 'x_dut_rm2p_value'
ROUT1 vss vcmfb1 'rout_val'
ROUT2 vss vcmfb2 'rout_val'
VB2 vb2 vss dc {vb2}
VREF1 vref_cm1 vss dc {vref_cm}
VREF2 vref_cm2 vss dc {vref_cm}
XM1 voutp vo1n vss vss sg13_lv_nmos l=x_dut_xm1_l m=x_dut_xm1_m w=x_dut_xm1_w
XM10 voutn vcmfb2 vdd vdd sg13_lv_pmos l=x_dut_xm10_l m=x_dut_xm10_m w=x_dut_xm10_w
XM2 voutp vcmfb2 vdd vdd sg13_lv_pmos l=x_dut_xm2_l m=x_dut_xm2_m w=x_dut_xm2_w
XM3 vo1n vinp ntail vss sg13_lv_nmos l=x_dut_xm3_l m=x_dut_xm3_m w=x_dut_xm3_w
XM4 vo1p vinn ntail vss sg13_lv_nmos l=x_dut_xm4_l m=x_dut_xm4_m w=x_dut_xm4_w
XM5 ntail vb2 vss vss sg13_lv_nmos l=x_dut_xm5_l m=x_dut_xm5_m w=x_dut_xm5_w
XM6 vo1p vinn ptail vdd sg13_lv_pmos l=x_dut_xm6_l m=x_dut_xm6_m w=x_dut_xm6_w
XM7 vo1n vinp ptail vdd sg13_lv_pmos l=x_dut_xm7_l m=x_dut_xm7_m w=x_dut_xm7_w
XM8 ptail vcmfb1 vdd vdd sg13_lv_pmos l=x_dut_xm8_l m=x_dut_xm8_m w=x_dut_xm8_w
XM9 voutn vo1p vss vss sg13_lv_nmos l=x_dut_xm9_l m=x_dut_xm9_m w=x_dut_xm9_w
.ends
.end
