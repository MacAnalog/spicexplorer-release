** GENERATED by `analog-db export-raw` — DO NOT EDIT.
** circuit=ia_002_fan_chopper_simple  class=ia  pdk=tsmc-n65  testbench=tran_chopper_ripple  corner=tt
** Self-contained deck: testbench + bound params + lowered DUT (.subckt ia_002_fan_chopper_simple).
** PDK corner libs resolve by BARE NAME on the image's ngspice sourcepath — run in a
** PDK-enabled env (the base image / api container), NOT a bare host:
**   docker run --rm -i spicexplorer-spice-base:local \
**     bash -lc 'd=$(mktemp -d) && cat > $d/c.spice && cd $d && ngspice -b c.spice' < raw/ia_002_fan_chopper_simple/tsmc-n65/tran_chopper_ripple.spice
*----------------------------------------------------------*
** params: 34 free + 14 frozen knobs (sizing.yaml) · 81 tied · 0 ratio-derived (abstract/params.yaml) · 7 testbench params
** AUTHORED TEMPLATE — ia/tran_chopper_ripple (plan_hierarchical_composition P3; the
** CLOCKED bench family for the chopper subfamily — plan S4.6 "ia - chopper": a static
** .ac/.noise on the frozen network is the wrong analysis for these figures).
** One combined clocked transient: all chopper clock pairs run at FCHOP; the differential
** input is 0 until T1 (window A -> chopped output offset + ripple), then steps to VIN_DC
** (window B -> chopped closed-loop gain). Measures, all in-deck:
**   v_ripple_pp   peak-to-peak differential output ripple in the settled window B
**   gain_cl       (avgB - avgA)/VIN_DC — the chopped closed-loop gain
**   vos_residual  window-A output average, input-referred through gain_cl
** Windows WA0..WA1 (before T1) and WB0..WB1 (before TSTOP) MUST each span an integer
** number of chop periods, settled after the respective input change.
**
** Assumes the chopper-IA port convention (extra clock pairs are driven even if a given
** DUT omits some — extra driven nets are harmless):
**   .subckt <id> vinp vinn voutp voutn vref clk_chin clk_chin_not clk_chfb clk_chfb_not
**                clk_chout clk_chout_not [clk_chpf clk_chpf_not] vdd vss
** Required bindings: DUT PORT_LINE VDD VCM CL FCHOP TEDGE VIN_DC T1 WA0 WA1 WB0 WB1
**                    TSTEP TSTOP PDK_INCLUDE.
.lib tsmc_n65_models.scs tt
.temp 27

.param VDD=1.2
.param VCM=0.6
.param CL=50f
.param FCHOP=5k
.param TCHOP={1/FCHOP}
.param TEDGE=50n
.param VIN_DC=10m

Vdd  vdd 0 dc {VDD}
Vss  vss 0 dc 0
CLoadp voutp 0 {CL}
CLoadn voutn 0 {CL}
Vref vref 0 dc {VCM}
Vcm  vcm 0 dc {VCM}
* differential input: 0 in window A, VIN_DC from T1 (window B)
Vinp vinp vcm pulse(0 {VIN_DC} 4m 1n 1n 1 2)
Vinn vinn vcm dc 0

* chopper clocks: complementary pairs, all phases aligned at FCHOP
Vck_in_a  clk_chin      0 pulse(0 {VDD} 0 {TEDGE} {TEDGE} {TCHOP/2-TEDGE} {TCHOP})
Vck_in_b  clk_chin_not  0 pulse({VDD} 0 0 {TEDGE} {TEDGE} {TCHOP/2-TEDGE} {TCHOP})
Vck_fb_a  clk_chfb      0 pulse(0 {VDD} 0 {TEDGE} {TEDGE} {TCHOP/2-TEDGE} {TCHOP})
Vck_fb_b  clk_chfb_not  0 pulse({VDD} 0 0 {TEDGE} {TEDGE} {TCHOP/2-TEDGE} {TCHOP})
Vck_out_a clk_chout     0 pulse(0 {VDD} 0 {TEDGE} {TEDGE} {TCHOP/2-TEDGE} {TCHOP})
Vck_out_b clk_chout_not 0 pulse({VDD} 0 0 {TEDGE} {TEDGE} {TCHOP/2-TEDGE} {TCHOP})
Vck_pf_a  clk_chpf      0 pulse(0 {VDD} 0 {TEDGE} {TEDGE} {TCHOP/2-TEDGE} {TCHOP})
Vck_pf_b  clk_chpf_not  0 pulse({VDD} 0 0 {TEDGE} {TEDGE} {TCHOP/2-TEDGE} {TCHOP})

XDUT vinp vinn voutp voutn vref clk_chin clk_chin_not clk_chfb clk_chfb_not clk_chout clk_chout_not vdd vss ia_002_fan_chopper_simple

.control
  set filetype=ascii
  tran 1u 8m
  let vd = v(voutp) - v(voutn)
  meas tran vavga AVG vd from=3m to=4m
  meas tran vavgb AVG vd from=7m to=8m
  meas tran vdmax MAX vd from=7m to=8m
  meas tran vdmin MIN vd from=7m to=8m
  let v_ripple_pp = vdmax - vdmin
  let gain_cl = (vavgb - vavga)/10m
  let vos_residual = vavga/gain_cl
  print v_ripple_pp gain_cl vos_residual
  write
  quit
.endc
.param x_dut_xm1_w=5.629u
.param x_dut_xm1_l=1u
.param x_dut_xm2_w=4.933u
.param x_dut_xm2_l=0.5u
.param x_dut_xm4_w=2.51u
.param x_dut_xm4_l=1u
.param x_dut_xm6_w=2.814u
.param x_dut_xm8_w=11.257u
.param x_dut_xm10_w=2.398u
.param x_dut_xm10_l=0.3u
.param x_dut_xm12_w=0.792u
.param x_dut_xm12_l=0.3u
.param x_dut_xm14_w=1.043u
.param x_dut_xm14_l=0.25u
.param x_dut_xm16_w=2u
.param x_dut_xm16_l=0.13u
.param x_dut_xm17_w=2u
.param x_dut_xm17_l=0.13u
.param x_dut_xm20_w=2u
.param x_dut_xm20_l=0.13u
.param x_dut_xm21_w=2u
.param x_dut_xm21_l=0.13u
.param x_dut_xm24_w=2u
.param x_dut_xm24_l=0.13u
.param x_dut_xm25_w=2u
.param x_dut_xm25_l=0.13u
.param x_dut_cin1_value=16p
.param x_dut_cfb1_value=0.8p
.param x_dut_cm1_value=2p
.param x_dut_rb1_value=10Meg
.param vb1=0.324117
.param vb2=0.472198
.param vb3=0.438401
.param vb4=0.785955
.param x_dut_xm1_m=1
.param x_dut_xm2_m=1
.param x_dut_xm4_m=1
.param x_dut_xm6_m=1
.param x_dut_xm8_m=1
.param x_dut_xm10_m=1
.param x_dut_xm12_m=1
.param x_dut_xm14_m=1
.param x_dut_xm16_m=1
.param x_dut_xm17_m=1
.param x_dut_xm20_m=1
.param x_dut_xm21_m=1
.param x_dut_xm24_m=1
.param x_dut_xm25_m=1
* ---- GENERATED parameter ties (abstract/params.yaml groups/ratios) ----
* Each tied symbol is defined exactly once, by its line below; rewrite that
* .param to untie just that symbol (untying = shadowing, plan D-3).
.param x_dut_xm3_w = {x_dut_xm2_w}
.param x_dut_xm3_l = {x_dut_xm2_l}
.param x_dut_xm3_m = {x_dut_xm2_m}
.param x_dut_xm5_w = {x_dut_xm4_w}
.param x_dut_xm5_l = {x_dut_xm4_l}
.param x_dut_xm5_m = {x_dut_xm4_m}
.param x_dut_xm13_w = {x_dut_xm12_w}
.param x_dut_xm13_l = {x_dut_xm12_l}
.param x_dut_xm13_m = {x_dut_xm12_m}
.param x_dut_xm11_w = {x_dut_xm10_w}
.param x_dut_xm11_l = {x_dut_xm10_l}
.param x_dut_xm11_m = {x_dut_xm10_m}
.param x_dut_xm7_w = {x_dut_xm6_w}
.param x_dut_xm7_m = {x_dut_xm6_m}
.param x_dut_xm9_w = {x_dut_xm8_w}
.param x_dut_xm9_m = {x_dut_xm8_m}
.param x_dut_xm6_l = {x_dut_xm1_l}
.param x_dut_xm7_l = {x_dut_xm1_l}
.param x_dut_xm8_l = {x_dut_xm1_l}
.param x_dut_xm9_l = {x_dut_xm1_l}
.param x_dut_xm15_w = {x_dut_xm14_w}
.param x_dut_xm15_l = {x_dut_xm14_l}
.param x_dut_xm15_m = {x_dut_xm14_m}
.param x_dut_xm18_w = {x_dut_xm16_w}
.param x_dut_xm28_w = {x_dut_xm16_w}
.param x_dut_xm30_w = {x_dut_xm16_w}
.param x_dut_xm18_l = {x_dut_xm16_l}
.param x_dut_xm28_l = {x_dut_xm16_l}
.param x_dut_xm30_l = {x_dut_xm16_l}
.param x_dut_xm18_m = {x_dut_xm16_m}
.param x_dut_xm28_m = {x_dut_xm16_m}
.param x_dut_xm30_m = {x_dut_xm16_m}
.param x_dut_xm19_w = {x_dut_xm17_w}
.param x_dut_xm29_w = {x_dut_xm17_w}
.param x_dut_xm31_w = {x_dut_xm17_w}
.param x_dut_xm19_l = {x_dut_xm17_l}
.param x_dut_xm29_l = {x_dut_xm17_l}
.param x_dut_xm31_l = {x_dut_xm17_l}
.param x_dut_xm19_m = {x_dut_xm17_m}
.param x_dut_xm29_m = {x_dut_xm17_m}
.param x_dut_xm31_m = {x_dut_xm17_m}
.param x_dut_xm26_w = {x_dut_xm24_w}
.param x_dut_xm32_w = {x_dut_xm24_w}
.param x_dut_xm34_w = {x_dut_xm24_w}
.param x_dut_xm26_l = {x_dut_xm24_l}
.param x_dut_xm32_l = {x_dut_xm24_l}
.param x_dut_xm34_l = {x_dut_xm24_l}
.param x_dut_xm26_m = {x_dut_xm24_m}
.param x_dut_xm32_m = {x_dut_xm24_m}
.param x_dut_xm34_m = {x_dut_xm24_m}
.param x_dut_xm27_w = {x_dut_xm25_w}
.param x_dut_xm33_w = {x_dut_xm25_w}
.param x_dut_xm35_w = {x_dut_xm25_w}
.param x_dut_xm27_l = {x_dut_xm25_l}
.param x_dut_xm33_l = {x_dut_xm25_l}
.param x_dut_xm35_l = {x_dut_xm25_l}
.param x_dut_xm27_m = {x_dut_xm25_m}
.param x_dut_xm33_m = {x_dut_xm25_m}
.param x_dut_xm35_m = {x_dut_xm25_m}
.param x_dut_xm22_w = {x_dut_xm20_w}
.param x_dut_xm36_w = {x_dut_xm20_w}
.param x_dut_xm38_w = {x_dut_xm20_w}
.param x_dut_xm22_l = {x_dut_xm20_l}
.param x_dut_xm36_l = {x_dut_xm20_l}
.param x_dut_xm38_l = {x_dut_xm20_l}
.param x_dut_xm22_m = {x_dut_xm20_m}
.param x_dut_xm36_m = {x_dut_xm20_m}
.param x_dut_xm38_m = {x_dut_xm20_m}
.param x_dut_xm23_w = {x_dut_xm21_w}
.param x_dut_xm37_w = {x_dut_xm21_w}
.param x_dut_xm39_w = {x_dut_xm21_w}
.param x_dut_xm23_l = {x_dut_xm21_l}
.param x_dut_xm37_l = {x_dut_xm21_l}
.param x_dut_xm39_l = {x_dut_xm21_l}
.param x_dut_xm23_m = {x_dut_xm21_m}
.param x_dut_xm37_m = {x_dut_xm21_m}
.param x_dut_xm39_m = {x_dut_xm21_m}
.param x_dut_cin2_value = {x_dut_cin1_value}
.param x_dut_cfb2_value = {x_dut_cfb1_value}
.param x_dut_cm2_value = {x_dut_cm1_value}
.param x_dut_rb2_value = {x_dut_rb1_value}
.subckt ia_002_fan_chopper_simple vinp vinn voutp voutn vref clk_chin clk_chin_not clk_chfb clk_chfb_not clk_chout clk_chout_not vdd vss
CFB1 fbch_p vsum_n 'x_dut_cfb1_value'
CFB2 fbch_n vsum_p 'x_dut_cfb2_value'
CIN1 vsum_n inch_n 'x_dut_cin1_value'
CIN2 vsum_p inch_p 'x_dut_cin2_value'
CM1 g2_p voutp 'x_dut_cm1_value'
CM2 g2_n voutn 'x_dut_cm2_value'
RB1 vsum_n vref 'x_dut_rb1_value'
RB2 vsum_p vref 'x_dut_rb2_value'
VB1 vb1 vss dc {vb1}
VB2 vb2 vss dc {vb2}
VB3 vb3 vss dc {vb3}
VB4 vb4 vss dc {vb4}
XM1 tail vb4 vdd vdd pch_lvt l=x_dut_xm1_l m=x_dut_xm1_m w=x_dut_xm1_w
XM10 out1_n vb3 casc_src_n vdd pch_lvt l=x_dut_xm10_l m=x_dut_xm10_m w=x_dut_xm10_w
XM11 out1_p vb3 casc_src_p vdd pch_lvt l=x_dut_xm11_l m=x_dut_xm11_m w=x_dut_xm11_w
XM12 out1_p vb2 fold_p vss nch_lvt l=x_dut_xm12_l m=x_dut_xm12_m w=x_dut_xm12_w
XM13 out1_n vb2 fold_n vss nch_lvt l=x_dut_xm13_l m=x_dut_xm13_m w=x_dut_xm13_w
XM14 voutp g2_p vss vss nch_lvt l=x_dut_xm14_l m=x_dut_xm14_m w=x_dut_xm14_w
XM15 voutn g2_n vss vss nch_lvt l=x_dut_xm15_l m=x_dut_xm15_m w=x_dut_xm15_w
XM16 out1_n clk_chout g2_n vss nch_lvt l=x_dut_xm16_l m=x_dut_xm16_m w=x_dut_xm16_w
XM17 g2_n clk_chout_not out1_n vdd pch_lvt l=x_dut_xm17_l m=x_dut_xm17_m w=x_dut_xm17_w
XM18 out1_p clk_chout g2_p vss nch_lvt l=x_dut_xm18_l m=x_dut_xm18_m w=x_dut_xm18_w
XM19 g2_p clk_chout_not out1_p vdd pch_lvt l=x_dut_xm19_l m=x_dut_xm19_m w=x_dut_xm19_w
XM2 fold_p vsum_p tail vdd pch_lvt l=x_dut_xm2_l m=x_dut_xm2_m w=x_dut_xm2_w
XM20 fbch_p clk_chfb voutp vss nch_lvt l=x_dut_xm20_l m=x_dut_xm20_m w=x_dut_xm20_w
XM21 voutp clk_chfb_not fbch_p vdd pch_lvt l=x_dut_xm21_l m=x_dut_xm21_m w=x_dut_xm21_w
XM22 fbch_n clk_chfb voutn vss nch_lvt l=x_dut_xm22_l m=x_dut_xm22_m w=x_dut_xm22_w
XM23 voutn clk_chfb_not fbch_n vdd pch_lvt l=x_dut_xm23_l m=x_dut_xm23_m w=x_dut_xm23_w
XM24 vinn clk_chin inch_n vss nch_lvt l=x_dut_xm24_l m=x_dut_xm24_m w=x_dut_xm24_w
XM25 inch_n clk_chin_not vinn vdd pch_lvt l=x_dut_xm25_l m=x_dut_xm25_m w=x_dut_xm25_w
XM26 vinp clk_chin inch_p vss nch_lvt l=x_dut_xm26_l m=x_dut_xm26_m w=x_dut_xm26_w
XM27 inch_p clk_chin_not vinp vdd pch_lvt l=x_dut_xm27_l m=x_dut_xm27_m w=x_dut_xm27_w
XM28 out1_n clk_chout_not g2_p vss nch_lvt l=x_dut_xm28_l m=x_dut_xm28_m w=x_dut_xm28_w
XM29 g2_p clk_chout out1_n vdd pch_lvt l=x_dut_xm29_l m=x_dut_xm29_m w=x_dut_xm29_w
XM3 fold_n vsum_n tail vdd pch_lvt l=x_dut_xm3_l m=x_dut_xm3_m w=x_dut_xm3_w
XM30 out1_p clk_chout_not g2_n vss nch_lvt l=x_dut_xm30_l m=x_dut_xm30_m w=x_dut_xm30_w
XM31 g2_n clk_chout out1_p vdd pch_lvt l=x_dut_xm31_l m=x_dut_xm31_m w=x_dut_xm31_w
XM32 vinn clk_chin_not inch_p vss nch_lvt l=x_dut_xm32_l m=x_dut_xm32_m w=x_dut_xm32_w
XM33 inch_p clk_chin vinn vdd pch_lvt l=x_dut_xm33_l m=x_dut_xm33_m w=x_dut_xm33_w
XM34 vinp clk_chin_not inch_n vss nch_lvt l=x_dut_xm34_l m=x_dut_xm34_m w=x_dut_xm34_w
XM35 inch_n clk_chin vinp vdd pch_lvt l=x_dut_xm35_l m=x_dut_xm35_m w=x_dut_xm35_w
XM36 fbch_p clk_chfb_not voutn vss nch_lvt l=x_dut_xm36_l m=x_dut_xm36_m w=x_dut_xm36_w
XM37 voutn clk_chfb fbch_p vdd pch_lvt l=x_dut_xm37_l m=x_dut_xm37_m w=x_dut_xm37_w
XM38 fbch_n clk_chfb_not voutp vss nch_lvt l=x_dut_xm38_l m=x_dut_xm38_m w=x_dut_xm38_w
XM39 voutp clk_chfb fbch_n vdd pch_lvt l=x_dut_xm39_l m=x_dut_xm39_m w=x_dut_xm39_w
XM4 fold_p vb1 vss vss nch_lvt l=x_dut_xm4_l m=x_dut_xm4_m w=x_dut_xm4_w
XM5 fold_n vb1 vss vss nch_lvt l=x_dut_xm5_l m=x_dut_xm5_m w=x_dut_xm5_w
XM6 casc_src_n vb4 vdd vdd pch_lvt l=x_dut_xm6_l m=x_dut_xm6_m w=x_dut_xm6_w
XM7 casc_src_p vb4 vdd vdd pch_lvt l=x_dut_xm7_l m=x_dut_xm7_m w=x_dut_xm7_w
XM8 voutp vb4 vdd vdd pch_lvt l=x_dut_xm8_l m=x_dut_xm8_m w=x_dut_xm8_w
XM9 voutn vb4 vdd vdd pch_lvt l=x_dut_xm9_l m=x_dut_xm9_m w=x_dut_xm9_w
.ends
.end
