** GENERATED by `analog-db generate` — DO NOT EDIT. Source: abstract/netlist.spice → ihp-sg13g2
* sup_001_vcm_detector (emitted by spicexplorer-circuitgraph)
RMN vinn vcm_out 'x_dut_rmn_value'
RMP vcm_out vinp 'x_dut_rmp_value'
.end
