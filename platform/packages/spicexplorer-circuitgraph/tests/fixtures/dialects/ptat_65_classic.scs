// sensor/PTAT_65_classic1/schematic
subckt PTAT_65_classic1 GND VDD VOUT
M1 (net3 net3 GND GND) nmos_a l=60n w=200n multi=1 nf=1 sigma=1 mismatchflag=1
M0 (VOUT net3 GND GND) nmos_a l=60n w=200n multi=1 nf=1 sigma=1 mismatchflag=1
M3 (VOUT VOUT VDD VDD) pmos_a l=60n w=200n multi=1 nf=1 sigma=1 mismatchflag=1
M4 (net3 VOUT VDD VDD) pmos_a l=60n w=200n multi=1 nf=1 sigma=1 mismatchflag=1
ends PTAT_65_classic1
