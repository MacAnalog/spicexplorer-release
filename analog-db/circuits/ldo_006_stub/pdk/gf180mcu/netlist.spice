** GENERATED by `analog-db generate` — DO NOT EDIT. Source: abstract/netlist.spice → gf180mcu
* ldo_006_stub (emitted by spicexplorer-circuitgraph)
R1 vdd vref r_top
R2 vref vss r_bot
XM1 vdd vref vout vss nfet_03v3 l=x_dut_xm1_l m=x_dut_xm1_m w=x_dut_xm1_w
.end
