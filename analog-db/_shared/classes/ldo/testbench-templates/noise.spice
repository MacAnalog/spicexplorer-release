** AUTHORED TEMPLATE — ldo/noise: closed-loop output noise, integrated over a band.
** Methodology from the LDO literature benches vendored at circuits/ldo_004_basic_pmos/reference/
** ltspice/Noise_6p38..42.asc (`.noise v(vout)` + integrated output noise). ngspice's `.noise`
** needs an independent source as its "input"; the supply Vdd serves (the DUT's reference is
** internal to the 3-port subckt), so only the OUTPUT-referred noise is meaningful here:
** vn_out_rms = onoise_total over FSTART..FSTOP.
**
** UNIT: ngspice's `.noise` integrated totals (`onoise_total`/`inoise_total`) are ALREADY the
** integrated RMS quantities (V rms at the output), NOT the mean-square V^2/Hz integral -- ngspice
** takes the square root itself when it accumulates the band. Measured on a 1k resistor with
** `noise v(out) V1 dec 10 1 1meg` at 27 C: onoise_total = 4.071369e-06, against the analytic
** sqrt(4kTR*df) = sqrt(4*1.38e-23*300*1e3*1e6) = 4.07e-06 V rms. So NEVER apply a second sqrt
** here: it used to read `sqrt(onoise_total)` and reported 2.018e-03 for that same resistor --
** wrong by ~500x, and worse the smaller the true noise.
** Bindings: DUT PORT_LINE VDD ILOAD COUT FSTART FSTOP PPD PDK_INCLUDE.
${PDK_INCLUDE}

.param VDD=${VDD}

Vdd  vdd 0 dc {VDD} ac 1
Vss  vss 0 dc 0
Iload vout 0 dc ${ILOAD}
CLoad vout 0 ${COUT}

${PORT_LINE} ${DUT}

.control
  set filetype=ascii
  noise v(vout) Vdd dec ${PPD} ${FSTART} ${FSTOP}
  let vn_out_rms = onoise_total
  print onoise_total vn_out_rms
  write
  quit
.endc
.end
