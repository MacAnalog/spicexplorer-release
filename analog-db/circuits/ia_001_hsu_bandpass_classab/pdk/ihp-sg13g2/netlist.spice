** GENERATED by `analog-db generate` — DO NOT EDIT. Source: abstract/netlist.spice → ihp-sg13g2
* ia_001_hsu_bandpass_classab (emitted by spicexplorer-circuitgraph)
C1 flt_p zc_p 'x_dut_c1_value'
C2 flt_n zc_n 'x_dut_c2_value'
CF1 sum_p voutp 'x_dut_cf1_value'
CF2 voutn sum_n 'x_dut_cf2_value'
CIN1 vinn sum_p 'x_dut_cin1_value'
CIN2 vinp sum_n 'x_dut_cin2_value'
CISRV vcm_sense vcmfb_ref 'cin_val'
COSRV vss vcmfb 'cout_val'
GSRV vss vcmfb vcmfb_ref vcm_sense {gm_val}
R1 zc_p out1p 'x_dut_r1_value'
R2 out1n zc_n 'x_dut_r2_value'
RISRV vcm_sense vcmfb_ref 'rin_val'
RMN voutn vcm_sense 'x_dut_rmn_value'
RMP vcm_sense voutp 'x_dut_rmp_value'
ROSRV vcmfb_ref vcmfb 'rout_val'
VB1 vb1 vss dc {vb1}
VB2 vb2 vss dc {vb2}
VB3 vb3 vss dc {vb3}
VCMREF vcmfb_ref vss dc {vcmfb_ref}
XM1 sum_p sum_p pr_mid_p pr_mid_p sg13_lv_pmos l=x_dut_xm1_l m=x_dut_xm1_m w=x_dut_xm1_w
XM2 voutp voutp pr_mid_p pr_mid_p sg13_lv_pmos l=x_dut_xm2_l m=x_dut_xm2_m w=x_dut_xm2_w
XM3 voutn voutn pr_mid_n pr_mid_n sg13_lv_pmos l=x_dut_xm3_l m=x_dut_xm3_m w=x_dut_xm3_w
XM4 sum_n sum_n pr_mid_n pr_mid_n sg13_lv_pmos l=x_dut_xm4_l m=x_dut_xm4_m w=x_dut_xm4_w
XMO1 tail vb1 vdd vdd sg13_lv_pmos l=x_dut_xmo1_l m=x_dut_xmo1_m w=x_dut_xmo1_w
XMO10 out1n vb2 csrc_n vdd sg13_lv_pmos l=x_dut_xmo10_l m=x_dut_xmo10_m w=x_dut_xmo10_w
XMO11 out1p vb2 csrc_p vdd sg13_lv_pmos l=x_dut_xmo11_l m=x_dut_xmo11_m w=x_dut_xmo11_w
XMO12 csrc_n vcmfb vdd vdd sg13_lv_pmos l=x_dut_xmo12_l m=x_dut_xmo12_m w=x_dut_xmo12_w
XMO13 csrc_p vcmfb vdd vdd sg13_lv_pmos l=x_dut_xmo13_l m=x_dut_xmo13_m w=x_dut_xmo13_w
XMO14 gup_p vb1 vdd vdd sg13_lv_pmos l=x_dut_xmo14_l m=x_dut_xmo14_m w=x_dut_xmo14_w
XMO15 gup_p gup_p flt_p vss sg13_lv_nmos l=x_dut_xmo15_l m=x_dut_xmo15_m w=x_dut_xmo15_w
XMO16 vdd gup_p voutp vss sg13_lv_nmos l=x_dut_xmo16_l m=x_dut_xmo16_m w=x_dut_xmo16_w
XMO17 gdn_p gdn_p flt_p vdd sg13_lv_pmos l=x_dut_xmo17_l m=x_dut_xmo17_m w=x_dut_xmo17_w
XMO18 vss gdn_p voutp vdd sg13_lv_pmos l=x_dut_xmo18_l m=x_dut_xmo18_m w=x_dut_xmo18_w
XMO19 gdn_p out1p vss vss sg13_lv_nmos l=x_dut_xmo19_l m=x_dut_xmo19_m w=x_dut_xmo19_w
XMO2 dio_p sum_p tail vdd sg13_lv_pmos l=x_dut_xmo2_l m=x_dut_xmo2_m w=x_dut_xmo2_w
XMO20 gup_n vb1 vdd vdd sg13_lv_pmos l=x_dut_xmo20_l m=x_dut_xmo20_m w=x_dut_xmo20_w
XMO21 gup_n gup_n flt_n vss sg13_lv_nmos l=x_dut_xmo21_l m=x_dut_xmo21_m w=x_dut_xmo21_w
XMO22 vdd gup_n voutn vss sg13_lv_nmos l=x_dut_xmo22_l m=x_dut_xmo22_m w=x_dut_xmo22_w
XMO23 gdn_n gdn_n flt_n vdd sg13_lv_pmos l=x_dut_xmo23_l m=x_dut_xmo23_m w=x_dut_xmo23_w
XMO24 vss gdn_n voutn vdd sg13_lv_pmos l=x_dut_xmo24_l m=x_dut_xmo24_m w=x_dut_xmo24_w
XMO25 gdn_n out1n vss vss sg13_lv_nmos l=x_dut_xmo25_l m=x_dut_xmo25_m w=x_dut_xmo25_w
XMO3 dio_n sum_n tail vdd sg13_lv_pmos l=x_dut_xmo3_l m=x_dut_xmo3_m w=x_dut_xmo3_w
XMO4 dio_p dio_p vss vss sg13_lv_nmos l=x_dut_xmo4_l m=x_dut_xmo4_m w=x_dut_xmo4_w
XMO5 dio_n dio_n vss vss sg13_lv_nmos l=x_dut_xmo5_l m=x_dut_xmo5_m w=x_dut_xmo5_w
XMO6 msrc_n dio_n vss vss sg13_lv_nmos l=x_dut_xmo6_l m=x_dut_xmo6_m w=x_dut_xmo6_w
XMO7 out1n vb3 msrc_n vss sg13_lv_nmos l=x_dut_xmo7_l m=x_dut_xmo7_m w=x_dut_xmo7_w
XMO8 msrc_p dio_p vss vss sg13_lv_nmos l=x_dut_xmo8_l m=x_dut_xmo8_m w=x_dut_xmo8_w
XMO9 out1p vb3 msrc_p vss sg13_lv_nmos l=x_dut_xmo9_l m=x_dut_xmo9_m w=x_dut_xmo9_w
.end
