** GENERATED by `analog-db export-raw` — DO NOT EDIT.
** circuit=amp_024_smcnr  class=amplifier  pdk=ihp-sg13g2  testbench=thd  corner=tt
** Self-contained deck: testbench + bound params + lowered DUT (.subckt amp_024_smcnr).
** PDK corner libs resolve by BARE NAME on the image's ngspice sourcepath — run in a
** PDK-enabled env (the base image / api container), NOT a bare host:
**   docker run --rm -i spicexplorer-spice-base:local \
**     bash -lc 'd=$(mktemp -d) && cat > $d/c.spice && cd $d && ngspice -b c.spice' < raw/amp_024_smcnr/ihp-sg13g2/thd.spice
*----------------------------------------------------------*
** params: 9 free + 9 frozen knobs (sizing.yaml) · 9 tied · 0 ratio-derived (abstract/params.yaml) · 4 testbench params
** AUTHORED TEMPLATE — amplifier/thd_selfbias (2026-08-01): large-signal harmonic distortion in
** the unity buffer for SELF-BIASED DUTs (no ibias port — the TI-LDO error amps amp_032/033).
** Identical to `thd` except there is no external bias source — derived exactly as
** psrr_vdd_selfbias derives from psrr_vdd (drop `.param IBIAS` and the `Ibias` line), so a
** 5-port [vdd vout vinp vinn vss] DUT does not leave a current source driving a dangling
** `ibias` node (which makes the DC solve singular). The unity-buffer DC op point is the same
** one ac_closed_loop_selfbias / linearity_selfbias already prove out for these DUTs, so
** biasing is safe. EVERYTHING measurement-side is grafted from thd.spice UNCHANGED — that
** header carries the full audited story and is the reference for any future edit here; the
** load-bearing invariants it establishes (do not relax ANY of them):
**   * COHERENT WINDOW: (TSTOP-TSTART) MUST be an integer number of F0 periods — a half-period
**     mismatch inflates thd_pct up to 63x (measured). TSTART discards the startup transient
**     and need not land on a period boundary. >= 8 measured periods, TSTEP <= 1/(200*F0).
**   * ENDPOINT-DUPLICATION CORRECTION: `linearize` returns np = nd+1 points whose last sample
**     repeats the first; every bin is therefore taken as
**         re_k = (mean(vac*c_k)*np - vac[0]*c_k[0])/nd
**     Without it the window phase alone swings thd 2.95x and a3 41x (measured on amp_022@ihp).
**     a4/a5 are the tell-tale: if either creeps up to 2*|vac[0]|/np the correction is broken.
**   * `write` BEFORE `linearize`: linearize swaps the current plot for its interpolated
**     scratch copy, so a trailing write guts the raw from every circuit node to the DFT
**     leftovers and breaks the platform {meas: thd_pct} cross-check on the raw.
**   * DEAD-OUTPUT GUARD: a MEASURED tone gain (a1 over the same bin taken on the drive
**     v(vinp)), threshold 0.5 = the |A| = 1 line of gain_tone = A/(1+A). On a fail thd_pct
**     becomes the loud 999 sentinel — bad-direction for a minimize metric, and NOT NaN (a NaN
**     makes the runner discard the whole analysis). It is a SCREEN, not a proof.
**   * No `>` inside a `let` — the .control preprocessor strips it as an output redirection
**     and silently truncates the RHS; masks use `<=` and 1 - mask.
**   * Measure names match the ibias sibling EXACTLY (thd_pct, thd_db, a1..a5, a1_in,
**     gain_tone, vout_op) so datasheet wiring stays uniform across template variants; none is
**     in raw_project._SPEC_REGISTRY (deliberately: `vout_op` not `vout_dc`, `gain_tone` not
**     `gain_cl` — the alternatives ARE registry names and would silently add objectives).
** Bindings: DUT PORT_LINE VDD VCM CL ASIG F0 TSTEP TSTART TSTOP PDK_INCLUDE.
.lib cornerMOSlv.lib mos_tt
.temp 27

.param VDD=1.5
.param VCM=0.5
.param CL=10p
.param ASIG=0.1

Vdd  vdd 0 dc {VDD}
Vss  vss 0 dc 0
CLoad vout 0 {CL}

* unity buffer; the sine offset VCM doubles as the DC operating point
Vinp vinp 0 sin({VCM} {ASIG} 1.0e4)
Vfb  vinn vout dc 0

XDUT vss vdd vinn vinp vout amp_024_smcnr

.control
  set filetype=ascii
  tran 200n 1.8m 200u
  * raw first — see the header; linearize below switches the current plot
  write
  let vo = v(vout)
  let vi = v(vinp)
  linearize vo vi
  let t = time
* --- endpoint-duplication correction (see the header): `linearize` hands back np = nd+1
* --- points whose last sample repeats the first, so mean() averages one sample too many.
* --- mean()*np recovers the sum, subtracting vac[0]*c_k[0] drops the duplicate, /nd gives
* --- the true rectangular-window average over one whole number of periods.
  let np = length(vo)
  let nd = np - 1
  let vout_op = (mean(vo)*np - vo[0])/nd
  * the pedestal subtraction is exactly cancelled by the correction above (measured
  * bit-identical); kept because vout_op is reported anyway and `vac` reads clearer
  let vac = vo - vout_op
  let vin_ac = vi - mean(vi)
  let w = 2*pi*1.0e4
  let c1 = cos(w*t)
  let s1 = sin(w*t)
  let re1 = (mean(vac*c1)*np - vac[0]*c1[0])/nd
  let im1 = (mean(vac*s1)*np - vac[0]*s1[0])/nd
  let a1 = 2*sqrt(re1^2+im1^2)
* --- the SAME bin taken on the DRIVE v(vinp) — the reference for the dead-output guard ---
  let rei = (mean(vin_ac*c1)*np - vin_ac[0]*c1[0])/nd
  let imi = (mean(vin_ac*s1)*np - vin_ac[0]*s1[0])/nd
  let a1_in = 2*sqrt(rei^2+imi^2)
  let c2 = cos(2*w*t)
  let s2 = sin(2*w*t)
  let re2 = (mean(vac*c2)*np - vac[0]*c2[0])/nd
  let im2 = (mean(vac*s2)*np - vac[0]*s2[0])/nd
  let a2 = 2*sqrt(re2^2+im2^2)
  let c3 = cos(3*w*t)
  let s3 = sin(3*w*t)
  let re3 = (mean(vac*c3)*np - vac[0]*c3[0])/nd
  let im3 = (mean(vac*s3)*np - vac[0]*s3[0])/nd
  let a3 = 2*sqrt(re3^2+im3^2)
  let c4 = cos(4*w*t)
  let s4 = sin(4*w*t)
  let re4 = (mean(vac*c4)*np - vac[0]*c4[0])/nd
  let im4 = (mean(vac*s4)*np - vac[0]*s4[0])/nd
  let a4 = 2*sqrt(re4^2+im4^2)
  let c5 = cos(5*w*t)
  let s5 = sin(5*w*t)
  let re5 = (mean(vac*c5)*np - vac[0]*c5[0])/nd
  let im5 = (mean(vac*s5)*np - vac[0]*s5[0])/nd
  let a5 = 2*sqrt(re5^2+im5^2)
* --- DEAD-OUTPUT GUARD (see the header): a MEASURED gain, not a NaN check. Do NOT write
* --- `>` inside a `let` — the control preprocessor strips it as an output redirection and
* --- silently truncates the RHS. Masks use `<=`, inverted with 1 - mask.
  let gain_tone = a1/(a1_in + 1e-18)
  let dead = (gain_tone <= 0.5)
  let live = 1 - dead
  * the 1e-18 floors keep a dead output (a1 == 0) from emitting inf/NaN, which makes the runner
  * throw away the WHOLE analysis; they sit 12+ decades below any real amplitude
  let thd_raw = 100*sqrt(a2^2+a3^2+a4^2+a5^2)/(a1+1e-18)
  let thd_pct = live*thd_raw + dead*999
  let thd_db = 20*log10(thd_pct/100 + 1e-18)
  print a1 a2 a3 a4 a5 a1_in gain_tone thd_pct thd_db vout_op
  quit
.endc
.param x_dut_xm7_w=0.25u
.param x_dut_xm7_l=10u
.param x_dut_xm0_w=7.5u
.param x_dut_xm0_l=8u
.param x_dut_xm1_w=1.5u
.param x_dut_xm1_l=10u
.param x_dut_xm4_w=1.5u
.param x_rz=1e5
.param x_c0=2e-12
.param x_ibias_val=1e-7
.param x_dut_xm7_m=1
.param x_dut_xm6_m=2
.param x_dut_xm5_m=10
.param x_dut_xm0_m=1
.param x_dut_xm2_m=1
.param x_dut_xm1_m=1
.param x_dut_xm3_m=1
.param x_dut_xm4_m=10
* ---- GENERATED parameter ties (abstract/params.yaml groups/ratios) ----
* Each tied symbol is defined exactly once, by its line below; rewrite that
* .param to untie just that symbol (untying = shadowing, plan D-3).
.param x_dut_xm6_w = {x_dut_xm7_w}
.param x_dut_xm5_w = {x_dut_xm7_w}
.param x_dut_xm6_l = {x_dut_xm7_l}
.param x_dut_xm5_l = {x_dut_xm7_l}
.param x_dut_xm2_w = {x_dut_xm0_w}
.param x_dut_xm2_l = {x_dut_xm0_l}
.param x_dut_xm3_l = {x_dut_xm1_l}
.param x_dut_xm4_l = {x_dut_xm1_l}
.param x_dut_xm3_w = {x_dut_xm1_w}
.subckt amp_024_smcnr vss vdd vinn vinp vout
C0 outn nzo x_c0
IBS ibias vss dc {x_ibias_val}
R0 nzo vout x_rz
XM0 outp vinn tailp vdd sg13_lv_pmos l=x_dut_xm0_l m=x_dut_xm0_m w=x_dut_xm0_w
XM1 outp outp vss vss sg13_lv_nmos l=x_dut_xm1_l m=x_dut_xm1_m w=x_dut_xm1_w
XM2 outn vinp tailp vdd sg13_lv_pmos l=x_dut_xm2_l m=x_dut_xm2_m w=x_dut_xm2_w
XM3 outn outp vss vss sg13_lv_nmos l=x_dut_xm3_l m=x_dut_xm3_m w=x_dut_xm3_w
XM4 vout outn vss vss sg13_lv_nmos l=x_dut_xm4_l m=x_dut_xm4_m w=x_dut_xm4_w
XM5 vout ibias vdd vdd sg13_lv_pmos l=x_dut_xm5_l m=x_dut_xm5_m w=x_dut_xm5_w
XM6 tailp ibias vdd vdd sg13_lv_pmos l=x_dut_xm6_l m=x_dut_xm6_m w=x_dut_xm6_w
XM7 ibias ibias vdd vdd sg13_lv_pmos l=x_dut_xm7_l m=x_dut_xm7_m w=x_dut_xm7_w
.ends
.end
