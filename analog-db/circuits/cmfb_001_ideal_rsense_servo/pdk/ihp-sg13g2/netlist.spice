** GENERATED by `analog-db generate` — DO NOT EDIT. Source: abstract/netlist.spice → ihp-sg13g2
* cmfb_001_ideal_rsense_servo (emitted by spicexplorer-circuitgraph)
CIN_SERVO cm_sense vref 'cin_val'
COUT_SERVO vss vcmfb 'cout_val'
GM_SERVO vss vcmfb vref cm_sense {gm_val}
RIN_SERVO cm_sense vref 'rin_val'
RMN vinn cm_sense 'x_dut_rmn_value'
RMP cm_sense vinp 'x_dut_rmp_value'
ROUT_SERVO vss vcmfb 'rout_val'
.end
