* TB[pam4] S-param tone probe f=1e+09 drive=msb
Vcc vcc 0 PWL(0 0 8n 4)
Vcasc vcasc 0 PWL(0 0 8n 3.25)
Vcmb vcmb 0 PWL(0 0 8n 1.9)
Vblsb blsb 0 PWL(0 0 8n 16)
Vbmsb bmsb 0 PWL(0 0 8n 16)
XDUT lsbp lsbn msbp msbn outp outn vcc vcasc vcmb blsb bmsb pam4drv_pam4
Rlp outp vcc 50
Rln outn vcc 50
Vslsbp slsbp 0 PWL(0 0 8n 1.9)
Vslsbn slsbn 0 PWL(0 0 8n 1.9)
Rslsbp slsbp lsbp 50
Rslsbn slsbn lsbn 50
Vsmsbp smsbp 0 SIN(1.9 0.001 1e+09 9n)
Vsmsbn smsbn 0 SIN(1.9 -0.001 1e+09 9n)
Rsmsbp smsbp msbp 50
Rsmsbn smsbn msbn 50
.include ../dut/dut_pam4.spice
.lib "cornerHBT.lib" hbt_typ
.options gmin=1e-12 reltol=1e-3
.control
tran 0.0166667n 35n uic
wrdata ss.csv v(outp)-v(outn) v(msbp)-v(msbn) v(smsbp)-v(smsbn)
.endc
.GLOBAL GND
.end
