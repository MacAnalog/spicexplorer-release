** GENERATED by `analog-db export-raw` — DO NOT EDIT.
** Standalone lowered DUT subckt for ldo_005_buffered_ref on gf180mcu (sizing .param defaults + .subckt).
** Not a runnable deck on its own — include it under your own testbench:
**   .include _dut.spice
**   XDUT vdd vout vss ldo_005_buffered_ref
** Source: pdk/gf180mcu/netlist.spice (run `analog-db generate` to refresh).
*----------------------------------------------------------*
** params: 40 free + 0 frozen knobs (sizing.yaml) · 15 tied · 0 ratio-derived (abstract/params.yaml)
.param x_dut_xmra_bp_w=10.844u
.param x_dut_xmra_bp_l=2u
.param x_dut_xmra_b0_w=12u
.param x_dut_xmra_b0_l=2u
.param x_dut_xmra_bc_w=8.316u
.param x_dut_xmra_bo_w=4u
.param x_dut_xmra_1_w=86.42u
.param x_dut_xmra_1_l=0.7u
.param x_dut_xmra_3_w=20u
.param x_dut_xmra_3_l=1u
.param x_dut_xmra_5_w=37.76u
.param x_dut_xmra_5_l=2.646u
.param r_ra_z=30.853k
.param c_ra_comp=4.508p
.param x_dut_xmea_bp_w=6.3111u
.param x_dut_xmea_bp_l=2u
.param x_dut_xmea_b0_w=34.533u
.param x_dut_xmea_b0_l=2u
.param x_dut_xmea_bf_w=5u
.param x_dut_xmea_1_w=68.542u
.param x_dut_xmea_1_l=0.7u
.param x_dut_xmea_3_w=100u
.param x_dut_xmea_3_l=0.5u
.param x_dut_xmea_4_w=10u
.param x_dut_xmea_4_l=0.5u
.param x_dut_xmea_6_w=14u
.param x_dut_xmea_6_l=3.8349u
.param r_ea_z=28.429k
.param r_ea_nd=50k
.param c_ea_comp=0.2p
.param vref_val=0.8
.param r_ref_top=100k
.param r_ref_bot=100k
.param r_lpf=10k
.param c_lpf=10p
.param x_dut_xmp_w=20u
.param x_dut_xmp_m=7
.param x_dut_xmp_l=0.6u
.param r_bleed=10k
.param c_out_int=10p
* ---- GENERATED parameter ties (abstract/params.yaml groups/ratios) ----
* Each tied symbol is defined exactly once, by its line below; rewrite that
* .param to untie just that symbol (untying = shadowing, plan D-3).
.param x_dut_xmra_bc_l = {x_dut_xmra_b0_l}
.param x_dut_xmra_bo_l = {x_dut_xmra_b0_l}
.param x_dut_xmra_2_w = {x_dut_xmra_1_w}
.param x_dut_xmra_2_l = {x_dut_xmra_1_l}
.param x_dut_xmra_4_w = {x_dut_xmra_3_w}
.param x_dut_xmra_4_l = {x_dut_xmra_3_l}
.param x_dut_xmea_bc_l = {x_dut_xmea_b0_l}
.param x_dut_xmea_bf_l = {x_dut_xmea_b0_l}
.param x_dut_xmea_bo_l = {x_dut_xmea_b0_l}
.param x_dut_xmea_bc_w = {x_dut_xmea_b0_w}
.param x_dut_xmea_bo_w = {x_dut_xmea_b0_w}
.param x_dut_xmea_2_w = {x_dut_xmea_1_w}
.param x_dut_xmea_2_l = {x_dut_xmea_1_l}
.param x_dut_xmea_5_w = {x_dut_xmea_3_w}
.param x_dut_xmea_5_l = {x_dut_xmea_3_l}
.subckt ldo_005_buffered_ref vdd vout vss
C1 vout vss 'c_out_int'
CEAC ea_ncz ea_out 'c_ea_comp'
CRAC ra_ncz v_ref_out 'c_ra_comp'
C_LPF v_lpf_out vss 'c_lpf'
R1 v_ref_out v_ref_fb 'r_ref_top'
R2 v_ref_fb vss 'r_ref_bot'
R3 vout vss 'r_bleed'
REAND ea_na ea_nd 'r_ea_nd'
REAZ ea_nb ea_ncz 'r_ea_z'
RRAZ ra_nb ra_ncz 'r_ra_z'
R_LPF v_ref_out v_lpf_out 'r_lpf'
VLP lp_brk vout dc 0
VREF vref vss dc {vref_val}
XMEA_1 ea_na v_lpf_out ea_tail vss nfet_06v0 l=x_dut_xmea_1_l w=x_dut_xmea_1_w
XMEA_2 ea_nb lp_brk ea_tail vss nfet_06v0 l=x_dut_xmea_2_l w=x_dut_xmea_2_w
XMEA_3 ea_na ea_nd vdd vdd pfet_06v0 l=x_dut_xmea_3_l w=x_dut_xmea_3_w
XMEA_4 ea_nlev ea_na ea_nd vdd pfet_06v0 l=x_dut_xmea_4_l w=x_dut_xmea_4_w
XMEA_5 ea_nb ea_nd vdd vdd pfet_06v0 l=x_dut_xmea_5_l w=x_dut_xmea_5_w
XMEA_6 ea_out ea_nb vdd vdd pfet_06v0 l=x_dut_xmea_6_l w=x_dut_xmea_6_w
XMEA_B0 ea_ibias ea_ibias vss vss nfet_06v0 l=x_dut_xmea_b0_l w=x_dut_xmea_b0_w
XMEA_BC ea_tail ea_ibias vss vss nfet_06v0 l=x_dut_xmea_bc_l w=x_dut_xmea_bc_w
XMEA_BF ea_nlev ea_ibias vss vss nfet_06v0 l=x_dut_xmea_bf_l w=x_dut_xmea_bf_w
XMEA_BO ea_out ea_ibias vss vss nfet_06v0 l=x_dut_xmea_bo_l w=x_dut_xmea_bo_w
XMEA_BP ea_ibias ea_ibias vdd vdd pfet_06v0 l=x_dut_xmea_bp_l w=x_dut_xmea_bp_w
XMP vout ea_out vdd vdd pfet_06v0 l=x_dut_xmp_l m=x_dut_xmp_m w=x_dut_xmp_w
XMRA_1 ra_na v_ref_fb ra_tail vss nfet_06v0 l=x_dut_xmra_1_l w=x_dut_xmra_1_w
XMRA_2 ra_nb vref ra_tail vss nfet_06v0 l=x_dut_xmra_2_l w=x_dut_xmra_2_w
XMRA_3 ra_na ra_na vdd vdd pfet_06v0 l=x_dut_xmra_3_l w=x_dut_xmra_3_w
XMRA_4 ra_nb ra_na vdd vdd pfet_06v0 l=x_dut_xmra_4_l w=x_dut_xmra_4_w
XMRA_5 v_ref_out ra_nb vdd vdd pfet_06v0 l=x_dut_xmra_5_l w=x_dut_xmra_5_w
XMRA_B0 ra_ibias ra_ibias vss vss nfet_06v0 l=x_dut_xmra_b0_l w=x_dut_xmra_b0_w
XMRA_BC ra_tail ra_ibias vss vss nfet_06v0 l=x_dut_xmra_bc_l w=x_dut_xmra_bc_w
XMRA_BO v_ref_out ra_ibias vss vss nfet_06v0 l=x_dut_xmra_bo_l w=x_dut_xmra_bo_w
XMRA_BP ra_ibias ra_ibias vdd vdd pfet_06v0 l=x_dut_xmra_bp_l w=x_dut_xmra_bp_w
.ends
