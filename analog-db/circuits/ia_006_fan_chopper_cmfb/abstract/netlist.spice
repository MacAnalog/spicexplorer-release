** GENERATED by `analog-db generate` — DO NOT EDIT. Source: composition.yaml (composer, plan P4)
** Composite: ia_006_fan_chopper_cmfb = cmfb(cmfb_002_5t_pmos_input @ cf3a412052ba) + core(ia_002_fan_chopper_simple @ db0af98f1e15)
** ia_002_fan_chopper_simple with a REAL 5T CMFB (cmfb_002_5t_pmos_input) closed around its output common mode — the identical seam amp_034 uses on the static core: OMIT the class-A output PMOS current sources XM8/XM9 from the block and re-instantiate them here on their own gate node vb4o, driven by the CMFB.
** WHY THIS ENTRY EXISTS. review_chopper_cm_rejection_2026-08-04 measured ia_002's clocked CM supply rejection at -52.9 dB raw (vs -59.5 dB with the chopper static) and showed WHY chopping cannot help: the output chopper swaps voutp<->voutn, and vocm = (voutp+voutn)/2 is invariant under that swap, so the modulator never touches the CM path. The rejection is set entirely by the core's CM behaviour, and ia_002's core has no CMFB. That doc's recommendation was "size a CMFB'd variant, then re-run this bench" — this is the variant, and psrr_vdd_chop is that bench.
** The actuator, the flavor (PMOS-input cmfb_002 over NMOS-input cmfb_003) and the loop sign are all inherited from amp_034's measured selection — see doc/review_amp034_cm_closure_2026-08-05.md. Nothing about the clocked network changes the CM plant: the choppers sit between the fold nodes and the second-stage gates (out1 -> g2) and between the outputs and the feedback caps; the output current sources they feed are the same devices, on the same node.
** LOOP SIGN: vocm UP -> cm_sense UP -> vcmfb = A*(cm_sense - vref_cm) UP -> vb4o UP -> XM8O/XM9O |Vsg| DOWN -> output pull-up DOWN -> vocm DOWN. Negative feedback.
**.subckt ia_006_fan_chopper_cmfb vinp vinn voutp voutn vref clk_chin clk_chin_not clk_chfb clk_chfb_not clk_chout clk_chout_not vdd vss
* --- instance cmfb: cmfb_002_5t_pmos_input @ cf3a412052ba ---
RMP_CMFB cmfb__cm_sense voutp 'x_dut_rmp_cmfb_value'
RMN_CMFB voutn cmfb__cm_sense 'x_dut_rmn_cmfb_value'
XM1_CMFB cmfb__ptail cmfb__bias vdd vdd pmos l=x_dut_xm1_cmfb_l m=x_dut_xm1_cmfb_m w=x_dut_xm1_cmfb_w
XM2_CMFB vb4o cmfb__mirr vss vss nmos l=x_dut_xm2_cmfb_l m=x_dut_xm2_cmfb_m w=x_dut_xm2_cmfb_w
XM3_CMFB cmfb__bias cmfb__bias vdd vdd pmos l=x_dut_xm3_cmfb_l m=x_dut_xm3_cmfb_m w=x_dut_xm3_cmfb_w
XM4_CMFB cmfb__mirr cmfb__cm_sense cmfb__ptail vdd pmos l=x_dut_xm4_cmfb_l m=x_dut_xm4_cmfb_m w=x_dut_xm4_cmfb_w
XM5_CMFB vb4o vref_cm cmfb__ptail vdd pmos l=x_dut_xm5_cmfb_l m=x_dut_xm5_cmfb_m w=x_dut_xm5_cmfb_w
XM6_CMFB cmfb__mirr cmfb__mirr vss vss nmos l=x_dut_xm6_cmfb_l m=x_dut_xm6_cmfb_m w=x_dut_xm6_cmfb_w
XM7_CMFB cmfb__bias cmfb__bias vss vss nmos l=x_dut_xm7_cmfb_l m=x_dut_xm7_cmfb_m w=x_dut_xm7_cmfb_w
* --- instance core: ia_002_fan_chopper_simple @ db0af98f1e15 (omit: XM8, XM9) ---
XM1_CORE core__tail core__vb4 vdd vdd pmos w=x_dut_xm1_core_w l=x_dut_xm1_core_l m=x_dut_xm1_core_m
XM2_CORE core__fold_p core__vsum_p core__tail vdd pmos w=x_dut_xm2_core_w l=x_dut_xm2_core_l m=x_dut_xm2_core_m
XM3_CORE core__fold_n core__vsum_n core__tail vdd pmos w=x_dut_xm3_core_w l=x_dut_xm3_core_l m=x_dut_xm3_core_m
XM4_CORE core__fold_p core__vb1 vss vss nmos w=x_dut_xm4_core_w l=x_dut_xm4_core_l m=x_dut_xm4_core_m
XM5_CORE core__fold_n core__vb1 vss vss nmos w=x_dut_xm5_core_w l=x_dut_xm5_core_l m=x_dut_xm5_core_m
XM12_CORE core__out1_p core__vb2 core__fold_p vss nmos w=x_dut_xm12_core_w l=x_dut_xm12_core_l m=x_dut_xm12_core_m
XM13_CORE core__out1_n core__vb2 core__fold_n vss nmos w=x_dut_xm13_core_w l=x_dut_xm13_core_l m=x_dut_xm13_core_m
XM6_CORE core__casc_src_n core__vb4 vdd vdd pmos w=x_dut_xm6_core_w l=x_dut_xm6_core_l m=x_dut_xm6_core_m
XM7_CORE core__casc_src_p core__vb4 vdd vdd pmos w=x_dut_xm7_core_w l=x_dut_xm7_core_l m=x_dut_xm7_core_m
XM10_CORE core__out1_n core__vb3 core__casc_src_n vdd pmos w=x_dut_xm10_core_w l=x_dut_xm10_core_l m=x_dut_xm10_core_m
XM11_CORE core__out1_p core__vb3 core__casc_src_p vdd pmos w=x_dut_xm11_core_w l=x_dut_xm11_core_l m=x_dut_xm11_core_m
XM16_CORE core__out1_n clk_chout core__g2_n vss nmos w=x_dut_xm16_core_w l=x_dut_xm16_core_l m=x_dut_xm16_core_m
XM17_CORE core__g2_n clk_chout_not core__out1_n vdd pmos w=x_dut_xm17_core_w l=x_dut_xm17_core_l m=x_dut_xm17_core_m
XM18_CORE core__out1_p clk_chout core__g2_p vss nmos w=x_dut_xm18_core_w l=x_dut_xm18_core_l m=x_dut_xm18_core_m
XM19_CORE core__g2_p clk_chout_not core__out1_p vdd pmos w=x_dut_xm19_core_w l=x_dut_xm19_core_l m=x_dut_xm19_core_m
XM28_CORE core__out1_n clk_chout_not core__g2_p vss nmos w=x_dut_xm28_core_w l=x_dut_xm28_core_l m=x_dut_xm28_core_m
XM29_CORE core__g2_p clk_chout core__out1_n vdd pmos w=x_dut_xm29_core_w l=x_dut_xm29_core_l m=x_dut_xm29_core_m
XM30_CORE core__out1_p clk_chout_not core__g2_n vss nmos w=x_dut_xm30_core_w l=x_dut_xm30_core_l m=x_dut_xm30_core_m
XM31_CORE core__g2_n clk_chout core__out1_p vdd pmos w=x_dut_xm31_core_w l=x_dut_xm31_core_l m=x_dut_xm31_core_m
XM14_CORE voutp core__g2_p vss vss nmos w=x_dut_xm14_core_w l=x_dut_xm14_core_l m=x_dut_xm14_core_m
XM15_CORE voutn core__g2_n vss vss nmos w=x_dut_xm15_core_w l=x_dut_xm15_core_l m=x_dut_xm15_core_m
Cm1_CORE core__g2_p voutp 'x_dut_cm1_core_value'
Cm2_CORE core__g2_n voutn 'x_dut_cm2_core_value'
Vb1_CORE core__vb1 vss dc {vb1_core}
Vb2_CORE core__vb2 vss dc {vb2_core}
Vb3_CORE core__vb3 vss dc {vb3_core}
Vb4_CORE core__vb4 vss dc {vb4_core}
XM24_CORE vinn clk_chin core__inch_n vss nmos w=x_dut_xm24_core_w l=x_dut_xm24_core_l m=x_dut_xm24_core_m
XM25_CORE core__inch_n clk_chin_not vinn vdd pmos w=x_dut_xm25_core_w l=x_dut_xm25_core_l m=x_dut_xm25_core_m
XM26_CORE vinp clk_chin core__inch_p vss nmos w=x_dut_xm26_core_w l=x_dut_xm26_core_l m=x_dut_xm26_core_m
XM27_CORE core__inch_p clk_chin_not vinp vdd pmos w=x_dut_xm27_core_w l=x_dut_xm27_core_l m=x_dut_xm27_core_m
XM32_CORE vinn clk_chin_not core__inch_p vss nmos w=x_dut_xm32_core_w l=x_dut_xm32_core_l m=x_dut_xm32_core_m
XM33_CORE core__inch_p clk_chin vinn vdd pmos w=x_dut_xm33_core_w l=x_dut_xm33_core_l m=x_dut_xm33_core_m
XM34_CORE vinp clk_chin_not core__inch_n vss nmos w=x_dut_xm34_core_w l=x_dut_xm34_core_l m=x_dut_xm34_core_m
XM35_CORE core__inch_n clk_chin vinp vdd pmos w=x_dut_xm35_core_w l=x_dut_xm35_core_l m=x_dut_xm35_core_m
Cin1_CORE core__vsum_n core__inch_n 'x_dut_cin1_core_value'
Cin2_CORE core__vsum_p core__inch_p 'x_dut_cin2_core_value'
Rb1_CORE core__vsum_n vref 'x_dut_rb1_core_value'
Rb2_CORE core__vsum_p vref 'x_dut_rb2_core_value'
XM20_CORE core__fbch_p clk_chfb voutp vss nmos w=x_dut_xm20_core_w l=x_dut_xm20_core_l m=x_dut_xm20_core_m
XM21_CORE voutp clk_chfb_not core__fbch_p vdd pmos w=x_dut_xm21_core_w l=x_dut_xm21_core_l m=x_dut_xm21_core_m
XM22_CORE core__fbch_n clk_chfb voutn vss nmos w=x_dut_xm22_core_w l=x_dut_xm22_core_l m=x_dut_xm22_core_m
XM23_CORE voutn clk_chfb_not core__fbch_n vdd pmos w=x_dut_xm23_core_w l=x_dut_xm23_core_l m=x_dut_xm23_core_m
XM36_CORE core__fbch_p clk_chfb_not voutn vss nmos w=x_dut_xm36_core_w l=x_dut_xm36_core_l m=x_dut_xm36_core_m
XM37_CORE voutn clk_chfb core__fbch_p vdd pmos w=x_dut_xm37_core_w l=x_dut_xm37_core_l m=x_dut_xm37_core_m
XM38_CORE core__fbch_n clk_chfb_not voutp vss nmos w=x_dut_xm38_core_w l=x_dut_xm38_core_l m=x_dut_xm38_core_m
XM39_CORE voutp clk_chfb core__fbch_n vdd pmos w=x_dut_xm39_core_w l=x_dut_xm39_core_l m=x_dut_xm39_core_m
Cfb1_CORE core__fbch_p core__vsum_n 'x_dut_cfb1_core_value'
Cfb2_CORE core__fbch_n core__vsum_p 'x_dut_cfb2_core_value'
* --- composite-owned nets ---
Vrefcm vref_cm vss dc {vcm_ref}
XM8O voutp vb4o vdd vdd pmos w=x_dut_xm8o_w l=x_dut_xm8o_l m=x_dut_xm8o_m
XM9O voutn vb4o vdd vdd pmos w=x_dut_xm9o_w l=x_dut_xm9o_l m=x_dut_xm9o_m
Ccm vb4o vss 'c_cm'
**.ends
.end
