// Library name: SAR_11B_ZZS
// Cell name: L5_CAP_ARRAY
// View name: schematic
// Inherited view list: spectre cmos_sch cmos.sch schematic veriloga ahdl
// pspice dspf
subckt L5_CAP_ARRAY VBOT\<11\> VBOT\<10\> VBOT\<9\> VBOT\<8\> VBOT\<7\> \
        VBOT\<6\> VBOT\<5\> VBOT\<4\> VBOT\<3\> VBOT\<2\> VBOT\<1\> VREFP \
        VTOP
    I0 (VREFP VTOP) LB_CUNIT_X1
    I1 (VBOT\<1\> VTOP) LB_CUNIT_X1
    I2\<2\> (VBOT\<2\> VTOP) LB_CUNIT_X1
    I2\<1\> (VBOT\<2\> VTOP) LB_CUNIT_X1
    I11\<167\> (VBOT\<11\> VTOP) LB_CUNIT_X3
    I11\<166\> (VBOT\<11\> VTOP) LB_CUNIT_X3
    I11\<165\> (VBOT\<11\> VTOP) LB_CUNIT_X3
    I11\<164\> (VBOT\<11\> VTOP) LB_CUNIT_X3
    I11\<163\> (VBOT\<11\> VTOP) LB_CUNIT_X3
    I11\<162\> (VBOT\<11\> VTOP) LB_CUNIT_X3
    I11\<161\> (VBOT\<11\> VTOP) LB_CUNIT_X3
    I11\<160\> (VBOT\<11\> VTOP) LB_CUNIT_X3
    I11\<159\> (VBOT\<11\> VTOP) LB_CUNIT_X3
    I11\<158\> (VBOT\<11\> VTOP) LB_CUNIT_X3
    I11\<157\> (VBOT\<11\> VTOP) LB_CUNIT_X3
    I11\<156\> (VBOT\<11\> VTOP) LB_CUNIT_X3
    I11\<155\> (VBOT\<11\> VTOP) LB_CUNIT_X3
    I11\<154\> (VBOT\<11\> VTOP) LB_CUNIT_X3
    I11\<153\> (VBOT\<11\> VTOP) LB_CUNIT_X3
    I11\<152\> (VBOT\<11\> VTOP) LB_CUNIT_X3
    I11\<151\> (VBOT\<11\> VTOP) LB_CUNIT_X3
    I11\<150\> (VBOT\<11\> VTOP) LB_CUNIT_X3
    I11\<149\> (VBOT\<11\> VTOP) LB_CUNIT_X3
    I11\<148\> (VBOT\<11\> VTOP) LB_CUNIT_X3
    I11\<147\> (VBOT\<11\> VTOP) LB_CUNIT_X3
    I11\<146\> (VBOT\<11\> VTOP) LB_CUNIT_X3
    I11\<145\> (VBOT\<11\> VTOP) LB_CUNIT_X3
    I11\<144\> (VBOT\<11\> VTOP) LB_CUNIT_X3
    I11\<143\> (VBOT\<11\> VTOP) LB_CUNIT_X3
    I11\<142\> (VBOT\<11\> VTOP) LB_CUNIT_X3
    I11\<141\> (VBOT\<11\> VTOP) LB_CUNIT_X3
    I11\<140\> (VBOT\<11\> VTOP) LB_CUNIT_X3
    I11\<139\> (VBOT\<11\> VTOP) LB_CUNIT_X3
    I11\<138\> (VBOT\<11\> VTOP) LB_CUNIT_X3
    I11\<137\> (VBOT\<11\> VTOP) LB_CUNIT_X3
    I11\<136\> (VBOT\<11\> VTOP) LB_CUNIT_X3
    I11\<135\> (VBOT\<11\> VTOP) LB_CUNIT_X3
    I11\<134\> (VBOT\<11\> VTOP) LB_CUNIT_X3
    I11\<133\> (VBOT\<11\> VTOP) LB_CUNIT_X3
    I11\<132\> (VBOT\<11\> VTOP) LB_CUNIT_X3
    I11\<131\> (VBOT\<11\> VTOP) LB_CUNIT_X3
    I11\<130\> (VBOT\<11\> VTOP) LB_CUNIT_X3
    I11\<129\> (VBOT\<11\> VTOP) LB_CUNIT_X3
    I11\<128\> (VBOT\<11\> VTOP) LB_CUNIT_X3
    I11\<127\> (VBOT\<11\> VTOP) LB_CUNIT_X3
    I11\<126\> (VBOT\<11\> VTOP) LB_CUNIT_X3
    I11\<125\> (VBOT\<11\> VTOP) LB_CUNIT_X3
    I11\<124\> (VBOT\<11\> VTOP) LB_CUNIT_X3
    I11\<123\> (VBOT\<11\> VTOP) LB_CUNIT_X3
    I11\<122\> (VBOT\<11\> VTOP) LB_CUNIT_X3
    I11\<121\> (VBOT\<11\> VTOP) LB_CUNIT_X3
    I11\<120\> (VBOT\<11\> VTOP) LB_CUNIT_X3
    I11\<119\> (VBOT\<11\> VTOP) LB_CUNIT_X3
    I11\<118\> (VBOT\<11\> VTOP) LB_CUNIT_X3
    I11\<117\> (VBOT\<11\> VTOP) LB_CUNIT_X3
    I11\<116\> (VBOT\<11\> VTOP) LB_CUNIT_X3
    I11\<115\> (VBOT\<11\> VTOP) LB_CUNIT_X3
    I11\<114\> (VBOT\<11\> VTOP) LB_CUNIT_X3
    I11\<113\> (VBOT\<11\> VTOP) LB_CUNIT_X3
    I11\<112\> (VBOT\<11\> VTOP) LB_CUNIT_X3
    I11\<111\> (VBOT\<11\> VTOP) LB_CUNIT_X3
    I11\<110\> (VBOT\<11\> VTOP) LB_CUNIT_X3
    I11\<109\> (VBOT\<11\> VTOP) LB_CUNIT_X3
    I11\<108\> (VBOT\<11\> VTOP) LB_CUNIT_X3
    I11\<107\> (VBOT\<11\> VTOP) LB_CUNIT_X3
    I11\<106\> (VBOT\<11\> VTOP) LB_CUNIT_X3
    I11\<105\> (VBOT\<11\> VTOP) LB_CUNIT_X3
    I11\<104\> (VBOT\<11\> VTOP) LB_CUNIT_X3
    I11\<103\> (VBOT\<11\> VTOP) LB_CUNIT_X3
    I11\<102\> (VBOT\<11\> VTOP) LB_CUNIT_X3
    I11\<101\> (VBOT\<11\> VTOP) LB_CUNIT_X3
    I11\<100\> (VBOT\<11\> VTOP) LB_CUNIT_X3
    I11\<99\> (VBOT\<11\> VTOP) LB_CUNIT_X3
    I11\<98\> (VBOT\<11\> VTOP) LB_CUNIT_X3
    I11\<97\> (VBOT\<11\> VTOP) LB_CUNIT_X3
    I11\<96\> (VBOT\<11\> VTOP) LB_CUNIT_X3
    I11\<95\> (VBOT\<11\> VTOP) LB_CUNIT_X3
    I11\<94\> (VBOT\<11\> VTOP) LB_CUNIT_X3
    I11\<93\> (VBOT\<11\> VTOP) LB_CUNIT_X3
    I11\<92\> (VBOT\<11\> VTOP) LB_CUNIT_X3
    I11\<91\> (VBOT\<11\> VTOP) LB_CUNIT_X3
    I11\<90\> (VBOT\<11\> VTOP) LB_CUNIT_X3
    I11\<89\> (VBOT\<11\> VTOP) LB_CUNIT_X3
    I11\<88\> (VBOT\<11\> VTOP) LB_CUNIT_X3
    I11\<87\> (VBOT\<11\> VTOP) LB_CUNIT_X3
    I11\<86\> (VBOT\<11\> VTOP) LB_CUNIT_X3
    I11\<85\> (VBOT\<11\> VTOP) LB_CUNIT_X3
    I11\<84\> (VBOT\<11\> VTOP) LB_CUNIT_X3
    I11\<83\> (VBOT\<11\> VTOP) LB_CUNIT_X3
    I11\<82\> (VBOT\<11\> VTOP) LB_CUNIT_X3
    I11\<81\> (VBOT\<11\> VTOP) LB_CUNIT_X3
    I11\<80\> (VBOT\<11\> VTOP) LB_CUNIT_X3
    I11\<79\> (VBOT\<11\> VTOP) LB_CUNIT_X3
    I11\<78\> (VBOT\<11\> VTOP) LB_CUNIT_X3
    I11\<77\> (VBOT\<11\> VTOP) LB_CUNIT_X3
    I11\<76\> (VBOT\<11\> VTOP) LB_CUNIT_X3
    I11\<75\> (VBOT\<11\> VTOP) LB_CUNIT_X3
    I11\<74\> (VBOT\<11\> VTOP) LB_CUNIT_X3
    I11\<73\> (VBOT\<11\> VTOP) LB_CUNIT_X3
    I11\<72\> (VBOT\<11\> VTOP) LB_CUNIT_X3
    I11\<71\> (VBOT\<11\> VTOP) LB_CUNIT_X3
    I11\<70\> (VBOT\<11\> VTOP) LB_CUNIT_X3
    I11\<69\> (VBOT\<11\> VTOP) LB_CUNIT_X3
    I11\<68\> (VBOT\<11\> VTOP) LB_CUNIT_X3
    I11\<67\> (VBOT\<11\> VTOP) LB_CUNIT_X3
    I11\<66\> (VBOT\<11\> VTOP) LB_CUNIT_X3
    I11\<65\> (VBOT\<11\> VTOP) LB_CUNIT_X3
    I11\<64\> (VBOT\<11\> VTOP) LB_CUNIT_X3
    I11\<63\> (VBOT\<11\> VTOP) LB_CUNIT_X3
    I11\<62\> (VBOT\<11\> VTOP) LB_CUNIT_X3
    I11\<61\> (VBOT\<11\> VTOP) LB_CUNIT_X3
    I11\<60\> (VBOT\<11\> VTOP) LB_CUNIT_X3
    I11\<59\> (VBOT\<11\> VTOP) LB_CUNIT_X3
    I11\<58\> (VBOT\<11\> VTOP) LB_CUNIT_X3
    I11\<57\> (VBOT\<11\> VTOP) LB_CUNIT_X3
    I11\<56\> (VBOT\<11\> VTOP) LB_CUNIT_X3
    I11\<55\> (VBOT\<11\> VTOP) LB_CUNIT_X3
    I11\<54\> (VBOT\<11\> VTOP) LB_CUNIT_X3
    I11\<53\> (VBOT\<11\> VTOP) LB_CUNIT_X3
    I11\<52\> (VBOT\<11\> VTOP) LB_CUNIT_X3
    I11\<51\> (VBOT\<11\> VTOP) LB_CUNIT_X3
    I11\<50\> (VBOT\<11\> VTOP) LB_CUNIT_X3
    I11\<49\> (VBOT\<11\> VTOP) LB_CUNIT_X3
    I11\<48\> (VBOT\<11\> VTOP) LB_CUNIT_X3
    I11\<47\> (VBOT\<11\> VTOP) LB_CUNIT_X3
    I11\<46\> (VBOT\<11\> VTOP) LB_CUNIT_X3
    I11\<45\> (VBOT\<11\> VTOP) LB_CUNIT_X3
    I11\<44\> (VBOT\<11\> VTOP) LB_CUNIT_X3
    I11\<43\> (VBOT\<11\> VTOP) LB_CUNIT_X3
    I11\<42\> (VBOT\<11\> VTOP) LB_CUNIT_X3
    I11\<41\> (VBOT\<11\> VTOP) LB_CUNIT_X3
    I11\<40\> (VBOT\<11\> VTOP) LB_CUNIT_X3
    I11\<39\> (VBOT\<11\> VTOP) LB_CUNIT_X3
    I11\<38\> (VBOT\<11\> VTOP) LB_CUNIT_X3
    I11\<37\> (VBOT\<11\> VTOP) LB_CUNIT_X3
    I11\<36\> (VBOT\<11\> VTOP) LB_CUNIT_X3
    I11\<35\> (VBOT\<11\> VTOP) LB_CUNIT_X3
    I11\<34\> (VBOT\<11\> VTOP) LB_CUNIT_X3
    I11\<33\> (VBOT\<11\> VTOP) LB_CUNIT_X3
    I11\<32\> (VBOT\<11\> VTOP) LB_CUNIT_X3
    I11\<31\> (VBOT\<11\> VTOP) LB_CUNIT_X3
    I11\<30\> (VBOT\<11\> VTOP) LB_CUNIT_X3
    I11\<29\> (VBOT\<11\> VTOP) LB_CUNIT_X3
    I11\<28\> (VBOT\<11\> VTOP) LB_CUNIT_X3
    I11\<27\> (VBOT\<11\> VTOP) LB_CUNIT_X3
    I11\<26\> (VBOT\<11\> VTOP) LB_CUNIT_X3
    I11\<25\> (VBOT\<11\> VTOP) LB_CUNIT_X3
    I11\<24\> (VBOT\<11\> VTOP) LB_CUNIT_X3
    I11\<23\> (VBOT\<11\> VTOP) LB_CUNIT_X3
    I11\<22\> (VBOT\<11\> VTOP) LB_CUNIT_X3
    I11\<21\> (VBOT\<11\> VTOP) LB_CUNIT_X3
    I11\<20\> (VBOT\<11\> VTOP) LB_CUNIT_X3
    I11\<19\> (VBOT\<11\> VTOP) LB_CUNIT_X3
    I11\<18\> (VBOT\<11\> VTOP) LB_CUNIT_X3
    I11\<17\> (VBOT\<11\> VTOP) LB_CUNIT_X3
    I11\<16\> (VBOT\<11\> VTOP) LB_CUNIT_X3
    I11\<15\> (VBOT\<11\> VTOP) LB_CUNIT_X3
    I11\<14\> (VBOT\<11\> VTOP) LB_CUNIT_X3
    I11\<13\> (VBOT\<11\> VTOP) LB_CUNIT_X3
    I11\<12\> (VBOT\<11\> VTOP) LB_CUNIT_X3
    I11\<11\> (VBOT\<11\> VTOP) LB_CUNIT_X3
    I11\<10\> (VBOT\<11\> VTOP) LB_CUNIT_X3
    I11\<9\> (VBOT\<11\> VTOP) LB_CUNIT_X3
    I11\<8\> (VBOT\<11\> VTOP) LB_CUNIT_X3
    I11\<7\> (VBOT\<11\> VTOP) LB_CUNIT_X3
    I11\<6\> (VBOT\<11\> VTOP) LB_CUNIT_X3
    I11\<5\> (VBOT\<11\> VTOP) LB_CUNIT_X3
    I11\<4\> (VBOT\<11\> VTOP) LB_CUNIT_X3
    I11\<3\> (VBOT\<11\> VTOP) LB_CUNIT_X3
    I11\<2\> (VBOT\<11\> VTOP) LB_CUNIT_X3
    I11\<1\> (VBOT\<11\> VTOP) LB_CUNIT_X3
    I9\<48\> (VBOT\<9\> VTOP) LB_CUNIT_X3
    I9\<47\> (VBOT\<9\> VTOP) LB_CUNIT_X3
    I9\<46\> (VBOT\<9\> VTOP) LB_CUNIT_X3
    I9\<45\> (VBOT\<9\> VTOP) LB_CUNIT_X3
    I9\<44\> (VBOT\<9\> VTOP) LB_CUNIT_X3
    I9\<43\> (VBOT\<9\> VTOP) LB_CUNIT_X3
    I9\<42\> (VBOT\<9\> VTOP) LB_CUNIT_X3
    I9\<41\> (VBOT\<9\> VTOP) LB_CUNIT_X3
    I9\<40\> (VBOT\<9\> VTOP) LB_CUNIT_X3
    I9\<39\> (VBOT\<9\> VTOP) LB_CUNIT_X3
    I9\<38\> (VBOT\<9\> VTOP) LB_CUNIT_X3
    I9\<37\> (VBOT\<9\> VTOP) LB_CUNIT_X3
    I9\<36\> (VBOT\<9\> VTOP) LB_CUNIT_X3
    I9\<35\> (VBOT\<9\> VTOP) LB_CUNIT_X3
    I9\<34\> (VBOT\<9\> VTOP) LB_CUNIT_X3
    I9\<33\> (VBOT\<9\> VTOP) LB_CUNIT_X3
    I9\<32\> (VBOT\<9\> VTOP) LB_CUNIT_X3
    I9\<31\> (VBOT\<9\> VTOP) LB_CUNIT_X3
    I9\<30\> (VBOT\<9\> VTOP) LB_CUNIT_X3
    I9\<29\> (VBOT\<9\> VTOP) LB_CUNIT_X3
    I9\<28\> (VBOT\<9\> VTOP) LB_CUNIT_X3
    I9\<27\> (VBOT\<9\> VTOP) LB_CUNIT_X3
    I9\<26\> (VBOT\<9\> VTOP) LB_CUNIT_X3
    I9\<25\> (VBOT\<9\> VTOP) LB_CUNIT_X3
    I9\<24\> (VBOT\<9\> VTOP) LB_CUNIT_X3
    I9\<23\> (VBOT\<9\> VTOP) LB_CUNIT_X3
    I9\<22\> (VBOT\<9\> VTOP) LB_CUNIT_X3
    I9\<21\> (VBOT\<9\> VTOP) LB_CUNIT_X3
    I9\<20\> (VBOT\<9\> VTOP) LB_CUNIT_X3
    I9\<19\> (VBOT\<9\> VTOP) LB_CUNIT_X3
    I9\<18\> (VBOT\<9\> VTOP) LB_CUNIT_X3
    I9\<17\> (VBOT\<9\> VTOP) LB_CUNIT_X3
    I9\<16\> (VBOT\<9\> VTOP) LB_CUNIT_X3
    I9\<15\> (VBOT\<9\> VTOP) LB_CUNIT_X3
    I9\<14\> (VBOT\<9\> VTOP) LB_CUNIT_X3
    I9\<13\> (VBOT\<9\> VTOP) LB_CUNIT_X3
    I9\<12\> (VBOT\<9\> VTOP) LB_CUNIT_X3
    I9\<11\> (VBOT\<9\> VTOP) LB_CUNIT_X3
    I9\<10\> (VBOT\<9\> VTOP) LB_CUNIT_X3
    I9\<9\> (VBOT\<9\> VTOP) LB_CUNIT_X3
    I9\<8\> (VBOT\<9\> VTOP) LB_CUNIT_X3
    I9\<7\> (VBOT\<9\> VTOP) LB_CUNIT_X3
    I9\<6\> (VBOT\<9\> VTOP) LB_CUNIT_X3
    I9\<5\> (VBOT\<9\> VTOP) LB_CUNIT_X3
    I9\<4\> (VBOT\<9\> VTOP) LB_CUNIT_X3
    I9\<3\> (VBOT\<9\> VTOP) LB_CUNIT_X3
    I9\<2\> (VBOT\<9\> VTOP) LB_CUNIT_X3
    I9\<1\> (VBOT\<9\> VTOP) LB_CUNIT_X3
    I10\<90\> (VBOT\<10\> VTOP) LB_CUNIT_X3
    I10\<89\> (VBOT\<10\> VTOP) LB_CUNIT_X3
    I10\<88\> (VBOT\<10\> VTOP) LB_CUNIT_X3
    I10\<87\> (VBOT\<10\> VTOP) LB_CUNIT_X3
    I10\<86\> (VBOT\<10\> VTOP) LB_CUNIT_X3
    I10\<85\> (VBOT\<10\> VTOP) LB_CUNIT_X3
    I10\<84\> (VBOT\<10\> VTOP) LB_CUNIT_X3
    I10\<83\> (VBOT\<10\> VTOP) LB_CUNIT_X3
    I10\<82\> (VBOT\<10\> VTOP) LB_CUNIT_X3
    I10\<81\> (VBOT\<10\> VTOP) LB_CUNIT_X3
    I10\<80\> (VBOT\<10\> VTOP) LB_CUNIT_X3
    I10\<79\> (VBOT\<10\> VTOP) LB_CUNIT_X3
    I10\<78\> (VBOT\<10\> VTOP) LB_CUNIT_X3
    I10\<77\> (VBOT\<10\> VTOP) LB_CUNIT_X3
    I10\<76\> (VBOT\<10\> VTOP) LB_CUNIT_X3
    I10\<75\> (VBOT\<10\> VTOP) LB_CUNIT_X3
    I10\<74\> (VBOT\<10\> VTOP) LB_CUNIT_X3
    I10\<73\> (VBOT\<10\> VTOP) LB_CUNIT_X3
    I10\<72\> (VBOT\<10\> VTOP) LB_CUNIT_X3
    I10\<71\> (VBOT\<10\> VTOP) LB_CUNIT_X3
    I10\<70\> (VBOT\<10\> VTOP) LB_CUNIT_X3
    I10\<69\> (VBOT\<10\> VTOP) LB_CUNIT_X3
    I10\<68\> (VBOT\<10\> VTOP) LB_CUNIT_X3
    I10\<67\> (VBOT\<10\> VTOP) LB_CUNIT_X3
    I10\<66\> (VBOT\<10\> VTOP) LB_CUNIT_X3
    I10\<65\> (VBOT\<10\> VTOP) LB_CUNIT_X3
    I10\<64\> (VBOT\<10\> VTOP) LB_CUNIT_X3
    I10\<63\> (VBOT\<10\> VTOP) LB_CUNIT_X3
    I10\<62\> (VBOT\<10\> VTOP) LB_CUNIT_X3
    I10\<61\> (VBOT\<10\> VTOP) LB_CUNIT_X3
    I10\<60\> (VBOT\<10\> VTOP) LB_CUNIT_X3
    I10\<59\> (VBOT\<10\> VTOP) LB_CUNIT_X3
    I10\<58\> (VBOT\<10\> VTOP) LB_CUNIT_X3
    I10\<57\> (VBOT\<10\> VTOP) LB_CUNIT_X3
    I10\<56\> (VBOT\<10\> VTOP) LB_CUNIT_X3
    I10\<55\> (VBOT\<10\> VTOP) LB_CUNIT_X3
    I10\<54\> (VBOT\<10\> VTOP) LB_CUNIT_X3
    I10\<53\> (VBOT\<10\> VTOP) LB_CUNIT_X3
    I10\<52\> (VBOT\<10\> VTOP) LB_CUNIT_X3
    I10\<51\> (VBOT\<10\> VTOP) LB_CUNIT_X3
    I10\<50\> (VBOT\<10\> VTOP) LB_CUNIT_X3
    I10\<49\> (VBOT\<10\> VTOP) LB_CUNIT_X3
    I10\<48\> (VBOT\<10\> VTOP) LB_CUNIT_X3
    I10\<47\> (VBOT\<10\> VTOP) LB_CUNIT_X3
    I10\<46\> (VBOT\<10\> VTOP) LB_CUNIT_X3
    I10\<45\> (VBOT\<10\> VTOP) LB_CUNIT_X3
    I10\<44\> (VBOT\<10\> VTOP) LB_CUNIT_X3
    I10\<43\> (VBOT\<10\> VTOP) LB_CUNIT_X3
    I10\<42\> (VBOT\<10\> VTOP) LB_CUNIT_X3
    I10\<41\> (VBOT\<10\> VTOP) LB_CUNIT_X3
    I10\<40\> (VBOT\<10\> VTOP) LB_CUNIT_X3
    I10\<39\> (VBOT\<10\> VTOP) LB_CUNIT_X3
    I10\<38\> (VBOT\<10\> VTOP) LB_CUNIT_X3
    I10\<37\> (VBOT\<10\> VTOP) LB_CUNIT_X3
    I10\<36\> (VBOT\<10\> VTOP) LB_CUNIT_X3
    I10\<35\> (VBOT\<10\> VTOP) LB_CUNIT_X3
    I10\<34\> (VBOT\<10\> VTOP) LB_CUNIT_X3
    I10\<33\> (VBOT\<10\> VTOP) LB_CUNIT_X3
    I10\<32\> (VBOT\<10\> VTOP) LB_CUNIT_X3
    I10\<31\> (VBOT\<10\> VTOP) LB_CUNIT_X3
    I10\<30\> (VBOT\<10\> VTOP) LB_CUNIT_X3
    I10\<29\> (VBOT\<10\> VTOP) LB_CUNIT_X3
    I10\<28\> (VBOT\<10\> VTOP) LB_CUNIT_X3
    I10\<27\> (VBOT\<10\> VTOP) LB_CUNIT_X3
    I10\<26\> (VBOT\<10\> VTOP) LB_CUNIT_X3
    I10\<25\> (VBOT\<10\> VTOP) LB_CUNIT_X3
    I10\<24\> (VBOT\<10\> VTOP) LB_CUNIT_X3
    I10\<23\> (VBOT\<10\> VTOP) LB_CUNIT_X3
    I10\<22\> (VBOT\<10\> VTOP) LB_CUNIT_X3
    I10\<21\> (VBOT\<10\> VTOP) LB_CUNIT_X3
    I10\<20\> (VBOT\<10\> VTOP) LB_CUNIT_X3
    I10\<19\> (VBOT\<10\> VTOP) LB_CUNIT_X3
    I10\<18\> (VBOT\<10\> VTOP) LB_CUNIT_X3
    I10\<17\> (VBOT\<10\> VTOP) LB_CUNIT_X3
    I10\<16\> (VBOT\<10\> VTOP) LB_CUNIT_X3
    I10\<15\> (VBOT\<10\> VTOP) LB_CUNIT_X3
    I10\<14\> (VBOT\<10\> VTOP) LB_CUNIT_X3
    I10\<13\> (VBOT\<10\> VTOP) LB_CUNIT_X3
    I10\<12\> (VBOT\<10\> VTOP) LB_CUNIT_X3
    I10\<11\> (VBOT\<10\> VTOP) LB_CUNIT_X3
    I10\<10\> (VBOT\<10\> VTOP) LB_CUNIT_X3
    I10\<9\> (VBOT\<10\> VTOP) LB_CUNIT_X3
    I10\<8\> (VBOT\<10\> VTOP) LB_CUNIT_X3
    I10\<7\> (VBOT\<10\> VTOP) LB_CUNIT_X3
    I10\<6\> (VBOT\<10\> VTOP) LB_CUNIT_X3
    I10\<5\> (VBOT\<10\> VTOP) LB_CUNIT_X3
    I10\<4\> (VBOT\<10\> VTOP) LB_CUNIT_X3
    I10\<3\> (VBOT\<10\> VTOP) LB_CUNIT_X3
    I10\<2\> (VBOT\<10\> VTOP) LB_CUNIT_X3
    I10\<1\> (VBOT\<10\> VTOP) LB_CUNIT_X3
    I6\<7\> (VBOT\<6\> VTOP) LB_CUNIT_X3
    I6\<6\> (VBOT\<6\> VTOP) LB_CUNIT_X3
    I6\<5\> (VBOT\<6\> VTOP) LB_CUNIT_X3
    I6\<4\> (VBOT\<6\> VTOP) LB_CUNIT_X3
    I6\<3\> (VBOT\<6\> VTOP) LB_CUNIT_X3
    I6\<2\> (VBOT\<6\> VTOP) LB_CUNIT_X3
    I6\<1\> (VBOT\<6\> VTOP) LB_CUNIT_X3
    I8\<26\> (VBOT\<8\> VTOP) LB_CUNIT_X3
    I8\<25\> (VBOT\<8\> VTOP) LB_CUNIT_X3
    I8\<24\> (VBOT\<8\> VTOP) LB_CUNIT_X3
    I8\<23\> (VBOT\<8\> VTOP) LB_CUNIT_X3
    I8\<22\> (VBOT\<8\> VTOP) LB_CUNIT_X3
    I8\<21\> (VBOT\<8\> VTOP) LB_CUNIT_X3
    I8\<20\> (VBOT\<8\> VTOP) LB_CUNIT_X3
    I8\<19\> (VBOT\<8\> VTOP) LB_CUNIT_X3
    I8\<18\> (VBOT\<8\> VTOP) LB_CUNIT_X3
    I8\<17\> (VBOT\<8\> VTOP) LB_CUNIT_X3
    I8\<16\> (VBOT\<8\> VTOP) LB_CUNIT_X3
    I8\<15\> (VBOT\<8\> VTOP) LB_CUNIT_X3
    I8\<14\> (VBOT\<8\> VTOP) LB_CUNIT_X3
    I8\<13\> (VBOT\<8\> VTOP) LB_CUNIT_X3
    I8\<12\> (VBOT\<8\> VTOP) LB_CUNIT_X3
    I8\<11\> (VBOT\<8\> VTOP) LB_CUNIT_X3
    I8\<10\> (VBOT\<8\> VTOP) LB_CUNIT_X3
    I8\<9\> (VBOT\<8\> VTOP) LB_CUNIT_X3
    I8\<8\> (VBOT\<8\> VTOP) LB_CUNIT_X3
    I8\<7\> (VBOT\<8\> VTOP) LB_CUNIT_X3
    I8\<6\> (VBOT\<8\> VTOP) LB_CUNIT_X3
    I8\<5\> (VBOT\<8\> VTOP) LB_CUNIT_X3
    I8\<4\> (VBOT\<8\> VTOP) LB_CUNIT_X3
    I8\<3\> (VBOT\<8\> VTOP) LB_CUNIT_X3
    I8\<2\> (VBOT\<8\> VTOP) LB_CUNIT_X3
    I8\<1\> (VBOT\<8\> VTOP) LB_CUNIT_X3
    I7\<14\> (VBOT\<7\> VTOP) LB_CUNIT_X3
    I7\<13\> (VBOT\<7\> VTOP) LB_CUNIT_X3
    I7\<12\> (VBOT\<7\> VTOP) LB_CUNIT_X3
    I7\<11\> (VBOT\<7\> VTOP) LB_CUNIT_X3
    I7\<10\> (VBOT\<7\> VTOP) LB_CUNIT_X3
    I7\<9\> (VBOT\<7\> VTOP) LB_CUNIT_X3
    I7\<8\> (VBOT\<7\> VTOP) LB_CUNIT_X3
    I7\<7\> (VBOT\<7\> VTOP) LB_CUNIT_X3
    I7\<6\> (VBOT\<7\> VTOP) LB_CUNIT_X3
    I7\<5\> (VBOT\<7\> VTOP) LB_CUNIT_X3
    I7\<4\> (VBOT\<7\> VTOP) LB_CUNIT_X3
    I7\<3\> (VBOT\<7\> VTOP) LB_CUNIT_X3
    I7\<2\> (VBOT\<7\> VTOP) LB_CUNIT_X3
    I7\<1\> (VBOT\<7\> VTOP) LB_CUNIT_X3
    I12\<9\> (net2\<0\> VTOP) LB_CUNIT_X3
    I12\<8\> (net2\<1\> VTOP) LB_CUNIT_X3
    I12\<7\> (net2\<2\> VTOP) LB_CUNIT_X3
    I12\<6\> (net2\<3\> VTOP) LB_CUNIT_X3
    I12\<5\> (net2\<4\> VTOP) LB_CUNIT_X3
    I12\<4\> (net2\<5\> VTOP) LB_CUNIT_X3
    I12\<3\> (net2\<6\> VTOP) LB_CUNIT_X3
    I12\<2\> (net2\<7\> VTOP) LB_CUNIT_X3
    I12\<1\> (net2\<8\> VTOP) LB_CUNIT_X3
    I5\<4\> (VBOT\<5\> VTOP) LB_CUNIT_X3
    I5\<3\> (VBOT\<5\> VTOP) LB_CUNIT_X3
    I5\<2\> (VBOT\<5\> VTOP) LB_CUNIT_X3
    I5\<1\> (VBOT\<5\> VTOP) LB_CUNIT_X3
    I3 (VBOT\<3\> VTOP) LB_CUNIT_X3
    I4\<2\> (VBOT\<4\> VTOP) LB_CUNIT_X3
    I4\<1\> (VBOT\<4\> VTOP) LB_CUNIT_X3
ends L5_CAP_ARRAY
// End of subcircuit definition.
