** GENERATED by `analog-db export-raw` — DO NOT EDIT.
** circuit=cmfb_004_output_switched_cap  class=cmfb  pdk=ihp-sg13g2  testbench=tran_sc_cmfb_step  corner=tt
** Self-contained deck: testbench + bound params + lowered DUT (.subckt cmfb_004_output_switched_cap).
** PDK corner libs resolve by BARE NAME on the image's ngspice sourcepath — run in a
** PDK-enabled env (the base image / api container), NOT a bare host:
**   docker run --rm -i spicexplorer-spice-base:local \
**     bash -lc 'd=$(mktemp -d) && cat > $d/c.spice && cd $d && ngspice -b c.spice' < raw/cmfb_004_output_switched_cap/ihp-sg13g2/tran_sc_cmfb_step.spice
*----------------------------------------------------------*
** params: 6 free + 2 frozen knobs (sizing.yaml) · 44 tied · 0 ratio-derived (abstract/params.yaml) · 7 testbench params
** AUTHORED TEMPLATE — cmfb/tran_sc_cmfb_step (clocked switched-capacitor CMFB suite).
** The continuous-time class benches (dc_cmfb_transfer / ac_servo) are meaningless for
** an SC-CMFB — every sense path is capacitive, so the DC transfer is zero and the
** static AC transfer is just a cap divider. The WHOLE suite therefore runs in one
** clocked transient: two-phase EXACT-COMPLEMENT clocks (support-class rule — a
** non-overlap gap would half-turn-on the PMOS halves), a sensed-CM one-shot step,
** and AVG measurement windows spanning INTEGER clock periods (FIND-at-instant
** aliases the clock ripple).
**   vcmfb_nat     settled control output at zero CM error (pre-step AVG window
**                 WP0..WP1). For the classic SC-CMFB this is ~VBIAS by
**                 construction: steady state enforces vcmfb = cm(vin) - VCM +
**                 VBIAS — the actuator level is PROGRAMMED, not sized.
**   step_delta_v  settled plateau AVG (WA0..WA1) minus vcmfb_nat — SIGNED; the
**                 charge-redistribution transfer is ~ +VSTEP (slope ~ +1).
**   cmfb_slope    step_delta_v / VSTEP — the discrete-time transfer slope
**                 (time-domain stand-in for the dc_cmfb_transfer slope; canonical
**                 polarity = positive).
**   ring_v        (max-min)/2 of vcmfb over the settled plateau window: clock
**                 ripple + charge-injection/feedthrough residue — the SC-CMFB's
**                 native figure of demerit.
**   t_cm_settle   release-edge recovery: last |vcmfb - vend| = VTOL crossing minus
**                 TSTEP2 (vend = settled end AVG window WE0..WE1). VTOL must sit
**                 ABOVE the steady clock ripple or the crossing never lands.
**   i_supply      AVG vdd draw over the settled pre-step window (switching charge
**                 pulses + junction leakage — there is no static path).
** Settling physics: each sense phase shares the switched caps (2*C_sw) with the
** bound CL, closing ~2*C_sw/(2*C_sw+CL) of the remaining error per clock — place
** WP0/WA0/WE0 several clock periods after the preceding edge. TMAX must bound the
** internal step (TSTEP is only the print interval): at slow clocks the solver
** otherwise steps over the TG conduction intervals (TMAX ~ 200n proven).
** Assumes the SC-CMFB port order (this member's PORT_LINE):
**   .subckt <id> vinp vinn vcmfb vcm vbias clk_phi clk_phi_not vdd vss
** Required bindings: DUT PORT_LINE VDD VCM VBIAS CL FCLK TEDGE VSTEP TSTEP1 TSTEP2
**                    WP0 WP1 WA0 WA1 WE0 WE1 VTOL TSTEP TSTOP TMAX PDK_INCLUDE.
.lib cornerMOSlv.lib mos_tt
.temp 27

.param VDD=1.2
.param VCM=0.5
.param VBIAS=0.3
.param CL=50f
.param FCLK=1k
.param TCLK={1/FCLK}
.param TEDGE=50n

Vdd   vdd 0 dc {VDD}
Vss   vss 0 dc 0
Vcm   vcm 0 dc {VCM}
Vbias vbias 0 dc {VBIAS}
* two-phase clocks: EXACT complements, phi high first (refresh phase at t=0+)
Vphi  clk_phi     0 pulse(0 {VDD} 0 {TEDGE} {TEDGE} {TCLK/2-TEDGE} {TCLK})
Vphin clk_phi_not 0 pulse({VDD} 0 0 {TEDGE} {TEDGE} {TCLK/2-TEDGE} {TCLK})
* sensed-CM one-shot square step: VCM -> VCM+VSTEP during TSTEP1..TSTEP2
Vs   vs 0 dc {VCM} pulse({VCM} {0.5+50m} 10m 10n 10n {20m-10m} 1)
Vinp vinp vs dc 0
Vinn vinn vs dc 0
* actuator gate proxy — also the SC network's hold capacitance during refresh
CLoad vcmfb 0 {CL}

XDUT vinp vinn vcmfb vcm vbias clk_phi clk_phi_not vdd vss cmfb_004_output_switched_cap

.control
  set filetype=ascii
  tran 5u 30m 0 200n
  meas tran vnat_raw AVG v(vcmfb) FROM=6m TO=9m
  let vcmfb_nat = vnat_raw
  print vcmfb_nat
  meas tran von AVG v(vcmfb) FROM=15m TO=19m
  let step_delta_v = von - vnat_raw
  print step_delta_v
  let cmfb_slope = step_delta_v/50m
  print cmfb_slope
  meas tran von_max MAX v(vcmfb) FROM=15m TO=19m
  meas tran von_min MIN v(vcmfb) FROM=15m TO=19m
  let ring_v = (von_max - von_min)/2
  print ring_v
  meas tran vend_raw AVG v(vcmfb) FROM=27m TO=29m
  let verr = abs(v(vcmfb) - vend_raw)
  meas tran tcross WHEN verr=5m FALL=LAST
  let t_cm_settle = tcross - 20m
  print t_cm_settle
  meas tran isup_raw AVG i(Vdd) FROM=6m TO=9m
  let i_supply = -isup_raw
  print i_supply
  write
  quit
.endc
.param x_dut_xm1_w=0.15u
.param x_dut_xm1_l=0.13u
.param x_dut_xm2_w=0.15u
.param x_dut_xm2_l=0.13u
.param x_dut_c1_value=1p
.param x_dut_c2_value=1p
.param x_dut_xm1_m=1
.param x_dut_xm2_m=1
* ---- GENERATED parameter ties (abstract/params.yaml groups/ratios) ----
* Each tied symbol is defined exactly once, by its line below; rewrite that
* .param to untie just that symbol (untying = shadowing, plan D-3).
.param x_dut_xm3_w = {x_dut_xm1_w}
.param x_dut_xm5_w = {x_dut_xm1_w}
.param x_dut_xm7_w = {x_dut_xm1_w}
.param x_dut_xm9_w = {x_dut_xm1_w}
.param x_dut_xm11_w = {x_dut_xm1_w}
.param x_dut_xm13_w = {x_dut_xm1_w}
.param x_dut_xm15_w = {x_dut_xm1_w}
.param x_dut_xm3_l = {x_dut_xm1_l}
.param x_dut_xm5_l = {x_dut_xm1_l}
.param x_dut_xm7_l = {x_dut_xm1_l}
.param x_dut_xm9_l = {x_dut_xm1_l}
.param x_dut_xm11_l = {x_dut_xm1_l}
.param x_dut_xm13_l = {x_dut_xm1_l}
.param x_dut_xm15_l = {x_dut_xm1_l}
.param x_dut_xm3_m = {x_dut_xm1_m}
.param x_dut_xm5_m = {x_dut_xm1_m}
.param x_dut_xm7_m = {x_dut_xm1_m}
.param x_dut_xm9_m = {x_dut_xm1_m}
.param x_dut_xm11_m = {x_dut_xm1_m}
.param x_dut_xm13_m = {x_dut_xm1_m}
.param x_dut_xm15_m = {x_dut_xm1_m}
.param x_dut_xm4_w = {x_dut_xm2_w}
.param x_dut_xm6_w = {x_dut_xm2_w}
.param x_dut_xm8_w = {x_dut_xm2_w}
.param x_dut_xm10_w = {x_dut_xm2_w}
.param x_dut_xm12_w = {x_dut_xm2_w}
.param x_dut_xm14_w = {x_dut_xm2_w}
.param x_dut_xm16_w = {x_dut_xm2_w}
.param x_dut_xm4_l = {x_dut_xm2_l}
.param x_dut_xm6_l = {x_dut_xm2_l}
.param x_dut_xm8_l = {x_dut_xm2_l}
.param x_dut_xm10_l = {x_dut_xm2_l}
.param x_dut_xm12_l = {x_dut_xm2_l}
.param x_dut_xm14_l = {x_dut_xm2_l}
.param x_dut_xm16_l = {x_dut_xm2_l}
.param x_dut_xm4_m = {x_dut_xm2_m}
.param x_dut_xm6_m = {x_dut_xm2_m}
.param x_dut_xm8_m = {x_dut_xm2_m}
.param x_dut_xm10_m = {x_dut_xm2_m}
.param x_dut_xm12_m = {x_dut_xm2_m}
.param x_dut_xm14_m = {x_dut_xm2_m}
.param x_dut_xm16_m = {x_dut_xm2_m}
.param x_dut_c4_value = {x_dut_c2_value}
.param x_dut_c3_value = {x_dut_c1_value}
.subckt cmfb_004_output_switched_cap vinp vinn vcmfb vcm vbias clk_phi clk_phi_not vdd vss
C1 vbias vcm 'x_dut_c1_value'
C2 ctl_p sense_p 'x_dut_c2_value'
C3 vbias vcm 'x_dut_c3_value'
C4 ctl_n sense_n 'x_dut_c4_value'
XM1 vcm clk_phi sense_p vss sg13_lv_nmos l=x_dut_xm1_l m=x_dut_xm1_m w=x_dut_xm1_w
XM10 sense_n clk_phi_not vcm vdd sg13_lv_pmos l=x_dut_xm10_l m=x_dut_xm10_m w=x_dut_xm10_w
XM11 vbias clk_phi ctl_n vss sg13_lv_nmos l=x_dut_xm11_l m=x_dut_xm11_m w=x_dut_xm11_w
XM12 ctl_n clk_phi_not vbias vdd sg13_lv_pmos l=x_dut_xm12_l m=x_dut_xm12_m w=x_dut_xm12_w
XM13 sense_n clk_phi_not vinn vss sg13_lv_nmos l=x_dut_xm13_l m=x_dut_xm13_m w=x_dut_xm13_w
XM14 vinn clk_phi sense_n vdd sg13_lv_pmos l=x_dut_xm14_l m=x_dut_xm14_m w=x_dut_xm14_w
XM15 ctl_n clk_phi_not vcmfb vss sg13_lv_nmos l=x_dut_xm15_l m=x_dut_xm15_m w=x_dut_xm15_w
XM16 vcmfb clk_phi ctl_n vdd sg13_lv_pmos l=x_dut_xm16_l m=x_dut_xm16_m w=x_dut_xm16_w
XM2 sense_p clk_phi_not vcm vdd sg13_lv_pmos l=x_dut_xm2_l m=x_dut_xm2_m w=x_dut_xm2_w
XM3 vbias clk_phi ctl_p vss sg13_lv_nmos l=x_dut_xm3_l m=x_dut_xm3_m w=x_dut_xm3_w
XM4 ctl_p clk_phi_not vbias vdd sg13_lv_pmos l=x_dut_xm4_l m=x_dut_xm4_m w=x_dut_xm4_w
XM5 sense_p clk_phi_not vinp vss sg13_lv_nmos l=x_dut_xm5_l m=x_dut_xm5_m w=x_dut_xm5_w
XM6 vinp clk_phi sense_p vdd sg13_lv_pmos l=x_dut_xm6_l m=x_dut_xm6_m w=x_dut_xm6_w
XM7 ctl_p clk_phi_not vcmfb vss sg13_lv_nmos l=x_dut_xm7_l m=x_dut_xm7_m w=x_dut_xm7_w
XM8 vcmfb clk_phi ctl_p vdd sg13_lv_pmos l=x_dut_xm8_l m=x_dut_xm8_m w=x_dut_xm8_w
XM9 vcm clk_phi sense_n vss sg13_lv_nmos l=x_dut_xm9_l m=x_dut_xm9_m w=x_dut_xm9_w
.ends
.end
