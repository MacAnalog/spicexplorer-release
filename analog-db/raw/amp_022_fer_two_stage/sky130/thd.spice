** GENERATED by `analog-db export-raw` — DO NOT EDIT.
** circuit=amp_022_fer_two_stage  class=amplifier  pdk=sky130  testbench=thd  corner=tt
** Self-contained deck: testbench + bound params + lowered DUT (.subckt amp_022_fer_two_stage).
** PDK corner libs resolve by BARE NAME on the image's ngspice sourcepath — run in a
** PDK-enabled env (the base image / api container), NOT a bare host:
**   docker run --rm -i spicexplorer-spice-base:local \
**     bash -lc 'd=$(mktemp -d) && cat > $d/c.spice && cd $d && ngspice -b c.spice' < raw/amp_022_fer_two_stage/sky130/thd.spice
*----------------------------------------------------------*
** params: 10 free + 5 frozen knobs (sizing.yaml) · 12 tied · 4 ratio-derived (abstract/params.yaml) · 5 testbench params
** AUTHORED TEMPLATE — amplifier/thd: large-signal harmonic distortion in the unity buffer.
** A single sine at F0 (amplitude ASIG, offset VCM) drives the + input; the buffer output's
** harmonic content IS the DUT's distortion. THD is computed IN-DECK by a coherent single-bin
** DFT over harmonics 2..5 (control-script vector math) so the runner's measure parser picks it
** up directly.
**
** WHY IN-DECK: analog-db's runner reads measures OUT OF THE NGSPICE LOG ONLY — it has no route
** into the platform Tier-1 registry. A template that merely writes a raw therefore yields
** "no measures parsed" at EVERY sizing, which is what this bench used to do. The written raw
** stays available for the platform {meas: thd_pct, f0: F0} cross-check, and the Spectre lane
** upgrade is still a NATIVE pss at F0 (fd-PSF harmonics -> {meas: thd_pss_*}, HARMS); ngspice
** has no PSS, so tran + in-deck DFT is the engine-neutral default.
**
** ENDPOINT-DUPLICATION CORRECTION (the same one iip3.spice carries; this deck was missing it
** and was biased because of it). `linearize` returns np = nd+1 uniformly spaced points spanning
** the WHOLE window, so when the window is an integer number of F0 periods its LAST sample
** repeats its FIRST. ngspice's `mean()` then averages nd+1 samples of a record whose true
** period is nd, which adds ~vac[0]*cos(k*w*t0)/np to the real part of EVERY bin. The fix is
** iip3's: recover the sum with mean()*np, drop the duplicated sample, divide by nd —
**     re_k = (mean(vac*c_k)*np - vac[0]*c_k[0])/nd
** which makes the window exactly rectangular over one whole number of periods.
** What the bias cost, all measured on amp_022 @ ihp-sg13g2, shipped window/step:
**   - a4 and a5 were PURE ARTIFACT. Naive a4 = 1.199348e-6, a5 = 1.199820e-6 against
**     2*|vac[0]|/np = 1.190958e-6 — i.e. 1.007x the artifact level, no circuit content at all.
**     Corrected they are 8.882883e-8 and 9.163461e-9 (13x and 131x smaller). The tell is that
**     the naive pair tracked 1/N exactly under TSTEP (2.388e-6 / 1.199e-6 / 6.07e-7 / 3.16e-7
**     at 4n/2n/1n/0.5n) while the corrected pair is TSTEP-invariant (8.904e-8 / 8.883e-8 /
**     8.877e-8 / 8.875e-8).
**   - WINDOW-PHASE NULL TEST. Hold the window at exactly 16 periods and move ONLY the opening
**     phase (TSTART 4.000..4.875 us in 1/8-period steps): naive thd_pct swung 0.020280 ->
**     0.059904 % (2.95x) and a3 6.023e-7 -> 2.460e-5 (40.8x). Corrected, all eight phases give
**     thd_pct = 0.021014 % and a3 = 1.7128e-6..1.7131e-6 — a 1.000x spread. The DUT's
**     distortion cannot depend on where the window opens; the naive number did.
**   - TSTEP CONVERGENCE. Naive thd_pct = 0.022843 / 0.021805 / 0.021371 / 0.021176 % at
**     4n/2n/1n/0.5n — never converging, drifting as 1/N toward the corrected answer.
**     Corrected: 0.021036 / 0.021014 / 0.021005 / 0.021001 %, a 0.17 % total spread.
**   - CUBIC CROSS-CHECK. A memoryless cubic obeys IM3 = HD3 + 20log10(3) = HD3 + 9.54 dB at
**     matched per-tone drive. At ASIG = 0.1 the iip3 bench (already endpoint-corrected)
**     measures im3_dbc = -86.402 dBc. Corrected THD gives HD3 = -95.301 -> predicts -85.758,
**     an error of +0.64 dB. Naive THD gives HD3 = -104.378 -> predicts -94.835, off by
**     -8.43 dB. The corrected number is the one that agrees with an independent bench.
**
** WHICH CELLS THIS ACTUALLY MOVES: the artifact is a fixed ~1e-6 V floor, so it only matters
** where the real harmonics are near it. Corrected/naive thd_pct measured across the six
** re-run cells: amp_022@ihp 0.9637x (0.021805 -> 0.021014 %) and amp_001@ihp 1.0037x
** (0.129833 -> 0.130312 %), but amp_001@sky130 0.9999x (7.539 %), amp_022@sky130 1.0003x
** (12.537 %), amp_022@gf180 1.0007x (1.735 %) and amp_001@gf180 0.9986x (10.871 %). The
** high-distortion readings were already dominated by real circuit distortion and barely move;
** the fix matters exactly where this bench is used to certify LOW distortion, and there it
** also fixes the individual harmonics (amp_022@ihp a3 6.023e-7 -> 1.713e-6, a 2.84x change,
** with a4/a5 collapsing 13x/131x) even where thd_pct moves only a few percent.
**
** DC PEDESTAL — subsumed by the correction, kept only for legibility. v(vout) rides on the VCM
** operating point, so `vac = vo - vout_op` is still computed here, but under the endpoint
** correction it changes NOTHING: for every k >= 1 the corrected sum runs over exactly nd
** samples of a period-nd record, where sum(cos(2*pi*k*i/nd)) = sum(sin(...)) = 0 EXACTLY, so an
** additive constant is annihilated identically. Measured: DFT-on-vo versus DFT-on-(vo-vout_op)
** are BIT-IDENTICAL in a1..a5 and thd_pct on amp_022@ihp (0.021 %), amp_001@ihp (0.130 %),
** amp_001@sky130 (7.54 %) and amp_022@gf180 (1.74 %) — four cells spanning 2.5 decades of THD.
** A PRIOR VERSION OF THIS HEADER CLAIMED the pedestal was the dominant error ("0.293 % vs
** 0.022 %, a 13x inflation, matching 2*VCM/(N+1)"). That is WRONG and must not be reinstated:
** the naive estimator leaks a constant only because summing np = nd+1 samples leaves the
** duplicated endpoint's cos = +1 uncancelled — the leak WAS the endpoint artifact, not DC.
**
** COHERENCE + SETTLING REQUIREMENT: recording starts at TSTART (the tran third argument) so the
** startup transient is DISCARDED — with TSTART=0 the startup edge sits inside the DFT window
** and corrupts the bins. The WINDOW LENGTH (TSTOP-TSTART) MUST be an integer number of F0
** periods; a half-period mismatch is fatal to the CORRECTED estimator too — re-measured after
** this fix, TSTOP 20u -> 20.5u at F0 = 1 MHz takes amp_022@ihp from 0.021014 % to 1.331435 %
** (63.4x) and amp_001@ihp from 0.130312 % to 1.214108 % (9.3x). The endpoint correction assumes
** the last sample duplicates the first; a fractional window breaks that assumption, so DO NOT
** read it as a licence to relax the window. TSTART itself need NOT land on a period boundary
** once the correction is in — see the window-phase null test above, where eight sub-period
** openings agreed to 5 digits. >= 8 measured periods recommended, and TSTEP <= 1/(200*F0).
**
** NUMERICAL FLOOR: applied to the ideal source v(vinp) on the shipped grid this DFT returns
** a2/a1 = 7.3e-12, i.e. a THD floor ~7.3e-10 %. NOTE that v(vinp) is NOT a valid probe for the
** endpoint bias and must not be used as one: at TSTART = 4 us the source sits essentially ON its
** zero crossing (its own naive floor, 3.89e-12 V, back-solves 2*|vac[0]|/np to |vac[0]| ~ 16 nV),
** so on v(vinp) the artifact is ~0 BY CONSTRUCTION. That is why an earlier "floor ~5e-9 %"
** reading there — itself nothing but that same 3.89e-12 V artifact, five decades down — could
** not see a bias that was 1.19e-6 V on the DUT output, where the buffer's phase lag puts
** vac[0] at 4.76 mV. In practice the corrected estimator is limited not by round-off but by the
** record's residual non-periodicity: |vout[np-1] - vout[0]| = 1.34e-7 V on amp_022@ihp, i.e.
** 1.3e-6 of the 0.1 V tone.
**
** `fourier` DROPPED (it used to sit here): it prints a table, never a `name = value` line, so
** it contributed no measure — and after `linearize` the current plot no longer holds v(vout),
** so it silently emits nothing at all. thd_pct/thd_db below replace it.
** `write` runs BEFORE `linearize` on purpose: `linearize` makes a NEW plot holding only the
** scratch vectors, so writing after it shrinks the raw from every circuit node (405 vectors)
** to 23 and loses v(vout) — which would break the platform cross-check named above. It also
** means the c1..s5 DFT basis vectors created below never reach the raw, so unlike iip3.spice
** this deck needs no `unlet` before `write`.
**
** DEAD-OUTPUT GUARD (2026-07-31). The old deck guarded NOTHING: it floored a1 with 1e-18 and
** otherwise relied on the runner, whose only rejection is a NaN. That is not enough, because a
** dead node here is not dead — it is capacitively fed. This deck's `vout` node exists whether or
** not the DUT has a `vout` PORT: `XDUT vdd vout vinp vinn ibias vss` wires the DUT by its OWN port list, so on a
** fully-differential member (voutp/voutn, no vout) node `vout` carries only CLoad and the Vfb
** feedback probe and is driven purely by coupling out of the DUT's vinn pin. It then returns a
** small but perfectly finite a1 and a plausible thd_pct — numbers from nothing. Measured before
** this guard, with IBIAS supplied: amp_023_fer_fd2s@ihp reported thd_pct = 5.372 % off
** a1 = 2.092 mV, amp_027_fan_rrl_ota@ihp 3.537 % and amp_020_two_stage_miller_cmfb@ihp 11.715 %,
** all `status: ok`.
** The guard is a MEASURED gain, not a NaN check: the SAME F0 bin is also taken on the drive
** v(vinp) (a1_in), and gain_tone = a1/a1_in must clear 0.5 V/V. Referencing the measured drive
** rather than the 0.1 binding makes it immune to a mis-bound or mis-parsed stimulus — on the
** shipped binding a1_in comes back 0.09999841 against ASIG = 0.1, so the two agree to 1.6e-5 and
** a disagreement means the source is wrong. On a fail thd_pct becomes the loud 999 sentinel
** (thd_db 19.99) — NOT NaN, which would make the runner discard the whole analysis, and in the
** BAD direction for `thd_pct`'s registry intent (goal: minimize).
**
** WHY THE THRESHOLD IS 0.5 (and NOT ia/thd_diff.spice's 0.1). This is a UNITY buffer: the ideal
** gain_tone is 1, so dead-node feedthrough sits only ~1 decade down, not the ~3 that an IA's
** 20 V/V closed-loop gain buys. Measured on this bench at the shipped 100 mV / 1 MHz over the
** whole amplifier corpus (80 cell x PDK pairs, unit-correct bias conditions, 78 of which
** simulate — amp_017_tan_clia@sky130 and amp_018_telescopic_cascode@sky130 never do):
**   - 13 fully-differential pairs (structurally dead — no `vout` port) read gain_tone
**     0.000286 .. 0.1748, the top of that range being amp_025_hsu_classab_ota@ihp.
**   - the 65 single-ended pairs that simulate read 0.000409 .. 1.388, with a natural gap
**     between 0.105 and 0.187.
** 0.5 is the PHYSICAL line rather than a fitted one: gain_tone = A/(1+A), so 0.5 is exactly
** |A| = 1 — below it the loop has less than unity gain at F0 and the deck is not a buffer, so
** whatever harmonics it produces are not a closed-loop buffer THD. Re-running the corpus with
** the guard live: all 13/13 dead cells now return 999; 19 single-ended cells trip (all with
** gain_tone <= 0.4666, i.e. attenuating >= 6.6 dB — the lowest PASSING cell is 0.5110, so the
** threshold falls in a gap, not through a cluster); the remaining 46 pass (2 more never
** simulate at all on any threshold) and every one of the 46 returns a thd_pct BIT-IDENTICAL to
** its pre-guard value. Both shipped consumers pass on all
** three open PDKs (amp_001_5t 0.849/0.938/0.975, amp_022_fer_two_stage 0.934/0.998/0.997).
** THE GUARD IS A SCREEN, NOT A PROOF. The worst dead cell measured sits only 2.9x under the
** threshold here, and on the iip3 bench at ITS shipped 6.25 mV tones the populations actually
** cross: amp_031_srmc_core_cmfb@ihp (dead) feeds through at 0.4136 while amp_017_tan_clia@gf180
** (LIVE, single-ended) reads 0.4354 — a live cell ABOVE the worst dead one, so no ratio
** threshold separates them in general. The structural fix for a differential DUT is a
** differential template (the ia class has thd_diff), not a number here.
**
** Measures: a1 a2 a3 a4 a5 (harmonic amplitudes, V), a1_in (measured drive), gain_tone,
** thd_pct, thd_db, vout_op (the measured output operating point — a buffer sanity read).
** a4/a5 are printed because they are the endpoint artifact's tell-tale: if either creeps back up
** to 2*|vac[0]|/np, the window or the correction is broken. None of a1..a5 / a1_in / gain_tone /
** vout_op is in raw_project._SPEC_REGISTRY, so they stay recorded diagnostics and score nothing.
** Two names are deliberate: `vout_op`, NOT `vout_dc`, and `gain_tone`, NOT `gain_cl` — both of
** the alternatives ARE in the registry, so printing them would silently add objectives
** (`vout_dc exact 1.2 V +/-0.02`, a target neither consumer's VCM of 0.6/0.8 V can meet) to any
** optimizer project exported from this deck.
** Bindings: DUT PORT_LINE VDD VCM IBIAS CL ASIG F0 TSTEP TSTART TSTOP PDK_INCLUDE.
.lib sky130.lib.spice tt
.temp 27

.param VDD=1.8
.param VCM=0.6
.param IBIAS=20u
.param CL=10p
.param ASIG=0.1

Vdd  vdd 0 dc {VDD}
Vss  vss 0 dc 0
Ibias vdd ibias dc {IBIAS}
CLoad vout 0 {CL}

* unity buffer; the sine offset VCM doubles as the DC operating point
Vinp vinp 0 sin({VCM} {ASIG} 1.0e6)
Vfb  vinn vout dc 0

XDUT vdd vout vinp vinn ibias vss amp_022_fer_two_stage

.control
  set filetype=ascii
  tran 2n 20u 4u
  * raw first — see the header; linearize below switches the current plot
  write
  let vo = v(vout)
  let vi = v(vinp)
  linearize vo vi
  let t = time
* --- endpoint-duplication correction (see the header): `linearize` hands back np = nd+1
* --- points whose last sample repeats the first, so mean() averages one sample too many.
* --- mean()*np recovers the sum, subtracting vac[0]*c_k[0] drops the duplicate, /nd gives
* --- the true rectangular-window average over one whole number of periods.
  let np = length(vo)
  let nd = np - 1
  let vout_op = (mean(vo)*np - vo[0])/nd
  * the pedestal subtraction is exactly cancelled by the correction above (measured
  * bit-identical); kept because vout_op is reported anyway and `vac` reads clearer
  let vac = vo - vout_op
  let vin_ac = vi - mean(vi)
  let w = 2*pi*1.0e6
  let c1 = cos(w*t)
  let s1 = sin(w*t)
  let re1 = (mean(vac*c1)*np - vac[0]*c1[0])/nd
  let im1 = (mean(vac*s1)*np - vac[0]*s1[0])/nd
  let a1 = 2*sqrt(re1^2+im1^2)
* --- the SAME bin taken on the DRIVE v(vinp) — the reference for the dead-output guard ---
  let rei = (mean(vin_ac*c1)*np - vin_ac[0]*c1[0])/nd
  let imi = (mean(vin_ac*s1)*np - vin_ac[0]*s1[0])/nd
  let a1_in = 2*sqrt(rei^2+imi^2)
  let c2 = cos(2*w*t)
  let s2 = sin(2*w*t)
  let re2 = (mean(vac*c2)*np - vac[0]*c2[0])/nd
  let im2 = (mean(vac*s2)*np - vac[0]*s2[0])/nd
  let a2 = 2*sqrt(re2^2+im2^2)
  let c3 = cos(3*w*t)
  let s3 = sin(3*w*t)
  let re3 = (mean(vac*c3)*np - vac[0]*c3[0])/nd
  let im3 = (mean(vac*s3)*np - vac[0]*s3[0])/nd
  let a3 = 2*sqrt(re3^2+im3^2)
  let c4 = cos(4*w*t)
  let s4 = sin(4*w*t)
  let re4 = (mean(vac*c4)*np - vac[0]*c4[0])/nd
  let im4 = (mean(vac*s4)*np - vac[0]*s4[0])/nd
  let a4 = 2*sqrt(re4^2+im4^2)
  let c5 = cos(5*w*t)
  let s5 = sin(5*w*t)
  let re5 = (mean(vac*c5)*np - vac[0]*c5[0])/nd
  let im5 = (mean(vac*s5)*np - vac[0]*s5[0])/nd
  let a5 = 2*sqrt(re5^2+im5^2)
* --- DEAD-OUTPUT GUARD (see the header): a MEASURED gain, not a NaN check. Do NOT write
* --- `>` inside a `let` — the control preprocessor strips it as an output redirection and
* --- silently truncates the RHS. Masks use `<=`, inverted with 1 - mask.
  let gain_tone = a1/(a1_in + 1e-18)
  let dead = (gain_tone <= 0.5)
  let live = 1 - dead
  * the 1e-18 floors keep a dead output (a1 == 0) from emitting inf/NaN, which makes the runner
  * throw away the WHOLE analysis; they sit 12+ decades below any real amplitude
  let thd_raw = 100*sqrt(a2^2+a3^2+a4^2+a5^2)/(a1+1e-18)
  let thd_pct = live*thd_raw + dead*999
  let thd_db = 20*log10(thd_pct/100 + 1e-18)
  print a1 a2 a3 a4 a5 a1_in gain_tone thd_pct thd_db vout_op
  quit
.endc
.param x_dut_xmbd_w=4
.param x_dut_xm7_w=8
.param x_dut_xm0_w=8
.param x_dut_xm3_w=6
.param x_dut_xm7_l=0.4
.param x_dut_xm0_l=0.4
.param x_dut_xm3_l=0.4
.param x_dut_xm2_l=0.4
.param x_dut_xmbd_l=0.4
.param x_dut_cc_value=2e-12
.param x_dut_xm0_m=5
.param x_dut_xm3_m=2
.param x_dut_xm2_m=24
.param x_dut_xm7_m=3
.param x_dut_xmbd_m=1
* ---- GENERATED parameter ties (abstract/params.yaml groups/ratios) ----
* Each tied symbol is defined exactly once, by its line below; rewrite that
* .param to untie just that symbol (untying = shadowing, plan D-3).
.param x_dut_xm1_w = {x_dut_xm0_w}
.param x_dut_xm1_l = {x_dut_xm0_l}
.param x_dut_xm1_m = {x_dut_xm0_m}
.param x_dut_xm4_w = {x_dut_xm3_w}
.param x_dut_xm4_l = {x_dut_xm3_l}
.param x_dut_xm2_w = {x_dut_xm3_w}
.param x_dut_xm5_w = {x_dut_xm7_w}
.param x_dut_xm6_w = {x_dut_xm7_w}
.param x_dut_xm5_l = {x_dut_xm7_l}
.param x_dut_xm6_l = {x_dut_xm7_l}
.param x_dut_xmbs_w = {x_dut_xmbd_w}
.param x_dut_xmbs_l = {x_dut_xmbd_l}
.param x_dut_xm4_m = {x_dut_xm3_m*1}
.param x_dut_xm5_m = {x_dut_xm7_m*1}
.param x_dut_xm6_m = {x_dut_xm7_m*17/3}
.param x_dut_xmbs_m = {x_dut_xmbd_m*1}
.subckt amp_022_fer_two_stage vdd vout vinp vinn ibias vss
CC b vout x_dut_cc_value
XM0 a vinn c vdd sky130_fd_pr__pfet_01v8 l=x_dut_xm0_l m=x_dut_xm0_m w=x_dut_xm0_w
XM1 b vinp c vdd sky130_fd_pr__pfet_01v8 l=x_dut_xm1_l m=x_dut_xm1_m w=x_dut_xm1_w
XM2 vout b vss vss sky130_fd_pr__nfet_01v8 l=x_dut_xm2_l m=x_dut_xm2_m w=x_dut_xm2_w
XM3 a a vss vss sky130_fd_pr__nfet_01v8 l=x_dut_xm3_l m=x_dut_xm3_m w=x_dut_xm3_w
XM4 b a vss vss sky130_fd_pr__nfet_01v8 l=x_dut_xm4_l m=x_dut_xm4_m w=x_dut_xm4_w
XM5 c pbias vdd vdd sky130_fd_pr__pfet_01v8 l=x_dut_xm5_l m=x_dut_xm5_m w=x_dut_xm5_w
XM6 vout pbias vdd vdd sky130_fd_pr__pfet_01v8 l=x_dut_xm6_l m=x_dut_xm6_m w=x_dut_xm6_w
XM7 pbias pbias vdd vdd sky130_fd_pr__pfet_01v8 l=x_dut_xm7_l m=x_dut_xm7_m w=x_dut_xm7_w
XMBD ibias ibias vss vss sky130_fd_pr__nfet_01v8 l=x_dut_xmbd_l m=x_dut_xmbd_m w=x_dut_xmbd_w
XMBS pbias ibias vss vss sky130_fd_pr__nfet_01v8 l=x_dut_xmbs_l m=x_dut_xmbs_m w=x_dut_xmbs_w
.ends
.end
