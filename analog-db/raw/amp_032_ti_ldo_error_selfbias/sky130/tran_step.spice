** GENERATED by `analog-db export-raw` — DO NOT EDIT.
** circuit=amp_032_ti_ldo_error_selfbias  class=amplifier  pdk=sky130  testbench=tran_step  corner=tt
** Self-contained deck: testbench + bound params + lowered DUT (.subckt amp_032_ti_ldo_error_selfbias).
** PDK corner libs resolve by BARE NAME on the image's ngspice sourcepath — run in a
** PDK-enabled env (the base image / api container), NOT a bare host:
**   docker run --rm -i spicexplorer-spice-base:local \
**     bash -lc 'd=$(mktemp -d) && cat > $d/c.spice && cd $d && ngspice -b c.spice' < raw/amp_032_ti_ldo_error_selfbias/sky130/tran_step.spice
*----------------------------------------------------------*
** params: 18 free + 0 frozen knobs (sizing.yaml) · 9 tied · 0 ratio-derived (abstract/params.yaml) · 4 testbench params
** AUTHORED TEMPLATE — amplifier/tran_step_biaswrap: unity-gain step settling for DUTs on the
** AnalogGym self-bias convention (ports vss vdd vinn vinp vout; NO ibias port). Single-ended
** companion of tran_step_diff (M4 follow-up). Unlike the AC/noise bias-wraps — which AC-open the
** loop with Lfb/Cin — a settling measurement WANTS the real closed loop: wire the inverting input
** directly to the output (unity-gain follower) and step the non-inverting input. Settle to the
** FINAL output value, not the input step, so a systematic offset can't hold a fixed-tolerance band
** open forever (see universal/tran_step for the rationale). These are compensated multistage OTAs,
** designed stable in unity feedback.
**
** Assumes the AnalogGym canonical DUT port order (self-biased; NO ibias port):
**   .subckt <id> vss vdd vinn vinp vout
** Bindings: DUT VDD VCM CL VSTEP TSTART TSTEP TSTOP VTOL PDK_INCLUDE.
** FIXED 2026-07-20: this template used to hardcode `X1 0 vdd opout_dc opin opout amp_032_ti_ldo_error_selfbias`,
** which silently assumed the AnalogGym port order [vss vdd vinn vinp vout] and MIS-WIRED any
** DUT declaring a different order (e.g. the amplifier-class [vdd vout vinp vinn vss] swaps
** vdd<->vss). It now uses XDUT vdd vout vinp vinn vss with canonical node names, exactly like the
** *_biaswrap_ibias sibling. For the AnalogGym DUTs this is a no-op: their vss port binds to
** node `vss`, which `Vss vss 0 dc 0` ties to ground just as the old direct-to-0 wiring did.
.lib sky130.lib.spice tt
.temp 27

.param VDD=1.8
.param VCM=0.9
.param CL=10p
.param VSTEP=0.1

Vdd  vdd 0 dc {VDD}
Vss  vss 0 dc 0
CLoad vout 0 {CL}
Vinp vinp 0 dc {VCM} pulse({VCM} {VCM+VSTEP} 1u 1n 1n 1 1)
Vfb  vinn vout dc 0          ; unity-gain feedback wire (vinn <- vout; 0 V source = ideal wire)

XDUT vdd vout vinp vinn vss amp_032_ti_ldo_error_selfbias
.control
  set filetype=ascii
  tran 1n 2u
  * settle to the FINAL value, not the input step — a follower's systematic offset would
  * otherwise keep |vout - vfinal| outside a tight tolerance band forever.
  meas tran vfinal FIND v(vout) AT=2u
  let verr = abs(v(vout) - vfinal)
  meas tran tcross WHEN verr=1m FALL=LAST
  let t_settle = tcross - 1u
  print t_settle
  write
  quit
.endc
.param x_dut_xmbp_w=41.49398303677232
.param x_dut_xmbp_l=2.329224498945873
.param x_dut_xmb0_w=58.50180313844321
.param x_dut_xmb0_l=1.482196715977639
.param x_dut_xmbc_m=1
.param x_dut_xmbo_m=1
.param x_dut_xm1_w=54.99700606429666
.param x_dut_xm1_l=0.47938582647537475
.param x_dut_xm3_w=87.01219712226481
.param x_dut_xm3_l=3.4338542074883858
.param x_dut_xm4_w=96.52927518861148
.param x_dut_xm4_l=4.243509159874362
.param x_dut_xm6_w=22.347200240809872
.param x_dut_xm6_l=1.08924987055143
.param r_z=30158.889051230384
.param c_comp=1.0277210259907484e-11
.param x_dut_xmbf_w=9.512915640352748
.param r_nd=7561703.647450356
* ---- GENERATED parameter ties (abstract/params.yaml groups/ratios) ----
* Each tied symbol is defined exactly once, by its line below; rewrite that
* .param to untie just that symbol (untying = shadowing, plan D-3).
.param x_dut_xmbc_l = {x_dut_xmb0_l}
.param x_dut_xmbf_l = {x_dut_xmb0_l}
.param x_dut_xmbo_l = {x_dut_xmb0_l}
.param x_dut_xmbc_w = {x_dut_xmb0_w}
.param x_dut_xmbo_w = {x_dut_xmb0_w}
.param x_dut_xm2_w = {x_dut_xm1_w}
.param x_dut_xm2_l = {x_dut_xm1_l}
.param x_dut_xm5_w = {x_dut_xm3_w}
.param x_dut_xm5_l = {x_dut_xm3_l}
.subckt amp_032_ti_ldo_error_selfbias vdd vout vinp vinn vss
CC ncz vout 'c_comp'
RND na nd 'r_nd'
RZ nb ncz 'r_z'
XM1 na vinn tail vss sky130_fd_pr__nfet_01v8 l=x_dut_xm1_l w=x_dut_xm1_w
XM2 nb vinp tail vss sky130_fd_pr__nfet_01v8 l=x_dut_xm2_l w=x_dut_xm2_w
XM3 na nd vdd vdd sky130_fd_pr__pfet_01v8 l=x_dut_xm3_l w=x_dut_xm3_w
XM4 nlev na nd vdd sky130_fd_pr__pfet_01v8 l=x_dut_xm4_l w=x_dut_xm4_w
XM5 nb nd vdd vdd sky130_fd_pr__pfet_01v8 l=x_dut_xm5_l w=x_dut_xm5_w
XM6 vout nb vdd vdd sky130_fd_pr__pfet_01v8 l=x_dut_xm6_l w=x_dut_xm6_w
XMB0 ibias ibias vss vss sky130_fd_pr__nfet_01v8 l=x_dut_xmb0_l w=x_dut_xmb0_w
XMBC tail ibias vss vss sky130_fd_pr__nfet_01v8 l=x_dut_xmbc_l m=x_dut_xmbc_m w=x_dut_xmbc_w
XMBF nlev ibias vss vss sky130_fd_pr__nfet_01v8 l=x_dut_xmbf_l w=x_dut_xmbf_w
XMBO vout ibias vss vss sky130_fd_pr__nfet_01v8 l=x_dut_xmbo_l m=x_dut_xmbo_m w=x_dut_xmbo_w
XMBP ibias ibias vdd vdd sky130_fd_pr__pfet_01v8 l=x_dut_xmbp_l w=x_dut_xmbp_w
.ends
.end
