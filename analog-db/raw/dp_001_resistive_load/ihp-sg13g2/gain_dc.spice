** GENERATED by `analog-db export-raw` — DO NOT EDIT.
** circuit=dp_001_resistive_load  class=diff_pair  pdk=ihp-sg13g2  testbench=gain_dc  corner=tt
** Self-contained deck: testbench + bound params + lowered DUT (.subckt dp_001_resistive_load).
** PDK corner libs resolve by BARE NAME on the image's ngspice sourcepath — run in a
** PDK-enabled env (the base image / api container), NOT a bare host:
**   docker run --rm -i spicexplorer-spice-base:local \
**     bash -lc 'd=$(mktemp -d) && cat > $d/c.spice && cd $d && ngspice -b c.spice' < raw/dp_001_resistive_load/ihp-sg13g2/gain_dc.spice
*----------------------------------------------------------*
** params: 7 free + 3 frozen knobs (sizing.yaml) · 4 tied · 0 ratio-derived (abstract/params.yaml) · 3 testbench params
** AUTHORED TEMPLATE — diff_pair/gain_dc (plan D-4): differential DC gain of a differential pair.
** Sweeps the differential input vid about the common-mode (vinp = vcm + vid/2, vinn = vcm - vid/2
** via VCVSs) and extracts the small-signal differential gain d(voutp-voutn)/d(vid) from a two-point
** slope across vid=0. Bindings: DUT PORT_LINE VDD VCM IBIAS, VID_LO VID_HI VID_STEP, PDK_INCLUDE.
.lib cornerMOSlv.lib mos_tt
.temp 27

.param VDD=1.5
.param VCM=0.75
.param IBIAS=20u

Vdd   vdd 0 dc {VDD}
Vss   vss 0 dc 0
Ibias vdd ibias dc {IBIAS}
Vcm   vcm 0 dc {VCM}
Vid   vid 0 dc 0
Einp  vinp vcm vid 0 0.5
Einn  vinn vcm vid 0 -0.5

XDUT vdd voutp voutn vinp vinn ibias vss dp_001_resistive_load

.control
  set filetype=ascii
  dc Vid -0.05 0.05 0.002
  let vdiff = v(voutp) - v(voutn)
  meas dc vd_lo FIND vdiff AT=-0.01
  meas dc vd_hi FIND vdiff AT=0.01
  * magnitude of the differential gain (the pair is inverting in the p-minus-n convention)
  let gain_dc = abs((vd_hi - vd_lo) / 0.02)
  print gain_dc
  write
  quit
.endc
.param x_dut_xmp_w=12u
.param x_dut_xmp_l=0.3u
.param x_dut_rp_value=22000
.param x_dut_xmt_w=24u
.param x_dut_xmr_l=0.3u
.param x_dut_xmt_m=1
.param x_dut_xmr_w=24u
.param x_dut_xmp_m=1
.param x_dut_xmn_m=1
.param x_dut_xmr_m=1
* ---- GENERATED parameter ties (abstract/params.yaml groups/ratios) ----
* Each tied symbol is defined exactly once, by its line below; rewrite that
* .param to untie just that symbol (untying = shadowing, plan D-3).
.param x_dut_xmn_w = {x_dut_xmp_w}
.param x_dut_xmn_l = {x_dut_xmp_l}
.param x_dut_xmt_l = {x_dut_xmr_l}
.param x_dut_rn_value = {x_dut_rp_value}
.subckt dp_001_resistive_load vdd voutp voutn vinp vinn ibias vss
RN vdd voutn x_dut_rn_value
RP vdd voutp x_dut_rp_value
XMN voutn vinn tail vss sg13_lv_nmos l=x_dut_xmn_l m=x_dut_xmn_m w=x_dut_xmn_w
XMP voutp vinp tail vss sg13_lv_nmos l=x_dut_xmp_l m=x_dut_xmp_m w=x_dut_xmp_w
XMR ibias ibias vss vss sg13_lv_nmos l=x_dut_xmr_l m=x_dut_xmr_m w=x_dut_xmr_w
XMT tail ibias vss vss sg13_lv_nmos l=x_dut_xmt_l m=x_dut_xmt_m w=x_dut_xmt_w
.ends
.end
