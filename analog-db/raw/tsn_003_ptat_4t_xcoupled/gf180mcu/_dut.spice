** GENERATED by `analog-db export-raw` — DO NOT EDIT.
** Standalone lowered DUT subckt for tsn_003_ptat_4t_xcoupled on gf180mcu (sizing .param defaults + .subckt).
** Not a runnable deck on its own — include it under your own testbench:
**   .include _dut.spice
**   XDUT vdd vout vss tsn_003_ptat_4t_xcoupled
** Source: pdk/gf180mcu/netlist.spice (run `analog-db generate` to refresh).
*----------------------------------------------------------*
** params: 5 free + 4 frozen knobs (sizing.yaml) · 3 tied · 0 ratio-derived (abstract/params.yaml)
.param x_dut_xm1_w=1u
.param x_dut_xm0_w=4u
.param x_dut_xm1_l=3u
.param x_dut_xm3_w=2u
.param x_dut_xm3_l=3u
.param x_dut_xm1_m=1
.param x_dut_xm0_m=1
.param x_dut_xm3_m=1
.param x_dut_xm4_m=1
* ---- GENERATED parameter ties (abstract/params.yaml groups/ratios) ----
* Each tied symbol is defined exactly once, by its line below; rewrite that
* .param to untie just that symbol (untying = shadowing, plan D-3).
.param x_dut_xm0_l = {x_dut_xm1_l}
.param x_dut_xm4_w = {x_dut_xm3_w}
.param x_dut_xm4_l = {x_dut_xm3_l}
.subckt tsn_003_ptat_4t_xcoupled vdd vout vss
XM0 vout na vss vss nfet_03v3 l=x_dut_xm0_l m=x_dut_xm0_m w=x_dut_xm0_w
XM1 na na vss vss nfet_03v3 l=x_dut_xm1_l m=x_dut_xm1_m w=x_dut_xm1_w
XM3 vout vout vdd vdd pfet_03v3 l=x_dut_xm3_l m=x_dut_xm3_m w=x_dut_xm3_w
XM4 na vout vdd vdd pfet_03v3 l=x_dut_xm4_l m=x_dut_xm4_m w=x_dut_xm4_w
.ends
