** GENERATED by `analog-db export-raw` — DO NOT EDIT.
** circuit=amp_018_telescopic_cascode  class=amplifier  pdk=sky130  testbench=psrr_vdd  corner=tt
** Self-contained deck: testbench + bound params + lowered DUT (.subckt amp_018_telescopic_cascode).
** PDK corner libs resolve by BARE NAME on the image's ngspice sourcepath — run in a
** PDK-enabled env (the base image / api container), NOT a bare host:
**   docker run --rm -i spicexplorer-spice-base:local \
**     bash -lc 'd=$(mktemp -d) && cat > $d/c.spice && cd $d && ngspice -b c.spice' < raw/amp_018_telescopic_cascode/sky130/psrr_vdd.spice
*----------------------------------------------------------*
** params: 15 free + 10 frozen knobs (sizing.yaml) · 8 tied · 0 ratio-derived (abstract/params.yaml) · 4 testbench params
** AUTHORED TEMPLATE — amplifier/psrr_vdd (plan D-4/D-5): positive-supply rejection.
** The DUT is closed in a unity-gain buffer (vinn shorted to vout, vinp held at VCM with NO ac), and
** the supply Vdd carries a 1 V AC ripple. With the signal input quiet, every AC volt at vout is
** supply feed-through, so PSRR+ = -20·log10|vout/vdd| = -vdb(vout) (vdd ac = 1). Reported at FSTART
** (the DC-band floor). This is the buffer-application PSRR — the meaningful number for the
** voltage-buffer OTAs whose datasheet is closed-loop (gain_cl/bw_cl); sim-validated on the 5T
** (ihp≈29.7, sky130≈26.8, gf180≈53.5 dB — tracks the loop gain, as expected).
** Bindings: DUT PORT_LINE VDD VCM IBIAS CL FSTART FSTOP PPD PDK_INCLUDE.
.lib sky130.lib.spice tt
.temp 27

.param VDD=1.5
.param VCM=0.8
.param IBIAS=5u
.param CL=50f

Vdd  vdd 0 dc {VDD} ac 1     ; 1 V supply-ripple stimulus
Vss  vss 0 dc 0
Ibias vdd ibias dc {IBIAS}
CLoad vout 0 {CL}

Vinp vinp 0 dc {VCM}         ; signal input held quiet (no ac) — isolate the supply path
Vfb  vinn vout dc 0          ; unity-gain buffer: vinn shorted to vout

XDUT vdd vout vinp vinn ibias vss amp_018_telescopic_cascode

.control
  set filetype=ascii
  ac dec 101 1k 1G
  let psrr = -vdb(vout)
  meas ac psrr_vdd_db FIND psrr AT=1k
  write
  quit
.endc
.param x_dut_xm1_w=27.241
.param x_dut_xm1_l=0.246
.param x_dut_xm1c_w=48.148
.param x_dut_xm1c_l=5.274
.param x_dut_xm3_w=99.145
.param x_dut_xm3_l=1.391
.param x_dut_xm3c_w=78.432
.param x_dut_xm3c_l=4.589
.param x_dut_xm5_w=170.082
.param x_dut_xm5_l=0.505
.param x_dut_xm5_ng=2
.param x_dut_xm6_w=118.161
.param x_dut_xm6_l=9.666
.param x_dut_v_bias_1=0.509
.param x_dut_v_bias_2=1.032
.param x_dut_xm1_m=1
.param x_dut_xm2_m=1
.param x_dut_xm1c_m=1
.param x_dut_xm2c_m=1
.param x_dut_xm3_m=1
.param x_dut_xm4_m=1
.param x_dut_xm3c_m=1
.param x_dut_xm4c_m=1
.param x_dut_xm5_m=1
.param x_dut_xm6_m=1
* ---- GENERATED parameter ties (abstract/params.yaml groups/ratios) ----
* Each tied symbol is defined exactly once, by its line below; rewrite that
* .param to untie just that symbol (untying = shadowing, plan D-3).
.param x_dut_xm2_w = {x_dut_xm1_w}
.param x_dut_xm2_l = {x_dut_xm1_l}
.param x_dut_xm2c_w = {x_dut_xm1c_w}
.param x_dut_xm2c_l = {x_dut_xm1c_l}
.param x_dut_xm4_w = {x_dut_xm3_w}
.param x_dut_xm4_l = {x_dut_xm3_l}
.param x_dut_xm4c_w = {x_dut_xm3c_w}
.param x_dut_xm4c_l = {x_dut_xm3c_l}
.subckt amp_018_telescopic_cascode vdd vout vinp vinn ibias vss
V1 vdd gate_pc x_dut_v_bias_2
V2 casc_n tail x_dut_v_bias_1
XM1 d1 vinp tail vss sky130_fd_pr__nfet_01v8 l=x_dut_xm1_l m=x_dut_xm1_m w=x_dut_xm1_w
XM1C gate_p casc_n d1 vss sky130_fd_pr__nfet_01v8 l=x_dut_xm1c_l m=x_dut_xm1c_m w=x_dut_xm1c_w
XM2 d2 vinn tail vss sky130_fd_pr__nfet_01v8 l=x_dut_xm2_l m=x_dut_xm2_m w=x_dut_xm2_w
XM2C vout casc_n d2 vss sky130_fd_pr__nfet_01v8 l=x_dut_xm2c_l m=x_dut_xm2c_m w=x_dut_xm2c_w
XM3 s3 gate_p vdd vdd sky130_fd_pr__pfet_01v8 l=x_dut_xm3_l m=x_dut_xm3_m w=x_dut_xm3_w
XM3C gate_p gate_pc s3 vdd sky130_fd_pr__pfet_01v8 l=x_dut_xm3c_l m=x_dut_xm3c_m w=x_dut_xm3c_w
XM4 s4 gate_p vdd vdd sky130_fd_pr__pfet_01v8 l=x_dut_xm4_l m=x_dut_xm4_m w=x_dut_xm4_w
XM4C vout gate_pc s4 vdd sky130_fd_pr__pfet_01v8 l=x_dut_xm4c_l m=x_dut_xm4c_m w=x_dut_xm4c_w
XM5 tail ibias vss vss sky130_fd_pr__nfet_01v8 l=x_dut_xm5_l m=x_dut_xm5_m nf=x_dut_xm5_ng w=x_dut_xm5_w
XM6 ibias ibias vss vss sky130_fd_pr__nfet_01v8 l=x_dut_xm6_l m=x_dut_xm6_m w=x_dut_xm6_w
.ends
.end
