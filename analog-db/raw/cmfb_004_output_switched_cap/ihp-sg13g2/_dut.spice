** GENERATED by `analog-db export-raw` — DO NOT EDIT.
** Standalone lowered DUT subckt for cmfb_004_output_switched_cap on ihp-sg13g2 (sizing .param defaults + .subckt).
** Not a runnable deck on its own — include it under your own testbench:
**   .include _dut.spice
**   XDUT vinp vinn vcmfb vcm vbias clk_phi clk_phi_not vdd vss cmfb_004_output_switched_cap
** Source: pdk/ihp-sg13g2/netlist.spice (run `analog-db generate` to refresh).
*----------------------------------------------------------*
** params: 6 free + 2 frozen knobs (sizing.yaml) · 44 tied · 0 ratio-derived (abstract/params.yaml)
.param x_dut_xm1_w=0.15u
.param x_dut_xm1_l=0.13u
.param x_dut_xm2_w=0.15u
.param x_dut_xm2_l=0.13u
.param x_dut_c1_value=1p
.param x_dut_c2_value=1p
.param x_dut_xm1_m=1
.param x_dut_xm2_m=1
* ---- GENERATED parameter ties (abstract/params.yaml groups/ratios) ----
* Each tied symbol is defined exactly once, by its line below; rewrite that
* .param to untie just that symbol (untying = shadowing, plan D-3).
.param x_dut_xm3_w = {x_dut_xm1_w}
.param x_dut_xm5_w = {x_dut_xm1_w}
.param x_dut_xm7_w = {x_dut_xm1_w}
.param x_dut_xm9_w = {x_dut_xm1_w}
.param x_dut_xm11_w = {x_dut_xm1_w}
.param x_dut_xm13_w = {x_dut_xm1_w}
.param x_dut_xm15_w = {x_dut_xm1_w}
.param x_dut_xm3_l = {x_dut_xm1_l}
.param x_dut_xm5_l = {x_dut_xm1_l}
.param x_dut_xm7_l = {x_dut_xm1_l}
.param x_dut_xm9_l = {x_dut_xm1_l}
.param x_dut_xm11_l = {x_dut_xm1_l}
.param x_dut_xm13_l = {x_dut_xm1_l}
.param x_dut_xm15_l = {x_dut_xm1_l}
.param x_dut_xm3_m = {x_dut_xm1_m}
.param x_dut_xm5_m = {x_dut_xm1_m}
.param x_dut_xm7_m = {x_dut_xm1_m}
.param x_dut_xm9_m = {x_dut_xm1_m}
.param x_dut_xm11_m = {x_dut_xm1_m}
.param x_dut_xm13_m = {x_dut_xm1_m}
.param x_dut_xm15_m = {x_dut_xm1_m}
.param x_dut_xm4_w = {x_dut_xm2_w}
.param x_dut_xm6_w = {x_dut_xm2_w}
.param x_dut_xm8_w = {x_dut_xm2_w}
.param x_dut_xm10_w = {x_dut_xm2_w}
.param x_dut_xm12_w = {x_dut_xm2_w}
.param x_dut_xm14_w = {x_dut_xm2_w}
.param x_dut_xm16_w = {x_dut_xm2_w}
.param x_dut_xm4_l = {x_dut_xm2_l}
.param x_dut_xm6_l = {x_dut_xm2_l}
.param x_dut_xm8_l = {x_dut_xm2_l}
.param x_dut_xm10_l = {x_dut_xm2_l}
.param x_dut_xm12_l = {x_dut_xm2_l}
.param x_dut_xm14_l = {x_dut_xm2_l}
.param x_dut_xm16_l = {x_dut_xm2_l}
.param x_dut_xm4_m = {x_dut_xm2_m}
.param x_dut_xm6_m = {x_dut_xm2_m}
.param x_dut_xm8_m = {x_dut_xm2_m}
.param x_dut_xm10_m = {x_dut_xm2_m}
.param x_dut_xm12_m = {x_dut_xm2_m}
.param x_dut_xm14_m = {x_dut_xm2_m}
.param x_dut_xm16_m = {x_dut_xm2_m}
.param x_dut_c4_value = {x_dut_c2_value}
.param x_dut_c3_value = {x_dut_c1_value}
.subckt cmfb_004_output_switched_cap vinp vinn vcmfb vcm vbias clk_phi clk_phi_not vdd vss
C1 vbias vcm 'x_dut_c1_value'
C2 ctl_p sense_p 'x_dut_c2_value'
C3 vbias vcm 'x_dut_c3_value'
C4 ctl_n sense_n 'x_dut_c4_value'
XM1 vcm clk_phi sense_p vss sg13_lv_nmos l=x_dut_xm1_l m=x_dut_xm1_m w=x_dut_xm1_w
XM10 sense_n clk_phi_not vcm vdd sg13_lv_pmos l=x_dut_xm10_l m=x_dut_xm10_m w=x_dut_xm10_w
XM11 vbias clk_phi ctl_n vss sg13_lv_nmos l=x_dut_xm11_l m=x_dut_xm11_m w=x_dut_xm11_w
XM12 ctl_n clk_phi_not vbias vdd sg13_lv_pmos l=x_dut_xm12_l m=x_dut_xm12_m w=x_dut_xm12_w
XM13 sense_n clk_phi_not vinn vss sg13_lv_nmos l=x_dut_xm13_l m=x_dut_xm13_m w=x_dut_xm13_w
XM14 vinn clk_phi sense_n vdd sg13_lv_pmos l=x_dut_xm14_l m=x_dut_xm14_m w=x_dut_xm14_w
XM15 ctl_n clk_phi_not vcmfb vss sg13_lv_nmos l=x_dut_xm15_l m=x_dut_xm15_m w=x_dut_xm15_w
XM16 vcmfb clk_phi ctl_n vdd sg13_lv_pmos l=x_dut_xm16_l m=x_dut_xm16_m w=x_dut_xm16_w
XM2 sense_p clk_phi_not vcm vdd sg13_lv_pmos l=x_dut_xm2_l m=x_dut_xm2_m w=x_dut_xm2_w
XM3 vbias clk_phi ctl_p vss sg13_lv_nmos l=x_dut_xm3_l m=x_dut_xm3_m w=x_dut_xm3_w
XM4 ctl_p clk_phi_not vbias vdd sg13_lv_pmos l=x_dut_xm4_l m=x_dut_xm4_m w=x_dut_xm4_w
XM5 sense_p clk_phi_not vinp vss sg13_lv_nmos l=x_dut_xm5_l m=x_dut_xm5_m w=x_dut_xm5_w
XM6 vinp clk_phi sense_p vdd sg13_lv_pmos l=x_dut_xm6_l m=x_dut_xm6_m w=x_dut_xm6_w
XM7 ctl_p clk_phi_not vcmfb vss sg13_lv_nmos l=x_dut_xm7_l m=x_dut_xm7_m w=x_dut_xm7_w
XM8 vcmfb clk_phi ctl_p vdd sg13_lv_pmos l=x_dut_xm8_l m=x_dut_xm8_m w=x_dut_xm8_w
XM9 vcm clk_phi sense_n vss sg13_lv_nmos l=x_dut_xm9_l m=x_dut_xm9_m w=x_dut_xm9_w
.ends
