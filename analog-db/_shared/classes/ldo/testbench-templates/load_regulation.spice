** AUTHORED TEMPLATE — ldo/load_regulation (plan D-10 STUB).
** Placeholder: DC load sweep measuring delta-vout per delta-iload. Completed when the
** first real LDO circuit lands; the stub exists so the class abstraction is exercised
** (template resolution + Tier 2 assembly) by a non-amplifier class.
** Bindings: DUT PORT_LINE VDD ILOAD_START ILOAD_STOP ILOAD_STEP PDK_INCLUDE.
${PDK_INCLUDE}

.param VDD=${VDD}

Vdd  vdd 0 dc {VDD}
Vss  vss 0 dc 0
Iload vout 0 dc ${ILOAD_START}

${PORT_LINE} ${DUT}

.control
  set filetype=ascii
  dc Iload ${ILOAD_START} ${ILOAD_STOP} ${ILOAD_STEP}
  meas dc vout_max MAX v(vout)
  meas dc vout_min MIN v(vout)
  let load_reg = vout_max - vout_min
  print load_reg
  write
  quit
.endc
.end
