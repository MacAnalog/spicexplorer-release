** GENERATED by `analog-db export-raw` — DO NOT EDIT.
** circuit=amp_027_fan_rrl_ota  class=amplifier  pdk=tsmc-n65  testbench=tran_step  corner=tt
** Self-contained deck: testbench + bound params + lowered DUT (.subckt amp_027_fan_rrl_ota).
** PDK corner libs resolve by BARE NAME on the image's ngspice sourcepath — run in a
** PDK-enabled env (the base image / api container), NOT a bare host:
**   docker run --rm -i spicexplorer-spice-base:local \
**     bash -lc 'd=$(mktemp -d) && cat > $d/c.spice && cd $d && ngspice -b c.spice' < raw/amp_027_fan_rrl_ota/tsmc-n65/tran_step.spice
*----------------------------------------------------------*
** params: 20 free + 9 frozen knobs (sizing.yaml) · 23 tied · 0 ratio-derived (abstract/params.yaml) · 4 testbench params
** AUTHORED TEMPLATE — amplifier/tran_step_diff (self-biased, differential-output step).
** Unity-gain step -> slew + settling for a DUT with no external ibias port and a true
** differential output. Closes ONE feedback path (vinn <- voutp) and steps vinp; by the
** differential pair's own symmetry (and, for a DUT like amp_020_two_stage_miller_cmfb, its
** internal common-mode servo) voutn tracks the complementary swing, so the DIFFERENTIAL
** output (voutp-voutn) is the correct unity-gain-follower signal to settle on.
**
** Assumes a self-biased, differential-output DUT port order:
**   .subckt <id> vinp vinn voutp voutn vdd vss
** Required bindings: DUT PORT_LINE VDD VCM CL VSTEP TSTART TSTEP TSTOP VTOL PDK_INCLUDE.
.lib tsmc_n65_models.scs tt
.temp 27

.param VDD=1.2
.param VCM=0.6
.param CL=50f
.param VSTEP=50m

Vdd  vdd 0 dc {VDD}
Vss  vss 0 dc 0
CLoadp voutp 0 {CL}
CLoadn voutn 0 {CL}

* unity-gain differential follower: vinn <- voutp (single feedback wire; 0 V source = ideal
* wire). vinp gets the step relative to the input common mode.
Vinp vinp 0 dc {VCM} pulse({VCM} {VCM+VSTEP} 1u 1n 1n 1 1)
Vfb  vinn voutp dc 0

XDUT vinp vinn voutp voutn vdd vss amp_027_fan_rrl_ota

.control
  set filetype=ascii
  tran 1n 20u
  let vodm = v(voutp) - v(voutn)
  * settle to the FINAL differential value, not the input step size — see tran_step.spice
  * (universal) for why: a systematic offset would otherwise keep the error band open forever.
  meas tran vfinal FIND vodm AT=20u
  let verr = abs(vodm - vfinal)
  meas tran tcross WHEN verr=5m FALL=LAST
  let t_settle = tcross - 1u
  print t_settle
  write
  quit
.endc
.param x_dut_xm1_w=20u
.param x_dut_xm1_l=1u
.param x_dut_xm2_w=20u
.param x_dut_xm2_l=0.5u
.param x_dut_xm4_w=10u
.param x_dut_xm5_w=4u
.param x_dut_xm5_l=0.5u
.param x_dut_xm6_w=4u
.param x_dut_xm6_l=0.5u
.param x_dut_xm9_w=10u
.param x_dut_xm9_l=0.3u
.param x_dut_xm11_w=5u
.param x_dut_xm11_l=0.3u
.param x_dut_xm13_w=6u
.param x_dut_xm15_w=2u
.param x_dut_xm15_l=1u
.param vb1=0.45
.param vb2=0.75
.param vb3=0.55
.param vb4=0.6
.param x_dut_xm1_m=1
.param x_dut_xm2_m=1
.param x_dut_xm4_m=1
.param x_dut_xm5_m=1
.param x_dut_xm6_m=1
.param x_dut_xm9_m=1
.param x_dut_xm11_m=1
.param x_dut_xm13_m=1
.param x_dut_xm15_m=1
* ---- GENERATED parameter ties (abstract/params.yaml groups/ratios) ----
* Each tied symbol is defined exactly once, by its line below; rewrite that
* .param to untie just that symbol (untying = shadowing, plan D-3).
.param x_dut_xm13_l = {x_dut_xm15_l}
.param x_dut_xm14_l = {x_dut_xm15_l}
.param x_dut_xm3_w = {x_dut_xm2_w}
.param x_dut_xm3_l = {x_dut_xm2_l}
.param x_dut_xm3_m = {x_dut_xm2_m}
.param x_dut_xm10_w = {x_dut_xm9_w}
.param x_dut_xm10_l = {x_dut_xm9_l}
.param x_dut_xm10_m = {x_dut_xm9_m}
.param x_dut_xm12_w = {x_dut_xm11_w}
.param x_dut_xm12_l = {x_dut_xm11_l}
.param x_dut_xm12_m = {x_dut_xm11_m}
.param x_dut_xm14_w = {x_dut_xm13_w}
.param x_dut_xm14_m = {x_dut_xm13_m}
.param x_dut_xm7_w = {x_dut_xm5_w}
.param x_dut_xm7_l = {x_dut_xm5_l}
.param x_dut_xm7_m = {x_dut_xm5_m}
.param x_dut_xm8_w = {x_dut_xm6_w}
.param x_dut_xm8_l = {x_dut_xm6_l}
.param x_dut_xm8_m = {x_dut_xm6_m}
.param x_dut_xm16_w = {x_dut_xm15_w}
.param x_dut_xm16_l = {x_dut_xm15_l}
.param x_dut_xm16_m = {x_dut_xm15_m}
.param x_dut_xm4_l = {x_dut_xm1_l}
.subckt amp_027_fan_rrl_ota vinp vinn voutp voutn vdd vss
VB1 vb1 vss dc {vb1}
VB2 vb2 vss dc {vb2}
VB3 vb3 vss dc {vb3}
VB4 vb4 vss dc {vb4}
XM1 tail vb3 vdd vdd pch_lvt l=x_dut_xm1_l m=x_dut_xm1_m w=x_dut_xm1_w
XM10 voutp vb1 d1p vdd pch_lvt l=x_dut_xm10_l m=x_dut_xm10_m w=x_dut_xm10_w
XM11 voutn vb2 csrc_n vss nch_lvt l=x_dut_xm11_l m=x_dut_xm11_m w=x_dut_xm11_w
XM12 voutp vb2 csrc_p vss nch_lvt l=x_dut_xm12_l m=x_dut_xm12_m w=x_dut_xm12_w
XM13 csrc_n cm_bias vss vss nch_lvt l=x_dut_xm13_l m=x_dut_xm13_m w=x_dut_xm13_w
XM14 csrc_p cm_bias vss vss nch_lvt l=x_dut_xm14_l m=x_dut_xm14_m w=x_dut_xm14_w
XM15 cm_bias cm_bias vss vss nch_lvt l=x_dut_xm15_l m=x_dut_xm15_m w=x_dut_xm15_w
XM16 cm_sense cm_sense vss vss nch_lvt l=x_dut_xm16_l m=x_dut_xm16_m w=x_dut_xm16_w
XM2 d1n vinp tail vdd pch_lvt l=x_dut_xm2_l m=x_dut_xm2_m w=x_dut_xm2_w
XM3 d1p vinn tail vdd pch_lvt l=x_dut_xm3_l m=x_dut_xm3_m w=x_dut_xm3_w
XM4 cm_tail vb3 vdd vdd pch_lvt l=x_dut_xm4_l m=x_dut_xm4_m w=x_dut_xm4_w
XM5 cm_sense voutn cm_tail vdd pch_lvt l=x_dut_xm5_l m=x_dut_xm5_m w=x_dut_xm5_w
XM6 cm_bias vb4 cm_tail vdd pch_lvt l=x_dut_xm6_l m=x_dut_xm6_m w=x_dut_xm6_w
XM7 cm_sense voutp cm_tail vdd pch_lvt l=x_dut_xm7_l m=x_dut_xm7_m w=x_dut_xm7_w
XM8 cm_bias vb4 cm_tail vdd pch_lvt l=x_dut_xm8_l m=x_dut_xm8_m w=x_dut_xm8_w
XM9 voutn vb1 d1n vdd pch_lvt l=x_dut_xm9_l m=x_dut_xm9_m w=x_dut_xm9_w
.ends
.end
