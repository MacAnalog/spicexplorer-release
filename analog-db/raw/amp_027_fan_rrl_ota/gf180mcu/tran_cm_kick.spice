** GENERATED by `analog-db export-raw` — DO NOT EDIT.
** circuit=amp_027_fan_rrl_ota  class=amplifier  pdk=gf180mcu  testbench=tran_cm_kick  corner=tt
** Self-contained deck: testbench + bound params + lowered DUT (.subckt amp_027_fan_rrl_ota).
** PDK corner libs resolve by BARE NAME on the image's ngspice sourcepath — run in a
** PDK-enabled env (the base image / api container), NOT a bare host:
**   docker run --rm -i spicexplorer-spice-base:local \
**     bash -lc 'd=$(mktemp -d) && cat > $d/c.spice && cd $d && ngspice -b c.spice' < raw/amp_027_fan_rrl_ota/gf180mcu/tran_cm_kick.spice
*----------------------------------------------------------*
** params: 20 free + 9 frozen knobs (sizing.yaml) · 23 tied · 0 ratio-derived (abstract/params.yaml) · 4 testbench params
** AUTHORED TEMPLATE — amplifier/tran_cm_kick (CM-loop health, time domain).
** Common-mode disturbance recovery: a CM current step ICM (0.5*ICM per side) kicks both
** outputs from TKICK to TREL; the CM feedback loop must absorb it and re-settle vocm.
**   cm_kick_v    settled vocm displacement while the kick is applied (at TMID) —
**                = ICM * Zcm(0); small = stiff servo
**   cm_resid_v   vocm at TEND minus the pre-kick level — residual after release (~0
**                for a healthy loop; nonzero flags CM bistability/latch-up: the kick
**                pushed the amp to another operating point)
**   t_cm_settle  recovery time from the release edge to |vocm - vocm(TEND)| < VTOL
** Ringing shows up as a long t_cm_settle relative to the loop bandwidth. See
** ac_cm_reg.spice's honesty note: internal T_cm/PM_cm need a composed loop probe.
**
** Assumes a self-biased, differential-output DUT with a CM control loop:
**   .subckt <id> vinp vinn voutp voutn vdd vss
** Required bindings: DUT PORT_LINE VDD VCM CL ICM TKICK TMID TREL TEND VTOL TSTEP
**                    TSTOP PDK_INCLUDE.  (TB0 sample of the pre-kick level is taken at
**                    TKICK/2; choose TKICK late enough for startup to settle.)
.include design.ngspice
.lib sm141064.ngspice noise_corner
.lib sm141064.ngspice nfet_03v3_t
.lib sm141064.ngspice pfet_03v3_t
.lib sm141064.ngspice fets_mm
.lib sm141064.ngspice res_typical
.lib sm141064.ngspice mimcap_typical
.lib sm141064.ngspice cap_mim
.temp 27

.param VDD=3.3
.param VCM=1.2
.param CL=10p
.param ICM=5u

Vdd  vdd 0 dc {VDD}
Vss  vss 0 dc 0
CLoadp voutp 0 {CL}
CLoadn voutn 0 {CL}
Vcm  vcm 0 dc {VCM}
Vinp vinp vcm dc 0
Vinn vinn vcm dc 0
* common-mode current kick, applied TKICK..TREL (one-shot: width TREL-TKICK, per >> pw)
Icmp 0 voutp pulse(0 {ICM/2} 2u 10n 10n {6u-2u} 1)
Icmn 0 voutn pulse(0 {ICM/2} 2u 10n 10n {6u-2u} 1)

XDUT vinp vinn voutp voutn vdd vss amp_027_fan_rrl_ota

.control
  set filetype=ascii
  tran 2n 20u
  let vocm = (v(voutp)+v(voutn))/2
  meas tran vocm0 FIND vocm AT={2u/2}
  meas tran vocm_mid FIND vocm AT=5u
  meas tran vocm_end FIND vocm AT=19u
  let cm_kick_v = vocm_mid - vocm0
  let cm_resid_v = vocm_end - vocm0
  let verr = abs(vocm - vocm_end)
  meas tran tcross WHEN verr=2m FALL=LAST
  let t_cm_settle = tcross - 6u
  print cm_kick_v cm_resid_v t_cm_settle
  write
  quit
.endc
.param x_dut_xm1_w=1.7623089602048373e-05
.param x_dut_xm1_l=1.369127501694859e-06
.param x_dut_xm2_w=5.889049437027081e-05
.param x_dut_xm2_l=1.6033732040870076e-06
.param x_dut_xm4_w=9.94615820750218e-05
.param x_dut_xm5_w=1.0451333631298199e-05
.param x_dut_xm5_l=1.3544484994578545e-06
.param x_dut_xm6_w=1.5274424179235197e-05
.param x_dut_xm6_l=1.6098583754463795e-06
.param x_dut_xm9_w=9.187857450587903e-05
.param x_dut_xm9_l=1.6789147317226054e-06
.param x_dut_xm11_w=9.296521288010723e-05
.param x_dut_xm11_l=2.3257966982671126e-06
.param x_dut_xm13_w=5.8433283014360016e-05
.param x_dut_xm15_w=2.016318826733622e-05
.param x_dut_xm15_l=9.487648744819404e-07
.param vb1=1.1
.param vb2=1.2
.param vb3=2.2
.param vb4=1.65
.param x_dut_xm1_m=1
.param x_dut_xm2_m=1
.param x_dut_xm4_m=1
.param x_dut_xm5_m=1
.param x_dut_xm6_m=1
.param x_dut_xm9_m=1
.param x_dut_xm11_m=1
.param x_dut_xm13_m=1
.param x_dut_xm15_m=1
* ---- GENERATED parameter ties (abstract/params.yaml groups/ratios) ----
* Each tied symbol is defined exactly once, by its line below; rewrite that
* .param to untie just that symbol (untying = shadowing, plan D-3).
.param x_dut_xm13_l = {x_dut_xm15_l}
.param x_dut_xm14_l = {x_dut_xm15_l}
.param x_dut_xm3_w = {x_dut_xm2_w}
.param x_dut_xm3_l = {x_dut_xm2_l}
.param x_dut_xm3_m = {x_dut_xm2_m}
.param x_dut_xm10_w = {x_dut_xm9_w}
.param x_dut_xm10_l = {x_dut_xm9_l}
.param x_dut_xm10_m = {x_dut_xm9_m}
.param x_dut_xm12_w = {x_dut_xm11_w}
.param x_dut_xm12_l = {x_dut_xm11_l}
.param x_dut_xm12_m = {x_dut_xm11_m}
.param x_dut_xm14_w = {x_dut_xm13_w}
.param x_dut_xm14_m = {x_dut_xm13_m}
.param x_dut_xm7_w = {x_dut_xm5_w}
.param x_dut_xm7_l = {x_dut_xm5_l}
.param x_dut_xm7_m = {x_dut_xm5_m}
.param x_dut_xm8_w = {x_dut_xm6_w}
.param x_dut_xm8_l = {x_dut_xm6_l}
.param x_dut_xm8_m = {x_dut_xm6_m}
.param x_dut_xm16_w = {x_dut_xm15_w}
.param x_dut_xm16_l = {x_dut_xm15_l}
.param x_dut_xm16_m = {x_dut_xm15_m}
.param x_dut_xm4_l = {x_dut_xm1_l}
.subckt amp_027_fan_rrl_ota vinp vinn voutp voutn vdd vss
VB1 vb1 vss dc {vb1}
VB2 vb2 vss dc {vb2}
VB3 vb3 vss dc {vb3}
VB4 vb4 vss dc {vb4}
XM1 tail vb3 vdd vdd pfet_03v3 l=x_dut_xm1_l m=x_dut_xm1_m w=x_dut_xm1_w
XM10 voutp vb1 d1p vdd pfet_03v3 l=x_dut_xm10_l m=x_dut_xm10_m w=x_dut_xm10_w
XM11 voutn vb2 csrc_n vss nfet_03v3 l=x_dut_xm11_l m=x_dut_xm11_m w=x_dut_xm11_w
XM12 voutp vb2 csrc_p vss nfet_03v3 l=x_dut_xm12_l m=x_dut_xm12_m w=x_dut_xm12_w
XM13 csrc_n cm_bias vss vss nfet_03v3 l=x_dut_xm13_l m=x_dut_xm13_m w=x_dut_xm13_w
XM14 csrc_p cm_bias vss vss nfet_03v3 l=x_dut_xm14_l m=x_dut_xm14_m w=x_dut_xm14_w
XM15 cm_bias cm_bias vss vss nfet_03v3 l=x_dut_xm15_l m=x_dut_xm15_m w=x_dut_xm15_w
XM16 cm_sense cm_sense vss vss nfet_03v3 l=x_dut_xm16_l m=x_dut_xm16_m w=x_dut_xm16_w
XM2 d1n vinp tail vdd pfet_03v3 l=x_dut_xm2_l m=x_dut_xm2_m w=x_dut_xm2_w
XM3 d1p vinn tail vdd pfet_03v3 l=x_dut_xm3_l m=x_dut_xm3_m w=x_dut_xm3_w
XM4 cm_tail vb3 vdd vdd pfet_03v3 l=x_dut_xm4_l m=x_dut_xm4_m w=x_dut_xm4_w
XM5 cm_sense voutn cm_tail vdd pfet_03v3 l=x_dut_xm5_l m=x_dut_xm5_m w=x_dut_xm5_w
XM6 cm_bias vb4 cm_tail vdd pfet_03v3 l=x_dut_xm6_l m=x_dut_xm6_m w=x_dut_xm6_w
XM7 cm_sense voutp cm_tail vdd pfet_03v3 l=x_dut_xm7_l m=x_dut_xm7_m w=x_dut_xm7_w
XM8 cm_bias vb4 cm_tail vdd pfet_03v3 l=x_dut_xm8_l m=x_dut_xm8_m w=x_dut_xm8_w
XM9 voutn vb1 d1n vdd pfet_03v3 l=x_dut_xm9_l m=x_dut_xm9_m w=x_dut_xm9_w
.ends
.end
